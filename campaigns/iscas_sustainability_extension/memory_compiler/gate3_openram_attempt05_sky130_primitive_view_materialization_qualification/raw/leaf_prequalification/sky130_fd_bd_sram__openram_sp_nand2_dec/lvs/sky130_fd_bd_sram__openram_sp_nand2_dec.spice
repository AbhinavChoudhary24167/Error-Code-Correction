* NGSPICE file created from sky130_fd_bd_sram__openram_sp_nand2_dec.ext - technology: sky130A

.subckt sky130_fd_bd_sram__openram_sp_nand2_dec A B GND VDD Z
.ends
