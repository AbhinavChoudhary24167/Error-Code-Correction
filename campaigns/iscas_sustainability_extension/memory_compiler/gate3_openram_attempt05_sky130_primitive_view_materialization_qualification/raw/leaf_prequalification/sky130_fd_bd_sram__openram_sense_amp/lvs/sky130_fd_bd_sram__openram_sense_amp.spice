* NGSPICE file created from sky130_fd_bd_sram__openram_sense_amp.ext - technology: sky130A

.subckt sky130_fd_bd_sram__openram_sense_amp BL BR DOUT EN GND VDD
.ends
