* NGSPICE file created from sky130_fd_bd_sram__openram_dff.ext - technology: sky130A

.subckt sky130_fd_bd_sram__openram_dff CLK D Q Q_N
.ends
