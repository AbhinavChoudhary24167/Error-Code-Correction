* NGSPICE file created from sky130_fd_bd_sram__openram_write_driver.ext - technology: sky130A

.subckt sky130_fd_bd_sram__openram_write_driver BL BR DIN EN GND VDD
.ends
