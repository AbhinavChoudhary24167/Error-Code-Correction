* NGSPICE file created from sky130_fd_bd_sram__sram_sp_colenda.ext - technology: sky130A

.subckt sky130_fd_bd_sram__sram_sp_colenda
X0 BL1 a_0_24# BL1 w_96_0# sky130_fd_pr__nfet_01v8 ad=0.0168p pd=0.52u as=0p ps=0u w=0.07u l=0.21u
.ends
