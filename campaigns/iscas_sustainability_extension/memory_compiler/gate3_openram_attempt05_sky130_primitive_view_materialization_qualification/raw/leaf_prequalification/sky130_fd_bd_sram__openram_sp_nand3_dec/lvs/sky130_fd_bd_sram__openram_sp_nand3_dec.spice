* NGSPICE file created from sky130_fd_bd_sram__openram_sp_nand3_dec.ext - technology: sky130A

.subckt sky130_fd_bd_sram__openram_sp_nand3_dec A B C GND VDD Z
.ends
