* cell sram22_256x8m8w1
* pin addr[7]
* pin addr[6]
* pin addr[5]
* pin addr[4]
* pin addr[3]
* pin addr[2]
* pin addr[1]
* pin addr[0]
* pin ce
* pin we
* pin clk
* pin rstb
* pin wmask[0]
* pin din[0]
* pin dout[0]
* pin wmask[1]
* pin din[1]
* pin dout[1]
* pin wmask[2]
* pin din[2]
* pin dout[2]
* pin wmask[3]
* pin din[3]
* pin dout[3]
* pin wmask[4]
* pin din[4]
* pin dout[4]
* pin wmask[5]
* pin din[5]
* pin dout[5]
* pin wmask[6]
* pin din[6]
* pin dout[6]
* pin wmask[7]
* pin din[7]
* pin dout[7]
* pin vdd
* pin vss
.SUBCKT sram22_256x8m8w1 1 2 3 4 5 6 7 8 9 10 11 12 13 14 15 16 17 18 19 20 21
+ 22 23 24 25 26 27 28 29 30 31 32 33 34 35 36 37 38
* net 1 addr[7]
* net 2 addr[6]
* net 3 addr[5]
* net 4 addr[4]
* net 5 addr[3]
* net 6 addr[2]
* net 7 addr[1]
* net 8 addr[0]
* net 9 ce
* net 10 we
* net 11 clk
* net 12 rstb
* net 13 wmask[0]
* net 14 din[0]
* net 15 dout[0]
* net 16 wmask[1]
* net 17 din[1]
* net 18 dout[1]
* net 19 wmask[2]
* net 20 din[2]
* net 21 dout[2]
* net 22 wmask[3]
* net 23 din[3]
* net 24 dout[3]
* net 25 wmask[4]
* net 26 din[4]
* net 27 dout[4]
* net 28 wmask[5]
* net 29 din[5]
* net 30 dout[5]
* net 31 wmask[6]
* net 32 din[6]
* net 33 dout[6]
* net 34 wmask[7]
* net 35 din[7]
* net 36 dout[7]
* net 37 vdd
* net 38 vss
* cell instance $1 r0 *1 154.32,142.08
X$1 1 2 3 4 5 6 7 8 9 10 11 12 37 13 14 15 16 17 18 19 20 21 22 23 24 25 26 27
+ 28 29 30 31 32 33 34 35 36 38 sram22_inner
.ENDS sram22_256x8m8w1

* cell sram22_inner
* pin addr[7]
* pin addr[6]
* pin addr[5]
* pin addr[4]
* pin addr[3]
* pin addr[2]
* pin addr[1]
* pin addr[0]
* pin ce
* pin we
* pin clk
* pin rstb
* pin vdd
* pin wmask[0]
* pin din[0]
* pin dout[0]
* pin wmask[1]
* pin din[1]
* pin dout[1]
* pin wmask[2]
* pin din[2]
* pin dout[2]
* pin wmask[3]
* pin din[3]
* pin dout[3]
* pin wmask[4]
* pin din[4]
* pin dout[4]
* pin wmask[5]
* pin din[5]
* pin dout[5]
* pin wmask[6]
* pin din[6]
* pin dout[6]
* pin wmask[7]
* pin din[7]
* pin dout[7]
* pin vss
.SUBCKT sram22_inner 3 5 9 11 14 17 20 23 25 27 29 30 31 32 33 34 35 36 37 38
+ 39 40 41 42 43 44 45 46 47 48 49 50 51 52 53 54 55 253
* net 3 addr[7]
* net 5 addr[6]
* net 9 addr[5]
* net 11 addr[4]
* net 14 addr[3]
* net 17 addr[2]
* net 20 addr[1]
* net 23 addr[0]
* net 25 ce
* net 27 we
* net 29 clk
* net 30 rstb
* net 31 vdd
* net 32 wmask[0]
* net 33 din[0]
* net 34 dout[0]
* net 35 wmask[1]
* net 36 din[1]
* net 37 dout[1]
* net 38 wmask[2]
* net 39 din[2]
* net 40 dout[2]
* net 41 wmask[3]
* net 42 din[3]
* net 43 dout[3]
* net 44 wmask[4]
* net 45 din[4]
* net 46 dout[4]
* net 47 wmask[5]
* net 48 din[5]
* net 49 dout[5]
* net 50 wmask[6]
* net 51 din[6]
* net 52 dout[6]
* net 53 wmask[7]
* net 54 din[7]
* net 55 dout[7]
* net 253 vss
* net 254 $144.y_b
* net 289 $302.y_b
* net 290 $414.y_b
* net 291 $246.y_b
* cell instance $2 m45 *1 -104.53,25.765
X$2 82 15 13 12 10 8 7 6 4 2 1 31 31 99 100 96 98 97 95 101 234 235 236 253
+ decoder_stage_1
* cell instance $6 r0 *1 -92.2,-131.015
X$6 3 5 9 11 14 17 20 23 25 27 31 1 253 31 4 253 31 7 253 31 10 253 31 13 253
+ 30 29 31 16 253 31 19 253 31 22 253 31 253 31 253 2 6 8 12 15 18 21 24 26 28
+ 253 dff_array_10
* cell instance $83 r90 *1 -91.935,-96.255
X$83 57 63 31 80 28 81 31 67 30 26 78 29 31 253 control_logic_replica_v2
* cell instance $177 r0 *1 -108.44,-40.495
X$177 31 79 78 78 79 253 253 253 253 67 253 253 253 253 253 253
+ replica_cell_array
* cell instance $305 r0 *1 -125.24,-7.605
X$305 78 31 253 replica_column_mos
* cell instance $323 r0 *1 0,0
X$323 31 31 102 103 104 105 106 107 108 109 110 111 112 113 114 115 116 117 118
+ 119 120 121 122 123 124 125 126 127 128 129 130 131 132 133 134 135 136 137
+ 138 139 140 141 142 143 144 145 146 147 148 149 150 151 152 153 154 155 156
+ 157 158 159 160 161 162 163 164 165 166 167 168 169 170 171 172 173 174 175
+ 176 177 178 179 180 181 182 183 184 185 186 187 188 189 190 191 192 193 194
+ 195 196 197 198 199 200 201 202 203 204 205 206 207 208 209 210 211 212 213
+ 214 215 216 217 218 219 220 221 222 223 224 225 226 227 228 229 31 31 253 87
+ 85 93 91 92 89 94 90 88 83 86 84 231 232 233 230 239 238 237 240 241 242 248
+ 249 244 243 245 246 247 252 250 251 253 253 sp_cell_array
* cell instance $533 r270 *1 -66.22,3.635
X$533 95 236 97 234 235 98 96 101 100 99 31 31 31 31 31 31 31 251 250 252 247
+ 246 245 243 244 249 248 242 241 240 237 238 239 230 233 232 231 84 86 83 88
+ 90 94 89 92 91 93 85 87 31 253 decoder_1
* cell instance $22286 m0 *1 -107.14,-3.365
X$22286 79 80 31 78 31 precharge_1
* cell instance $22287 r180 *1 -104.74,-3.365
X$22287 79 80 31 78 31 precharge_1
* cell instance $22817 r0 *1 4.94,-108.03
X$22817 293 300 31 31 31 31 56 324 253 decoder_stage
* cell instance $22819 r0 *1 15.84,-108.03
X$22819 295 301 31 31 31 31 56 325 253 decoder_stage
* cell instance $22821 r0 *1 26.74,-108.03
X$22821 294 302 31 31 31 31 56 326 253 decoder_stage
* cell instance $22823 r0 *1 37.64,-108.03
X$22823 297 303 31 31 31 31 56 327 253 decoder_stage
* cell instance $22825 r0 *1 48.54,-108.03
X$22825 296 304 31 31 31 31 56 328 253 decoder_stage
* cell instance $22827 r0 *1 59.44,-108.03
X$22827 298 305 31 31 31 31 56 329 253 decoder_stage
* cell instance $22829 r0 *1 70.34,-108.03
X$22829 299 306 31 31 31 31 56 330 253 decoder_stage
* cell instance $22831 r0 *1 81.24,-108.03
X$22831 292 307 31 31 31 31 56 331 253 decoder_stage
* cell instance $22876 r0 *1 8.335,-62.015
X$22876 340 341 322 320 300 31 253 293 31 253 write_driver
* cell instance $22880 r0 *1 7.01,-64.3
X$22880 34 343 342 31 31 31 253 253 253 253 31 31 31 253 diff_latch
* cell instance $22886 m0 *1 6.2,-33.025
X$22886 76 253 322 320 343 342 31 31 253 sramgen_sp_sense_amp
* cell instance $22899 r0 *1 19.235,-62.015
X$22899 344 345 323 321 301 31 253 295 31 253 write_driver
* cell instance $22903 r0 *1 17.91,-64.3
X$22903 37 347 346 31 31 31 253 253 253 253 31 31 31 253 diff_latch
* cell instance $22909 m0 *1 17.1,-33.025
X$22909 76 253 323 321 347 346 31 31 253 sramgen_sp_sense_amp
* cell instance $22922 r0 *1 30.135,-62.015
X$22922 348 349 317 311 302 31 253 294 31 253 write_driver
* cell instance $22926 r0 *1 28.81,-64.3
X$22926 40 351 350 31 31 31 253 253 253 253 31 31 31 253 diff_latch
* cell instance $22932 m0 *1 28,-33.025
X$22932 76 253 317 311 351 350 31 31 253 sramgen_sp_sense_amp
* cell instance $22945 r0 *1 41.035,-62.015
X$22945 352 353 314 308 303 31 253 297 31 253 write_driver
* cell instance $22949 r0 *1 39.71,-64.3
X$22949 43 355 354 31 31 31 253 253 253 253 31 31 31 253 diff_latch
* cell instance $22955 m0 *1 38.9,-33.025
X$22955 76 253 314 308 355 354 31 31 253 sramgen_sp_sense_amp
* cell instance $22968 r0 *1 51.935,-62.015
X$22968 356 357 319 313 304 31 253 296 31 253 write_driver
* cell instance $22972 r0 *1 50.61,-64.3
X$22972 46 359 358 31 31 31 253 253 253 253 31 31 31 253 diff_latch
* cell instance $22978 m0 *1 49.8,-33.025
X$22978 76 253 319 313 359 358 31 31 253 sramgen_sp_sense_amp
* cell instance $22991 r0 *1 62.835,-62.015
X$22991 360 361 315 309 305 31 253 298 31 253 write_driver
* cell instance $22995 r0 *1 61.51,-64.3
X$22995 49 363 362 31 31 31 253 253 253 253 31 31 31 253 diff_latch
* cell instance $23001 m0 *1 60.7,-33.025
X$23001 76 253 315 309 363 362 31 31 253 sramgen_sp_sense_amp
* cell instance $23014 r0 *1 73.735,-62.015
X$23014 364 365 316 310 306 31 253 299 31 253 write_driver
* cell instance $23018 r0 *1 72.41,-64.3
X$23018 52 367 366 31 31 31 253 253 253 253 31 31 31 253 diff_latch
* cell instance $23024 m0 *1 71.6,-33.025
X$23024 76 253 316 310 367 366 31 31 253 sramgen_sp_sense_amp
* cell instance $23037 r0 *1 84.635,-62.015
X$23037 368 369 318 312 307 31 253 292 31 253 write_driver
* cell instance $23041 r0 *1 83.31,-64.3
X$23041 55 371 370 31 31 31 253 253 253 253 31 31 31 253 diff_latch
* cell instance $23047 m0 *1 82.5,-33.025
X$23047 76 253 318 312 371 370 31 31 253 sramgen_sp_sense_amp
* cell instance $23700 r90 *1 10.265,-124.05
X$23700 253 324 32 332 30 29 31 31 253 sky130_fd_sc_hs__dfrbp_2
* cell instance $23706 r90 *1 21.165,-124.05
X$23706 253 325 35 333 30 29 31 31 253 sky130_fd_sc_hs__dfrbp_2
* cell instance $23712 r90 *1 32.065,-124.05
X$23712 253 326 38 334 30 29 31 31 253 sky130_fd_sc_hs__dfrbp_2
* cell instance $23718 r90 *1 42.965,-124.05
X$23718 253 327 41 335 30 29 31 31 253 sky130_fd_sc_hs__dfrbp_2
* cell instance $23724 r90 *1 53.865,-124.05
X$23724 253 328 44 336 30 29 31 31 253 sky130_fd_sc_hs__dfrbp_2
* cell instance $23730 r90 *1 64.765,-124.05
X$23730 253 329 47 337 30 29 31 31 253 sky130_fd_sc_hs__dfrbp_2
* cell instance $23736 r90 *1 75.665,-124.05
X$23736 253 330 50 338 30 29 31 31 253 sky130_fd_sc_hs__dfrbp_2
* cell instance $23742 r90 *1 86.565,-124.05
X$23742 253 331 53 339 30 29 31 31 253 sky130_fd_sc_hs__dfrbp_2
* cell instance $23748 r90 *1 10.265,-89.88
X$23748 253 341 33 340 30 29 31 31 253 sky130_fd_sc_hs__dfrbp_2
* cell instance $23754 r90 *1 21.165,-89.88
X$23754 253 345 36 344 30 29 31 31 253 sky130_fd_sc_hs__dfrbp_2
* cell instance $23760 r90 *1 32.065,-89.88
X$23760 253 349 39 348 30 29 31 31 253 sky130_fd_sc_hs__dfrbp_2
* cell instance $23766 r90 *1 42.965,-89.88
X$23766 253 353 42 352 30 29 31 31 253 sky130_fd_sc_hs__dfrbp_2
* cell instance $23772 r90 *1 53.865,-89.88
X$23772 253 357 45 356 30 29 31 31 253 sky130_fd_sc_hs__dfrbp_2
* cell instance $23778 r90 *1 64.765,-89.88
X$23778 253 361 48 360 30 29 31 31 253 sky130_fd_sc_hs__dfrbp_2
* cell instance $23784 r90 *1 75.665,-89.88
X$23784 253 365 51 364 30 29 31 31 253 sky130_fd_sc_hs__dfrbp_2
* cell instance $23790 r90 *1 86.565,-89.88
X$23790 253 369 54 368 30 29 31 31 253 sky130_fd_sc_hs__dfrbp_2
* device instance $1 m45 *1 -56.35,-78.595 pfet_01v8
M$1 31 16 255 31 pfet_01v8 L=150000U W=2500000U AS=662500000000P
+ AD=350000000000P PS=5530000U PD=2780000U
* device instance $2 m45 *1 -56.35,-78.165 pfet_01v8
M$2 255 19 31 31 pfet_01v8 L=150000U W=2500000U AS=350000000000P
+ AD=350000000000P PS=2780000U PD=2780000U
* device instance $3 m45 *1 -56.35,-77.735 pfet_01v8
M$3 31 22 255 31 pfet_01v8 L=150000U W=2500000U AS=350000000000P
+ AD=662500000000P PS=2780000U PD=5530000U
* device instance $4 m45 *1 -56.35,-74.795 pfet_01v8
M$4 31 16 256 31 pfet_01v8 L=150000U W=2500000U AS=662500000000P
+ AD=350000000000P PS=5530000U PD=2780000U
* device instance $5 m45 *1 -56.35,-74.365 pfet_01v8
M$5 256 19 31 31 pfet_01v8 L=150000U W=2500000U AS=350000000000P
+ AD=350000000000P PS=2780000U PD=2780000U
* device instance $6 m45 *1 -56.35,-73.935 pfet_01v8
M$6 31 24 256 31 pfet_01v8 L=150000U W=2500000U AS=350000000000P
+ AD=662500000000P PS=2780000U PD=5530000U
* device instance $7 m45 *1 -56.35,-69.995 pfet_01v8
M$7 31 16 257 31 pfet_01v8 L=150000U W=2500000U AS=662500000000P
+ AD=350000000000P PS=5530000U PD=2780000U
* device instance $8 m45 *1 -56.35,-69.565 pfet_01v8
M$8 257 21 31 31 pfet_01v8 L=150000U W=2500000U AS=350000000000P
+ AD=350000000000P PS=2780000U PD=2780000U
* device instance $9 m45 *1 -56.35,-69.135 pfet_01v8
M$9 31 22 257 31 pfet_01v8 L=150000U W=2500000U AS=350000000000P
+ AD=662500000000P PS=2780000U PD=5530000U
* device instance $10 m45 *1 -56.35,-66.195 pfet_01v8
M$10 31 16 258 31 pfet_01v8 L=150000U W=2500000U AS=662500000000P
+ AD=350000000000P PS=5530000U PD=2780000U
* device instance $11 m45 *1 -56.35,-65.765 pfet_01v8
M$11 258 21 31 31 pfet_01v8 L=150000U W=2500000U AS=350000000000P
+ AD=350000000000P PS=2780000U PD=2780000U
* device instance $12 m45 *1 -56.35,-65.335 pfet_01v8
M$12 31 24 258 31 pfet_01v8 L=150000U W=2500000U AS=350000000000P
+ AD=662500000000P PS=2780000U PD=5530000U
* device instance $13 m45 *1 -56.35,-61.395 pfet_01v8
M$13 31 18 259 31 pfet_01v8 L=150000U W=2500000U AS=662500000000P
+ AD=350000000000P PS=5530000U PD=2780000U
* device instance $14 m45 *1 -56.35,-60.965 pfet_01v8
M$14 259 19 31 31 pfet_01v8 L=150000U W=2500000U AS=350000000000P
+ AD=350000000000P PS=2780000U PD=2780000U
* device instance $15 m45 *1 -56.35,-60.535 pfet_01v8
M$15 31 22 259 31 pfet_01v8 L=150000U W=2500000U AS=350000000000P
+ AD=662500000000P PS=2780000U PD=5530000U
* device instance $16 m45 *1 -56.35,-57.595 pfet_01v8
M$16 31 18 260 31 pfet_01v8 L=150000U W=2500000U AS=662500000000P
+ AD=350000000000P PS=5530000U PD=2780000U
* device instance $17 m45 *1 -56.35,-57.165 pfet_01v8
M$17 260 19 31 31 pfet_01v8 L=150000U W=2500000U AS=350000000000P
+ AD=350000000000P PS=2780000U PD=2780000U
* device instance $18 m45 *1 -56.35,-56.735 pfet_01v8
M$18 31 24 260 31 pfet_01v8 L=150000U W=2500000U AS=350000000000P
+ AD=662500000000P PS=2780000U PD=5530000U
* device instance $19 m45 *1 -56.35,-52.795 pfet_01v8
M$19 31 18 261 31 pfet_01v8 L=150000U W=2500000U AS=662500000000P
+ AD=350000000000P PS=5530000U PD=2780000U
* device instance $20 m45 *1 -56.35,-52.365 pfet_01v8
M$20 261 21 31 31 pfet_01v8 L=150000U W=2500000U AS=350000000000P
+ AD=350000000000P PS=2780000U PD=2780000U
* device instance $21 m45 *1 -56.35,-51.935 pfet_01v8
M$21 31 22 261 31 pfet_01v8 L=150000U W=2500000U AS=350000000000P
+ AD=662500000000P PS=2780000U PD=5530000U
* device instance $22 m45 *1 -56.35,-48.995 pfet_01v8
M$22 31 18 262 31 pfet_01v8 L=150000U W=2500000U AS=662500000000P
+ AD=350000000000P PS=5530000U PD=2780000U
* device instance $23 m45 *1 -56.35,-48.565 pfet_01v8
M$23 262 21 31 31 pfet_01v8 L=150000U W=2500000U AS=350000000000P
+ AD=350000000000P PS=2780000U PD=2780000U
* device instance $24 m45 *1 -56.35,-48.135 pfet_01v8
M$24 31 24 262 31 pfet_01v8 L=150000U W=2500000U AS=350000000000P
+ AD=662500000000P PS=2780000U PD=5530000U
* device instance $25 m45 *1 -51.89,-78.345 pfet_01v8
M$25 279 255 31 31 pfet_01v8 L=150000U W=4200000U AS=675500000000P
+ AD=675500000000P PS=6830000U PD=6830000U
* device instance $31 m45 *1 -51.89,-74.545 pfet_01v8
M$31 280 256 31 31 pfet_01v8 L=150000U W=4200000U AS=675500000000P
+ AD=675500000000P PS=6830000U PD=6830000U
* device instance $37 m45 *1 -51.89,-69.745 pfet_01v8
M$37 281 257 31 31 pfet_01v8 L=150000U W=4200000U AS=675500000000P
+ AD=675500000000P PS=6830000U PD=6830000U
* device instance $43 m45 *1 -51.89,-65.945 pfet_01v8
M$43 282 258 31 31 pfet_01v8 L=150000U W=4200000U AS=675500000000P
+ AD=675500000000P PS=6830000U PD=6830000U
* device instance $49 m45 *1 -51.89,-61.145 pfet_01v8
M$49 283 259 31 31 pfet_01v8 L=150000U W=4200000U AS=675500000000P
+ AD=675500000000P PS=6830000U PD=6830000U
* device instance $55 m45 *1 -51.89,-57.345 pfet_01v8
M$55 284 260 31 31 pfet_01v8 L=150000U W=4200000U AS=675500000000P
+ AD=675500000000P PS=6830000U PD=6830000U
* device instance $61 m45 *1 -51.89,-52.545 pfet_01v8
M$61 285 261 31 31 pfet_01v8 L=150000U W=4200000U AS=675500000000P
+ AD=675500000000P PS=6830000U PD=6830000U
* device instance $67 m45 *1 -51.89,-48.745 pfet_01v8
M$67 286 262 31 31 pfet_01v8 L=150000U W=4200000U AS=675500000000P
+ AD=675500000000P PS=6830000U PD=6830000U
* device instance $73 m45 *1 -45.13,-78.345 pfet_01v8
M$73 64 279 31 31 pfet_01v8 L=150000U W=8400000U AS=1.2635e+12P AD=1.2635e+12P
+ PS=12710000U PD=12710000U
* device instance $85 m45 *1 -45.13,-74.545 pfet_01v8
M$85 66 280 31 31 pfet_01v8 L=150000U W=8400000U AS=1.2635e+12P AD=1.2635e+12P
+ PS=12710000U PD=12710000U
* device instance $97 m45 *1 -45.13,-65.945 pfet_01v8
M$97 59 282 31 31 pfet_01v8 L=150000U W=8400000U AS=1.2635e+12P AD=1.2635e+12P
+ PS=12710000U PD=12710000U
* device instance $109 m45 *1 -45.13,-61.145 pfet_01v8
M$109 75 283 31 31 pfet_01v8 L=150000U W=8400000U AS=1.2635e+12P AD=1.2635e+12P
+ PS=12710000U PD=12710000U
* device instance $121 m45 *1 -45.13,-57.345 pfet_01v8
M$121 72 284 31 31 pfet_01v8 L=150000U W=8400000U AS=1.2635e+12P AD=1.2635e+12P
+ PS=12710000U PD=12710000U
* device instance $133 m45 *1 -45.13,-52.545 pfet_01v8
M$133 70 285 31 31 pfet_01v8 L=150000U W=8400000U AS=1.2635e+12P AD=1.2635e+12P
+ PS=12710000U PD=12710000U
* device instance $145 m45 *1 -45.13,-48.745 pfet_01v8
M$145 69 286 31 31 pfet_01v8 L=150000U W=8400000U AS=1.2635e+12P AD=1.2635e+12P
+ PS=12710000U PD=12710000U
* device instance $157 m45 *1 -45.13,-69.745 pfet_01v8
M$157 61 281 31 31 pfet_01v8 L=150000U W=8400000U AS=1.2635e+12P AD=1.2635e+12P
+ PS=12710000U PD=12710000U
* device instance $169 m45 *1 -36.22,-78.345 pfet_01v8
M$169 31 64 65 31 pfet_01v8 L=150000U W=15400000U AS=2.331e+12P AD=2.331e+12P
+ PS=23460000U PD=23460000U
* device instance $191 m45 *1 -36.22,-74.545 pfet_01v8
M$191 31 66 62 31 pfet_01v8 L=150000U W=15400000U AS=2.331e+12P AD=2.331e+12P
+ PS=23460000U PD=23460000U
* device instance $213 m45 *1 -36.22,-69.745 pfet_01v8
M$213 31 61 60 31 pfet_01v8 L=150000U W=15400000U AS=2.331e+12P AD=2.331e+12P
+ PS=23460000U PD=23460000U
* device instance $224 m45 *1 -36.22,-64.045 pfet_01v8
M$224 31 59 58 31 pfet_01v8 L=150000U W=15400000U AS=2.331e+12P AD=2.331e+12P
+ PS=23460000U PD=23460000U
* device instance $235 m45 *1 -36.22,-61.145 pfet_01v8
M$235 31 75 73 31 pfet_01v8 L=150000U W=15400000U AS=2.331e+12P AD=2.331e+12P
+ PS=23460000U PD=23460000U
* device instance $257 m45 *1 -36.22,-55.445 pfet_01v8
M$257 31 72 74 31 pfet_01v8 L=150000U W=15400000U AS=2.331e+12P AD=2.331e+12P
+ PS=23460000U PD=23460000U
* device instance $268 m45 *1 -36.22,-52.545 pfet_01v8
M$268 31 70 71 31 pfet_01v8 L=150000U W=15400000U AS=2.331e+12P AD=2.331e+12P
+ PS=23460000U PD=23460000U
* device instance $290 m45 *1 -36.22,-48.745 pfet_01v8
M$290 31 69 68 31 pfet_01v8 L=150000U W=15400000U AS=2.331e+12P AD=2.331e+12P
+ PS=23460000U PD=23460000U
* device instance $345 m45 *1 -59.62,-78.595 nfet_01v8
M$345 264 16 255 253 nfet_01v8 L=150000U W=3000000U AS=795000000000P
+ AD=420000000000P PS=6530000U PD=3280000U
* device instance $346 m45 *1 -59.62,-78.165 nfet_01v8
M$346 263 19 264 253 nfet_01v8 L=150000U W=3000000U AS=420000000000P
+ AD=420000000000P PS=3280000U PD=3280000U
* device instance $347 m45 *1 -59.62,-77.735 nfet_01v8
M$347 253 22 263 253 nfet_01v8 L=150000U W=3000000U AS=420000000000P
+ AD=795000000000P PS=3280000U PD=6530000U
* device instance $348 m45 *1 -59.62,-74.795 nfet_01v8
M$348 266 16 256 253 nfet_01v8 L=150000U W=3000000U AS=795000000000P
+ AD=420000000000P PS=6530000U PD=3280000U
* device instance $349 m45 *1 -59.62,-74.365 nfet_01v8
M$349 265 19 266 253 nfet_01v8 L=150000U W=3000000U AS=420000000000P
+ AD=420000000000P PS=3280000U PD=3280000U
* device instance $350 m45 *1 -59.62,-73.935 nfet_01v8
M$350 253 24 265 253 nfet_01v8 L=150000U W=3000000U AS=420000000000P
+ AD=795000000000P PS=3280000U PD=6530000U
* device instance $351 m45 *1 -59.62,-69.995 nfet_01v8
M$351 270 16 257 253 nfet_01v8 L=150000U W=3000000U AS=795000000000P
+ AD=420000000000P PS=6530000U PD=3280000U
* device instance $352 m45 *1 -59.62,-69.565 nfet_01v8
M$352 269 21 270 253 nfet_01v8 L=150000U W=3000000U AS=420000000000P
+ AD=420000000000P PS=3280000U PD=3280000U
* device instance $353 m45 *1 -59.62,-69.135 nfet_01v8
M$353 253 22 269 253 nfet_01v8 L=150000U W=3000000U AS=420000000000P
+ AD=795000000000P PS=3280000U PD=6530000U
* device instance $354 m45 *1 -59.62,-66.195 nfet_01v8
M$354 272 16 258 253 nfet_01v8 L=150000U W=3000000U AS=795000000000P
+ AD=420000000000P PS=6530000U PD=3280000U
* device instance $355 m45 *1 -59.62,-65.765 nfet_01v8
M$355 271 21 272 253 nfet_01v8 L=150000U W=3000000U AS=420000000000P
+ AD=420000000000P PS=3280000U PD=3280000U
* device instance $356 m45 *1 -59.62,-65.335 nfet_01v8
M$356 253 24 271 253 nfet_01v8 L=150000U W=3000000U AS=420000000000P
+ AD=795000000000P PS=3280000U PD=6530000U
* device instance $357 m45 *1 -59.62,-61.395 nfet_01v8
M$357 276 18 259 253 nfet_01v8 L=150000U W=3000000U AS=795000000000P
+ AD=420000000000P PS=6530000U PD=3280000U
* device instance $358 m45 *1 -59.62,-60.965 nfet_01v8
M$358 275 19 276 253 nfet_01v8 L=150000U W=3000000U AS=420000000000P
+ AD=420000000000P PS=3280000U PD=3280000U
* device instance $359 m45 *1 -59.62,-60.535 nfet_01v8
M$359 253 22 275 253 nfet_01v8 L=150000U W=3000000U AS=420000000000P
+ AD=795000000000P PS=3280000U PD=6530000U
* device instance $360 m45 *1 -59.62,-57.595 nfet_01v8
M$360 278 18 260 253 nfet_01v8 L=150000U W=3000000U AS=795000000000P
+ AD=420000000000P PS=6530000U PD=3280000U
* device instance $361 m45 *1 -59.62,-57.165 nfet_01v8
M$361 277 19 278 253 nfet_01v8 L=150000U W=3000000U AS=420000000000P
+ AD=420000000000P PS=3280000U PD=3280000U
* device instance $362 m45 *1 -59.62,-56.735 nfet_01v8
M$362 253 24 277 253 nfet_01v8 L=150000U W=3000000U AS=420000000000P
+ AD=795000000000P PS=3280000U PD=6530000U
* device instance $363 m45 *1 -59.62,-52.795 nfet_01v8
M$363 273 18 261 253 nfet_01v8 L=150000U W=3000000U AS=795000000000P
+ AD=420000000000P PS=6530000U PD=3280000U
* device instance $364 m45 *1 -59.62,-52.365 nfet_01v8
M$364 274 21 273 253 nfet_01v8 L=150000U W=3000000U AS=420000000000P
+ AD=420000000000P PS=3280000U PD=3280000U
* device instance $365 m45 *1 -59.62,-51.935 nfet_01v8
M$365 253 22 274 253 nfet_01v8 L=150000U W=3000000U AS=420000000000P
+ AD=795000000000P PS=3280000U PD=6530000U
* device instance $366 m45 *1 -59.62,-48.995 nfet_01v8
M$366 267 18 262 253 nfet_01v8 L=150000U W=3000000U AS=795000000000P
+ AD=420000000000P PS=6530000U PD=3280000U
* device instance $367 m45 *1 -59.62,-48.565 nfet_01v8
M$367 268 21 267 253 nfet_01v8 L=150000U W=3000000U AS=420000000000P
+ AD=420000000000P PS=3280000U PD=3280000U
* device instance $368 m45 *1 -59.62,-48.135 nfet_01v8
M$368 253 24 268 253 nfet_01v8 L=150000U W=3000000U AS=420000000000P
+ AD=795000000000P PS=3280000U PD=6530000U
* device instance $369 m45 *1 -53.955,-78.345 nfet_01v8
M$369 253 255 279 253 nfet_01v8 L=150000U W=2100000U AS=381500000000P
+ AD=381500000000P PS=3890000U PD=3890000U
* device instance $372 m45 *1 -53.955,-74.545 nfet_01v8
M$372 253 256 280 253 nfet_01v8 L=150000U W=2100000U AS=381500000000P
+ AD=381500000000P PS=3890000U PD=3890000U
* device instance $375 m45 *1 -53.955,-69.745 nfet_01v8
M$375 253 257 281 253 nfet_01v8 L=150000U W=2100000U AS=381500000000P
+ AD=381500000000P PS=3890000U PD=3890000U
* device instance $378 m45 *1 -53.955,-65.945 nfet_01v8
M$378 253 258 282 253 nfet_01v8 L=150000U W=2100000U AS=381500000000P
+ AD=381500000000P PS=3890000U PD=3890000U
* device instance $381 m45 *1 -53.955,-61.145 nfet_01v8
M$381 253 259 283 253 nfet_01v8 L=150000U W=2100000U AS=381500000000P
+ AD=381500000000P PS=3890000U PD=3890000U
* device instance $384 m45 *1 -53.955,-57.345 nfet_01v8
M$384 253 260 284 253 nfet_01v8 L=150000U W=2100000U AS=381500000000P
+ AD=381500000000P PS=3890000U PD=3890000U
* device instance $387 m45 *1 -53.955,-52.545 nfet_01v8
M$387 253 261 285 253 nfet_01v8 L=150000U W=2100000U AS=381500000000P
+ AD=381500000000P PS=3890000U PD=3890000U
* device instance $390 m45 *1 -53.955,-48.745 nfet_01v8
M$390 253 262 286 253 nfet_01v8 L=150000U W=2100000U AS=381500000000P
+ AD=381500000000P PS=3890000U PD=3890000U
* device instance $393 m45 *1 -48.055,-78.345 nfet_01v8
M$393 253 279 64 253 nfet_01v8 L=150000U W=3500000U AS=577500000000P
+ AD=577500000000P PS=5850000U PD=5850000U
* device instance $398 m45 *1 -48.055,-65.945 nfet_01v8
M$398 253 282 59 253 nfet_01v8 L=150000U W=3500000U AS=577500000000P
+ AD=577500000000P PS=5850000U PD=5850000U
* device instance $403 m45 *1 -48.055,-61.145 nfet_01v8
M$403 253 283 75 253 nfet_01v8 L=150000U W=3500000U AS=577500000000P
+ AD=577500000000P PS=5850000U PD=5850000U
* device instance $408 m45 *1 -48.055,-57.345 nfet_01v8
M$408 253 284 72 253 nfet_01v8 L=150000U W=3500000U AS=577500000000P
+ AD=577500000000P PS=5850000U PD=5850000U
* device instance $413 m45 *1 -48.055,-48.745 nfet_01v8
M$413 253 286 69 253 nfet_01v8 L=150000U W=3500000U AS=577500000000P
+ AD=577500000000P PS=5850000U PD=5850000U
* device instance $418 m45 *1 -48.055,-74.545 nfet_01v8
M$418 253 280 66 253 nfet_01v8 L=150000U W=3500000U AS=577500000000P
+ AD=577500000000P PS=5850000U PD=5850000U
* device instance $423 m45 *1 -48.055,-69.745 nfet_01v8
M$423 253 281 61 253 nfet_01v8 L=150000U W=3500000U AS=577500000000P
+ AD=577500000000P PS=5850000U PD=5850000U
* device instance $428 m45 *1 -48.055,-52.545 nfet_01v8
M$428 253 285 70 253 nfet_01v8 L=150000U W=3500000U AS=577500000000P
+ AD=577500000000P PS=5850000U PD=5850000U
* device instance $433 m45 *1 -38.715,-78.345 nfet_01v8
M$433 65 64 253 253 nfet_01v8 L=150000U W=5600000U AS=959000000000P
+ AD=959000000000P PS=9740000U PD=9740000U
* device instance $441 m45 *1 -38.715,-74.545 nfet_01v8
M$441 62 66 253 253 nfet_01v8 L=150000U W=5600000U AS=959000000000P
+ AD=959000000000P PS=9740000U PD=9740000U
* device instance $449 m45 *1 -38.715,-69.745 nfet_01v8
M$449 60 61 253 253 nfet_01v8 L=150000U W=5600000U AS=959000000000P
+ AD=959000000000P PS=9740000U PD=9740000U
* device instance $457 m45 *1 -38.715,-64.045 nfet_01v8
M$457 58 59 253 253 nfet_01v8 L=150000U W=5600000U AS=959000000000P
+ AD=959000000000P PS=9740000U PD=9740000U
* device instance $461 m45 *1 -38.715,-61.145 nfet_01v8
M$461 73 75 253 253 nfet_01v8 L=150000U W=5600000U AS=959000000000P
+ AD=959000000000P PS=9740000U PD=9740000U
* device instance $465 m45 *1 -38.715,-57.345 nfet_01v8
M$465 74 72 253 253 nfet_01v8 L=150000U W=5600000U AS=959000000000P
+ AD=959000000000P PS=9740000U PD=9740000U
* device instance $469 m45 *1 -38.715,-52.545 nfet_01v8
M$469 71 70 253 253 nfet_01v8 L=150000U W=5600000U AS=959000000000P
+ AD=959000000000P PS=9740000U PD=9740000U
* device instance $477 m45 *1 -38.715,-48.745 nfet_01v8
M$477 68 69 253 253 nfet_01v8 L=150000U W=5600000U AS=959000000000P
+ AD=959000000000P PS=9740000U PD=9740000U
* device instance $497 r270 *1 -34.52,-87.725 pfet_01v8
M$497 31 254 56 31 pfet_01v8 L=150000U W=9800000U AS=1.547e+12P AD=1.547e+12P
+ PS=15620000U PD=15620000U
* device instance $504 r270 *1 -36.585,-87.725 nfet_01v8
M$504 253 254 56 253 nfet_01v8 L=150000U W=4200000U AS=763000000000P
+ AD=763000000000P PS=7780000U PD=7780000U
* device instance $517 r270 *1 -34.95,-4.61 pfet_01v8
M$517 77 289 31 31 pfet_01v8 L=150000U W=44800000U AS=6.972e+12P AD=6.972e+12P
+ PS=70320000U PD=70320000U
* device instance $525 r270 *1 -37.015,-4.61 nfet_01v8
M$525 253 289 77 253 nfet_01v8 L=150000U W=16800000U AS=3.052e+12P
+ AD=3.052e+12P PS=31120000U PD=31120000U
* device instance $605 r270 *1 -41.71,-4.61 pfet_01v8
M$605 289 288 31 31 pfet_01v8 L=150000U W=16800000U AS=2.6145e+12P
+ AD=2.6145e+12P PS=26370000U PD=26370000U
* device instance $613 r270 *1 -43.775,-4.61 nfet_01v8
M$613 253 288 289 253 nfet_01v8 L=150000U W=6300000U AS=1.1445e+12P
+ AD=1.1445e+12P PS=11670000U PD=11670000U
* device instance $638 r270 *1 -48.9,-4.61 pfet_01v8
M$638 31 287 288 31 pfet_01v8 L=150000U W=6300000U AS=969500000000P
+ AD=969500000000P PS=9770000U PD=9770000U
* device instance $647 r270 *1 -51.395,-4.61 nfet_01v8
M$647 288 287 253 253 nfet_01v8 L=150000U W=2800000U AS=479500000000P
+ AD=479500000000P PS=4870000U PD=4870000U
* device instance $651 r0 *1 -95.5,10.115 pfet_01v8
M$651 82 290 31 31 pfet_01v8 L=150000U W=11200000U AS=1.743e+12P AD=1.743e+12P
+ PS=17580000U PD=17580000U
* device instance $659 r0 *1 -95.5,8.05 nfet_01v8
M$659 253 290 82 253 nfet_01v8 L=150000U W=4200000U AS=763000000000P
+ AD=763000000000P PS=7780000U PD=7780000U
* device instance $673 r0 *1 -95.535,6.28 pfet_01v8
M$673 290 81 31 31 pfet_01v8 L=150000U W=2500000U AS=506250000000P
+ AD=506250000000P PS=4560000U PD=4560000U
* device instance $675 r0 *1 -95.535,4.885 nfet_01v8
M$675 290 81 253 253 nfet_01v8 L=150000U W=1000000U AS=202500000000P
+ AD=202500000000P PS=2310000U PD=2310000U
* device instance $677 r270 *1 -34.95,-26.25 pfet_01v8
M$677 76 291 31 31 pfet_01v8 L=150000U W=11200000U AS=1.743e+12P AD=1.743e+12P
+ PS=17580000U PD=17580000U
* device instance $685 r270 *1 -37.015,-26.25 nfet_01v8
M$685 253 291 76 253 nfet_01v8 L=150000U W=4200000U AS=763000000000P
+ AD=763000000000P PS=7780000U PD=7780000U
* device instance $699 r270 *1 -38.355,-87.69 pfet_01v8
M$699 254 57 31 31 pfet_01v8 L=150000U W=2500000U AS=506250000000P
+ AD=506250000000P PS=4560000U PD=4560000U
* device instance $701 r270 *1 -39.75,-87.69 nfet_01v8
M$701 254 57 253 253 nfet_01v8 L=150000U W=1000000U AS=202500000000P
+ AD=202500000000P PS=2310000U PD=2310000U
* device instance $703 r270 *1 -53.165,-4.575 pfet_01v8
M$703 287 80 31 31 pfet_01v8 L=150000U W=2500000U AS=506250000000P
+ AD=506250000000P PS=4560000U PD=4560000U
* device instance $705 r270 *1 -54.56,-4.575 nfet_01v8
M$705 287 80 253 253 nfet_01v8 L=150000U W=1000000U AS=202500000000P
+ AD=202500000000P PS=2310000U PD=2310000U
* device instance $707 r270 *1 -38.785,-26.215 pfet_01v8
M$707 291 63 31 31 pfet_01v8 L=150000U W=2500000U AS=506250000000P
+ AD=506250000000P PS=4560000U PD=4560000U
* device instance $709 r270 *1 -40.18,-26.215 nfet_01v8
M$709 291 63 253 253 nfet_01v8 L=150000U W=1000000U AS=202500000000P
+ AD=202500000000P PS=2310000U PD=2310000U
* device instance $711 r0 *1 5.6,-6.615 pfet_01v8
M$711 31 77 104 31 pfet_01v8 L=150000U W=1350000U AS=357750000000P
+ AD=357750000000P PS=3230000U PD=3230000U
* device instance $712 r0 *1 5.6,-8.235 pfet_01v8
M$712 105 77 31 31 pfet_01v8 L=150000U W=1350000U AS=357750000000P
+ AD=357750000000P PS=3230000U PD=3230000U
* device instance $713 r0 *1 5.6,-9.58 pfet_01v8
M$713 105 77 104 31 pfet_01v8 L=150000U W=800000U AS=212000000000P
+ AD=212000000000P PS=2130000U PD=2130000U
* device instance $714 m90 *1 4.4,-6.615 pfet_01v8
M$714 31 77 103 31 pfet_01v8 L=150000U W=1350000U AS=357750000000P
+ AD=357750000000P PS=3230000U PD=3230000U
* device instance $715 m90 *1 4.4,-8.235 pfet_01v8
M$715 102 77 31 31 pfet_01v8 L=150000U W=1350000U AS=357750000000P
+ AD=357750000000P PS=3230000U PD=3230000U
* device instance $716 m90 *1 4.4,-9.58 pfet_01v8
M$716 102 77 103 31 pfet_01v8 L=150000U W=800000U AS=212000000000P
+ AD=212000000000P PS=2130000U PD=2130000U
* device instance $717 m90 *1 6.8,-6.615 pfet_01v8
M$717 31 77 107 31 pfet_01v8 L=150000U W=1350000U AS=357750000000P
+ AD=357750000000P PS=3230000U PD=3230000U
* device instance $718 m90 *1 6.8,-8.235 pfet_01v8
M$718 106 77 31 31 pfet_01v8 L=150000U W=1350000U AS=357750000000P
+ AD=357750000000P PS=3230000U PD=3230000U
* device instance $719 m90 *1 6.8,-9.58 pfet_01v8
M$719 106 77 107 31 pfet_01v8 L=150000U W=800000U AS=212000000000P
+ AD=212000000000P PS=2130000U PD=2130000U
* device instance $720 r0 *1 8,-6.615 pfet_01v8
M$720 31 77 108 31 pfet_01v8 L=150000U W=1350000U AS=357750000000P
+ AD=357750000000P PS=3230000U PD=3230000U
* device instance $721 r0 *1 8,-8.235 pfet_01v8
M$721 109 77 31 31 pfet_01v8 L=150000U W=1350000U AS=357750000000P
+ AD=357750000000P PS=3230000U PD=3230000U
* device instance $722 r0 *1 8,-9.58 pfet_01v8
M$722 109 77 108 31 pfet_01v8 L=150000U W=800000U AS=212000000000P
+ AD=212000000000P PS=2130000U PD=2130000U
* device instance $723 m90 *1 9.2,-6.615 pfet_01v8
M$723 31 77 111 31 pfet_01v8 L=150000U W=1350000U AS=357750000000P
+ AD=357750000000P PS=3230000U PD=3230000U
* device instance $724 m90 *1 9.2,-8.235 pfet_01v8
M$724 110 77 31 31 pfet_01v8 L=150000U W=1350000U AS=357750000000P
+ AD=357750000000P PS=3230000U PD=3230000U
* device instance $725 m90 *1 9.2,-9.58 pfet_01v8
M$725 110 77 111 31 pfet_01v8 L=150000U W=800000U AS=212000000000P
+ AD=212000000000P PS=2130000U PD=2130000U
* device instance $726 r0 *1 10.4,-6.615 pfet_01v8
M$726 31 77 112 31 pfet_01v8 L=150000U W=1350000U AS=357750000000P
+ AD=357750000000P PS=3230000U PD=3230000U
* device instance $727 r0 *1 10.4,-8.235 pfet_01v8
M$727 113 77 31 31 pfet_01v8 L=150000U W=1350000U AS=357750000000P
+ AD=357750000000P PS=3230000U PD=3230000U
* device instance $728 r0 *1 10.4,-9.58 pfet_01v8
M$728 113 77 112 31 pfet_01v8 L=150000U W=800000U AS=212000000000P
+ AD=212000000000P PS=2130000U PD=2130000U
* device instance $729 m90 *1 11.6,-6.615 pfet_01v8
M$729 31 77 115 31 pfet_01v8 L=150000U W=1350000U AS=357750000000P
+ AD=357750000000P PS=3230000U PD=3230000U
* device instance $730 m90 *1 11.6,-8.235 pfet_01v8
M$730 114 77 31 31 pfet_01v8 L=150000U W=1350000U AS=357750000000P
+ AD=357750000000P PS=3230000U PD=3230000U
* device instance $731 m90 *1 11.6,-9.58 pfet_01v8
M$731 114 77 115 31 pfet_01v8 L=150000U W=800000U AS=212000000000P
+ AD=212000000000P PS=2130000U PD=2130000U
* device instance $732 r0 *1 12.8,-6.615 pfet_01v8
M$732 31 77 116 31 pfet_01v8 L=150000U W=1350000U AS=357750000000P
+ AD=357750000000P PS=3230000U PD=3230000U
* device instance $733 r0 *1 12.8,-8.235 pfet_01v8
M$733 117 77 31 31 pfet_01v8 L=150000U W=1350000U AS=357750000000P
+ AD=357750000000P PS=3230000U PD=3230000U
* device instance $734 r0 *1 12.8,-9.58 pfet_01v8
M$734 117 77 116 31 pfet_01v8 L=150000U W=800000U AS=212000000000P
+ AD=212000000000P PS=2130000U PD=2130000U
* device instance $735 r0 *1 16.5,-6.615 pfet_01v8
M$735 31 77 120 31 pfet_01v8 L=150000U W=1350000U AS=357750000000P
+ AD=357750000000P PS=3230000U PD=3230000U
* device instance $736 r0 *1 16.5,-8.235 pfet_01v8
M$736 121 77 31 31 pfet_01v8 L=150000U W=1350000U AS=357750000000P
+ AD=357750000000P PS=3230000U PD=3230000U
* device instance $737 r0 *1 16.5,-9.58 pfet_01v8
M$737 121 77 120 31 pfet_01v8 L=150000U W=800000U AS=212000000000P
+ AD=212000000000P PS=2130000U PD=2130000U
* device instance $738 m90 *1 15.3,-6.615 pfet_01v8
M$738 31 77 119 31 pfet_01v8 L=150000U W=1350000U AS=357750000000P
+ AD=357750000000P PS=3230000U PD=3230000U
* device instance $739 m90 *1 15.3,-8.235 pfet_01v8
M$739 118 77 31 31 pfet_01v8 L=150000U W=1350000U AS=357750000000P
+ AD=357750000000P PS=3230000U PD=3230000U
* device instance $740 m90 *1 15.3,-9.58 pfet_01v8
M$740 118 77 119 31 pfet_01v8 L=150000U W=800000U AS=212000000000P
+ AD=212000000000P PS=2130000U PD=2130000U
* device instance $741 m90 *1 17.7,-6.615 pfet_01v8
M$741 31 77 123 31 pfet_01v8 L=150000U W=1350000U AS=357750000000P
+ AD=357750000000P PS=3230000U PD=3230000U
* device instance $742 m90 *1 17.7,-8.235 pfet_01v8
M$742 122 77 31 31 pfet_01v8 L=150000U W=1350000U AS=357750000000P
+ AD=357750000000P PS=3230000U PD=3230000U
* device instance $743 m90 *1 17.7,-9.58 pfet_01v8
M$743 122 77 123 31 pfet_01v8 L=150000U W=800000U AS=212000000000P
+ AD=212000000000P PS=2130000U PD=2130000U
* device instance $744 r0 *1 18.9,-6.615 pfet_01v8
M$744 31 77 124 31 pfet_01v8 L=150000U W=1350000U AS=357750000000P
+ AD=357750000000P PS=3230000U PD=3230000U
* device instance $745 r0 *1 18.9,-8.235 pfet_01v8
M$745 125 77 31 31 pfet_01v8 L=150000U W=1350000U AS=357750000000P
+ AD=357750000000P PS=3230000U PD=3230000U
* device instance $746 r0 *1 18.9,-9.58 pfet_01v8
M$746 125 77 124 31 pfet_01v8 L=150000U W=800000U AS=212000000000P
+ AD=212000000000P PS=2130000U PD=2130000U
* device instance $747 m90 *1 20.1,-6.615 pfet_01v8
M$747 31 77 127 31 pfet_01v8 L=150000U W=1350000U AS=357750000000P
+ AD=357750000000P PS=3230000U PD=3230000U
* device instance $748 m90 *1 20.1,-8.235 pfet_01v8
M$748 126 77 31 31 pfet_01v8 L=150000U W=1350000U AS=357750000000P
+ AD=357750000000P PS=3230000U PD=3230000U
* device instance $749 m90 *1 20.1,-9.58 pfet_01v8
M$749 126 77 127 31 pfet_01v8 L=150000U W=800000U AS=212000000000P
+ AD=212000000000P PS=2130000U PD=2130000U
* device instance $750 r0 *1 21.3,-6.615 pfet_01v8
M$750 31 77 128 31 pfet_01v8 L=150000U W=1350000U AS=357750000000P
+ AD=357750000000P PS=3230000U PD=3230000U
* device instance $751 r0 *1 21.3,-8.235 pfet_01v8
M$751 129 77 31 31 pfet_01v8 L=150000U W=1350000U AS=357750000000P
+ AD=357750000000P PS=3230000U PD=3230000U
* device instance $752 r0 *1 21.3,-9.58 pfet_01v8
M$752 129 77 128 31 pfet_01v8 L=150000U W=800000U AS=212000000000P
+ AD=212000000000P PS=2130000U PD=2130000U
* device instance $753 m90 *1 22.5,-6.615 pfet_01v8
M$753 31 77 131 31 pfet_01v8 L=150000U W=1350000U AS=357750000000P
+ AD=357750000000P PS=3230000U PD=3230000U
* device instance $754 m90 *1 22.5,-8.235 pfet_01v8
M$754 130 77 31 31 pfet_01v8 L=150000U W=1350000U AS=357750000000P
+ AD=357750000000P PS=3230000U PD=3230000U
* device instance $755 m90 *1 22.5,-9.58 pfet_01v8
M$755 130 77 131 31 pfet_01v8 L=150000U W=800000U AS=212000000000P
+ AD=212000000000P PS=2130000U PD=2130000U
* device instance $756 r0 *1 23.7,-6.615 pfet_01v8
M$756 31 77 132 31 pfet_01v8 L=150000U W=1350000U AS=357750000000P
+ AD=357750000000P PS=3230000U PD=3230000U
* device instance $757 r0 *1 23.7,-8.235 pfet_01v8
M$757 133 77 31 31 pfet_01v8 L=150000U W=1350000U AS=357750000000P
+ AD=357750000000P PS=3230000U PD=3230000U
* device instance $758 r0 *1 23.7,-9.58 pfet_01v8
M$758 133 77 132 31 pfet_01v8 L=150000U W=800000U AS=212000000000P
+ AD=212000000000P PS=2130000U PD=2130000U
* device instance $759 r0 *1 27.4,-6.615 pfet_01v8
M$759 31 77 136 31 pfet_01v8 L=150000U W=1350000U AS=357750000000P
+ AD=357750000000P PS=3230000U PD=3230000U
* device instance $760 r0 *1 27.4,-8.235 pfet_01v8
M$760 137 77 31 31 pfet_01v8 L=150000U W=1350000U AS=357750000000P
+ AD=357750000000P PS=3230000U PD=3230000U
* device instance $761 r0 *1 27.4,-9.58 pfet_01v8
M$761 137 77 136 31 pfet_01v8 L=150000U W=800000U AS=212000000000P
+ AD=212000000000P PS=2130000U PD=2130000U
* device instance $762 m90 *1 26.2,-6.615 pfet_01v8
M$762 31 77 135 31 pfet_01v8 L=150000U W=1350000U AS=357750000000P
+ AD=357750000000P PS=3230000U PD=3230000U
* device instance $763 m90 *1 26.2,-8.235 pfet_01v8
M$763 134 77 31 31 pfet_01v8 L=150000U W=1350000U AS=357750000000P
+ AD=357750000000P PS=3230000U PD=3230000U
* device instance $764 m90 *1 26.2,-9.58 pfet_01v8
M$764 134 77 135 31 pfet_01v8 L=150000U W=800000U AS=212000000000P
+ AD=212000000000P PS=2130000U PD=2130000U
* device instance $765 m90 *1 28.6,-6.615 pfet_01v8
M$765 31 77 139 31 pfet_01v8 L=150000U W=1350000U AS=357750000000P
+ AD=357750000000P PS=3230000U PD=3230000U
* device instance $766 m90 *1 28.6,-8.235 pfet_01v8
M$766 138 77 31 31 pfet_01v8 L=150000U W=1350000U AS=357750000000P
+ AD=357750000000P PS=3230000U PD=3230000U
* device instance $767 m90 *1 28.6,-9.58 pfet_01v8
M$767 138 77 139 31 pfet_01v8 L=150000U W=800000U AS=212000000000P
+ AD=212000000000P PS=2130000U PD=2130000U
* device instance $768 r0 *1 29.8,-6.615 pfet_01v8
M$768 31 77 140 31 pfet_01v8 L=150000U W=1350000U AS=357750000000P
+ AD=357750000000P PS=3230000U PD=3230000U
* device instance $769 r0 *1 29.8,-8.235 pfet_01v8
M$769 141 77 31 31 pfet_01v8 L=150000U W=1350000U AS=357750000000P
+ AD=357750000000P PS=3230000U PD=3230000U
* device instance $770 r0 *1 29.8,-9.58 pfet_01v8
M$770 141 77 140 31 pfet_01v8 L=150000U W=800000U AS=212000000000P
+ AD=212000000000P PS=2130000U PD=2130000U
* device instance $771 m90 *1 31,-6.615 pfet_01v8
M$771 31 77 143 31 pfet_01v8 L=150000U W=1350000U AS=357750000000P
+ AD=357750000000P PS=3230000U PD=3230000U
* device instance $772 m90 *1 31,-8.235 pfet_01v8
M$772 142 77 31 31 pfet_01v8 L=150000U W=1350000U AS=357750000000P
+ AD=357750000000P PS=3230000U PD=3230000U
* device instance $773 m90 *1 31,-9.58 pfet_01v8
M$773 142 77 143 31 pfet_01v8 L=150000U W=800000U AS=212000000000P
+ AD=212000000000P PS=2130000U PD=2130000U
* device instance $774 r0 *1 32.2,-6.615 pfet_01v8
M$774 31 77 144 31 pfet_01v8 L=150000U W=1350000U AS=357750000000P
+ AD=357750000000P PS=3230000U PD=3230000U
* device instance $775 r0 *1 32.2,-8.235 pfet_01v8
M$775 145 77 31 31 pfet_01v8 L=150000U W=1350000U AS=357750000000P
+ AD=357750000000P PS=3230000U PD=3230000U
* device instance $776 r0 *1 32.2,-9.58 pfet_01v8
M$776 145 77 144 31 pfet_01v8 L=150000U W=800000U AS=212000000000P
+ AD=212000000000P PS=2130000U PD=2130000U
* device instance $777 m90 *1 33.4,-6.615 pfet_01v8
M$777 31 77 147 31 pfet_01v8 L=150000U W=1350000U AS=357750000000P
+ AD=357750000000P PS=3230000U PD=3230000U
* device instance $778 m90 *1 33.4,-8.235 pfet_01v8
M$778 146 77 31 31 pfet_01v8 L=150000U W=1350000U AS=357750000000P
+ AD=357750000000P PS=3230000U PD=3230000U
* device instance $779 m90 *1 33.4,-9.58 pfet_01v8
M$779 146 77 147 31 pfet_01v8 L=150000U W=800000U AS=212000000000P
+ AD=212000000000P PS=2130000U PD=2130000U
* device instance $780 r0 *1 34.6,-6.615 pfet_01v8
M$780 31 77 148 31 pfet_01v8 L=150000U W=1350000U AS=357750000000P
+ AD=357750000000P PS=3230000U PD=3230000U
* device instance $781 r0 *1 34.6,-8.235 pfet_01v8
M$781 149 77 31 31 pfet_01v8 L=150000U W=1350000U AS=357750000000P
+ AD=357750000000P PS=3230000U PD=3230000U
* device instance $782 r0 *1 34.6,-9.58 pfet_01v8
M$782 149 77 148 31 pfet_01v8 L=150000U W=800000U AS=212000000000P
+ AD=212000000000P PS=2130000U PD=2130000U
* device instance $783 r0 *1 38.3,-6.615 pfet_01v8
M$783 31 77 152 31 pfet_01v8 L=150000U W=1350000U AS=357750000000P
+ AD=357750000000P PS=3230000U PD=3230000U
* device instance $784 r0 *1 38.3,-8.235 pfet_01v8
M$784 153 77 31 31 pfet_01v8 L=150000U W=1350000U AS=357750000000P
+ AD=357750000000P PS=3230000U PD=3230000U
* device instance $785 r0 *1 38.3,-9.58 pfet_01v8
M$785 153 77 152 31 pfet_01v8 L=150000U W=800000U AS=212000000000P
+ AD=212000000000P PS=2130000U PD=2130000U
* device instance $786 m90 *1 37.1,-6.615 pfet_01v8
M$786 31 77 151 31 pfet_01v8 L=150000U W=1350000U AS=357750000000P
+ AD=357750000000P PS=3230000U PD=3230000U
* device instance $787 m90 *1 37.1,-8.235 pfet_01v8
M$787 150 77 31 31 pfet_01v8 L=150000U W=1350000U AS=357750000000P
+ AD=357750000000P PS=3230000U PD=3230000U
* device instance $788 m90 *1 37.1,-9.58 pfet_01v8
M$788 150 77 151 31 pfet_01v8 L=150000U W=800000U AS=212000000000P
+ AD=212000000000P PS=2130000U PD=2130000U
* device instance $789 m90 *1 39.5,-6.615 pfet_01v8
M$789 31 77 155 31 pfet_01v8 L=150000U W=1350000U AS=357750000000P
+ AD=357750000000P PS=3230000U PD=3230000U
* device instance $790 m90 *1 39.5,-8.235 pfet_01v8
M$790 154 77 31 31 pfet_01v8 L=150000U W=1350000U AS=357750000000P
+ AD=357750000000P PS=3230000U PD=3230000U
* device instance $791 m90 *1 39.5,-9.58 pfet_01v8
M$791 154 77 155 31 pfet_01v8 L=150000U W=800000U AS=212000000000P
+ AD=212000000000P PS=2130000U PD=2130000U
* device instance $792 r0 *1 40.7,-6.615 pfet_01v8
M$792 31 77 156 31 pfet_01v8 L=150000U W=1350000U AS=357750000000P
+ AD=357750000000P PS=3230000U PD=3230000U
* device instance $793 r0 *1 40.7,-8.235 pfet_01v8
M$793 157 77 31 31 pfet_01v8 L=150000U W=1350000U AS=357750000000P
+ AD=357750000000P PS=3230000U PD=3230000U
* device instance $794 r0 *1 40.7,-9.58 pfet_01v8
M$794 157 77 156 31 pfet_01v8 L=150000U W=800000U AS=212000000000P
+ AD=212000000000P PS=2130000U PD=2130000U
* device instance $795 m90 *1 41.9,-6.615 pfet_01v8
M$795 31 77 159 31 pfet_01v8 L=150000U W=1350000U AS=357750000000P
+ AD=357750000000P PS=3230000U PD=3230000U
* device instance $796 m90 *1 41.9,-8.235 pfet_01v8
M$796 158 77 31 31 pfet_01v8 L=150000U W=1350000U AS=357750000000P
+ AD=357750000000P PS=3230000U PD=3230000U
* device instance $797 m90 *1 41.9,-9.58 pfet_01v8
M$797 158 77 159 31 pfet_01v8 L=150000U W=800000U AS=212000000000P
+ AD=212000000000P PS=2130000U PD=2130000U
* device instance $798 r0 *1 43.1,-6.615 pfet_01v8
M$798 31 77 160 31 pfet_01v8 L=150000U W=1350000U AS=357750000000P
+ AD=357750000000P PS=3230000U PD=3230000U
* device instance $799 r0 *1 43.1,-8.235 pfet_01v8
M$799 161 77 31 31 pfet_01v8 L=150000U W=1350000U AS=357750000000P
+ AD=357750000000P PS=3230000U PD=3230000U
* device instance $800 r0 *1 43.1,-9.58 pfet_01v8
M$800 161 77 160 31 pfet_01v8 L=150000U W=800000U AS=212000000000P
+ AD=212000000000P PS=2130000U PD=2130000U
* device instance $801 m90 *1 44.3,-6.615 pfet_01v8
M$801 31 77 163 31 pfet_01v8 L=150000U W=1350000U AS=357750000000P
+ AD=357750000000P PS=3230000U PD=3230000U
* device instance $802 m90 *1 44.3,-8.235 pfet_01v8
M$802 162 77 31 31 pfet_01v8 L=150000U W=1350000U AS=357750000000P
+ AD=357750000000P PS=3230000U PD=3230000U
* device instance $803 m90 *1 44.3,-9.58 pfet_01v8
M$803 162 77 163 31 pfet_01v8 L=150000U W=800000U AS=212000000000P
+ AD=212000000000P PS=2130000U PD=2130000U
* device instance $804 r0 *1 45.5,-6.615 pfet_01v8
M$804 31 77 164 31 pfet_01v8 L=150000U W=1350000U AS=357750000000P
+ AD=357750000000P PS=3230000U PD=3230000U
* device instance $805 r0 *1 45.5,-8.235 pfet_01v8
M$805 165 77 31 31 pfet_01v8 L=150000U W=1350000U AS=357750000000P
+ AD=357750000000P PS=3230000U PD=3230000U
* device instance $806 r0 *1 45.5,-9.58 pfet_01v8
M$806 165 77 164 31 pfet_01v8 L=150000U W=800000U AS=212000000000P
+ AD=212000000000P PS=2130000U PD=2130000U
* device instance $807 r0 *1 49.2,-6.615 pfet_01v8
M$807 31 77 168 31 pfet_01v8 L=150000U W=1350000U AS=357750000000P
+ AD=357750000000P PS=3230000U PD=3230000U
* device instance $808 r0 *1 49.2,-8.235 pfet_01v8
M$808 169 77 31 31 pfet_01v8 L=150000U W=1350000U AS=357750000000P
+ AD=357750000000P PS=3230000U PD=3230000U
* device instance $809 r0 *1 49.2,-9.58 pfet_01v8
M$809 169 77 168 31 pfet_01v8 L=150000U W=800000U AS=212000000000P
+ AD=212000000000P PS=2130000U PD=2130000U
* device instance $810 m90 *1 48,-6.615 pfet_01v8
M$810 31 77 167 31 pfet_01v8 L=150000U W=1350000U AS=357750000000P
+ AD=357750000000P PS=3230000U PD=3230000U
* device instance $811 m90 *1 48,-8.235 pfet_01v8
M$811 166 77 31 31 pfet_01v8 L=150000U W=1350000U AS=357750000000P
+ AD=357750000000P PS=3230000U PD=3230000U
* device instance $812 m90 *1 48,-9.58 pfet_01v8
M$812 166 77 167 31 pfet_01v8 L=150000U W=800000U AS=212000000000P
+ AD=212000000000P PS=2130000U PD=2130000U
* device instance $813 m90 *1 50.4,-6.615 pfet_01v8
M$813 31 77 171 31 pfet_01v8 L=150000U W=1350000U AS=357750000000P
+ AD=357750000000P PS=3230000U PD=3230000U
* device instance $814 m90 *1 50.4,-8.235 pfet_01v8
M$814 170 77 31 31 pfet_01v8 L=150000U W=1350000U AS=357750000000P
+ AD=357750000000P PS=3230000U PD=3230000U
* device instance $815 m90 *1 50.4,-9.58 pfet_01v8
M$815 170 77 171 31 pfet_01v8 L=150000U W=800000U AS=212000000000P
+ AD=212000000000P PS=2130000U PD=2130000U
* device instance $816 r0 *1 51.6,-6.615 pfet_01v8
M$816 31 77 172 31 pfet_01v8 L=150000U W=1350000U AS=357750000000P
+ AD=357750000000P PS=3230000U PD=3230000U
* device instance $817 r0 *1 51.6,-8.235 pfet_01v8
M$817 173 77 31 31 pfet_01v8 L=150000U W=1350000U AS=357750000000P
+ AD=357750000000P PS=3230000U PD=3230000U
* device instance $818 r0 *1 51.6,-9.58 pfet_01v8
M$818 173 77 172 31 pfet_01v8 L=150000U W=800000U AS=212000000000P
+ AD=212000000000P PS=2130000U PD=2130000U
* device instance $819 m90 *1 52.8,-6.615 pfet_01v8
M$819 31 77 175 31 pfet_01v8 L=150000U W=1350000U AS=357750000000P
+ AD=357750000000P PS=3230000U PD=3230000U
* device instance $820 m90 *1 52.8,-8.235 pfet_01v8
M$820 174 77 31 31 pfet_01v8 L=150000U W=1350000U AS=357750000000P
+ AD=357750000000P PS=3230000U PD=3230000U
* device instance $821 m90 *1 52.8,-9.58 pfet_01v8
M$821 174 77 175 31 pfet_01v8 L=150000U W=800000U AS=212000000000P
+ AD=212000000000P PS=2130000U PD=2130000U
* device instance $822 r0 *1 54,-6.615 pfet_01v8
M$822 31 77 176 31 pfet_01v8 L=150000U W=1350000U AS=357750000000P
+ AD=357750000000P PS=3230000U PD=3230000U
* device instance $823 r0 *1 54,-8.235 pfet_01v8
M$823 177 77 31 31 pfet_01v8 L=150000U W=1350000U AS=357750000000P
+ AD=357750000000P PS=3230000U PD=3230000U
* device instance $824 r0 *1 54,-9.58 pfet_01v8
M$824 177 77 176 31 pfet_01v8 L=150000U W=800000U AS=212000000000P
+ AD=212000000000P PS=2130000U PD=2130000U
* device instance $825 m90 *1 55.2,-6.615 pfet_01v8
M$825 31 77 179 31 pfet_01v8 L=150000U W=1350000U AS=357750000000P
+ AD=357750000000P PS=3230000U PD=3230000U
* device instance $826 m90 *1 55.2,-8.235 pfet_01v8
M$826 178 77 31 31 pfet_01v8 L=150000U W=1350000U AS=357750000000P
+ AD=357750000000P PS=3230000U PD=3230000U
* device instance $827 m90 *1 55.2,-9.58 pfet_01v8
M$827 178 77 179 31 pfet_01v8 L=150000U W=800000U AS=212000000000P
+ AD=212000000000P PS=2130000U PD=2130000U
* device instance $828 r0 *1 56.4,-6.615 pfet_01v8
M$828 31 77 180 31 pfet_01v8 L=150000U W=1350000U AS=357750000000P
+ AD=357750000000P PS=3230000U PD=3230000U
* device instance $829 r0 *1 56.4,-8.235 pfet_01v8
M$829 181 77 31 31 pfet_01v8 L=150000U W=1350000U AS=357750000000P
+ AD=357750000000P PS=3230000U PD=3230000U
* device instance $830 r0 *1 56.4,-9.58 pfet_01v8
M$830 181 77 180 31 pfet_01v8 L=150000U W=800000U AS=212000000000P
+ AD=212000000000P PS=2130000U PD=2130000U
* device instance $831 r0 *1 60.1,-6.615 pfet_01v8
M$831 31 77 184 31 pfet_01v8 L=150000U W=1350000U AS=357750000000P
+ AD=357750000000P PS=3230000U PD=3230000U
* device instance $832 r0 *1 60.1,-8.235 pfet_01v8
M$832 185 77 31 31 pfet_01v8 L=150000U W=1350000U AS=357750000000P
+ AD=357750000000P PS=3230000U PD=3230000U
* device instance $833 r0 *1 60.1,-9.58 pfet_01v8
M$833 185 77 184 31 pfet_01v8 L=150000U W=800000U AS=212000000000P
+ AD=212000000000P PS=2130000U PD=2130000U
* device instance $834 m90 *1 58.9,-6.615 pfet_01v8
M$834 31 77 183 31 pfet_01v8 L=150000U W=1350000U AS=357750000000P
+ AD=357750000000P PS=3230000U PD=3230000U
* device instance $835 m90 *1 58.9,-8.235 pfet_01v8
M$835 182 77 31 31 pfet_01v8 L=150000U W=1350000U AS=357750000000P
+ AD=357750000000P PS=3230000U PD=3230000U
* device instance $836 m90 *1 58.9,-9.58 pfet_01v8
M$836 182 77 183 31 pfet_01v8 L=150000U W=800000U AS=212000000000P
+ AD=212000000000P PS=2130000U PD=2130000U
* device instance $837 m90 *1 61.3,-6.615 pfet_01v8
M$837 31 77 187 31 pfet_01v8 L=150000U W=1350000U AS=357750000000P
+ AD=357750000000P PS=3230000U PD=3230000U
* device instance $838 m90 *1 61.3,-8.235 pfet_01v8
M$838 186 77 31 31 pfet_01v8 L=150000U W=1350000U AS=357750000000P
+ AD=357750000000P PS=3230000U PD=3230000U
* device instance $839 m90 *1 61.3,-9.58 pfet_01v8
M$839 186 77 187 31 pfet_01v8 L=150000U W=800000U AS=212000000000P
+ AD=212000000000P PS=2130000U PD=2130000U
* device instance $840 r0 *1 62.5,-6.615 pfet_01v8
M$840 31 77 188 31 pfet_01v8 L=150000U W=1350000U AS=357750000000P
+ AD=357750000000P PS=3230000U PD=3230000U
* device instance $841 r0 *1 62.5,-8.235 pfet_01v8
M$841 189 77 31 31 pfet_01v8 L=150000U W=1350000U AS=357750000000P
+ AD=357750000000P PS=3230000U PD=3230000U
* device instance $842 r0 *1 62.5,-9.58 pfet_01v8
M$842 189 77 188 31 pfet_01v8 L=150000U W=800000U AS=212000000000P
+ AD=212000000000P PS=2130000U PD=2130000U
* device instance $843 m90 *1 63.7,-6.615 pfet_01v8
M$843 31 77 191 31 pfet_01v8 L=150000U W=1350000U AS=357750000000P
+ AD=357750000000P PS=3230000U PD=3230000U
* device instance $844 m90 *1 63.7,-8.235 pfet_01v8
M$844 190 77 31 31 pfet_01v8 L=150000U W=1350000U AS=357750000000P
+ AD=357750000000P PS=3230000U PD=3230000U
* device instance $845 m90 *1 63.7,-9.58 pfet_01v8
M$845 190 77 191 31 pfet_01v8 L=150000U W=800000U AS=212000000000P
+ AD=212000000000P PS=2130000U PD=2130000U
* device instance $846 r0 *1 64.9,-6.615 pfet_01v8
M$846 31 77 192 31 pfet_01v8 L=150000U W=1350000U AS=357750000000P
+ AD=357750000000P PS=3230000U PD=3230000U
* device instance $847 r0 *1 64.9,-8.235 pfet_01v8
M$847 193 77 31 31 pfet_01v8 L=150000U W=1350000U AS=357750000000P
+ AD=357750000000P PS=3230000U PD=3230000U
* device instance $848 r0 *1 64.9,-9.58 pfet_01v8
M$848 193 77 192 31 pfet_01v8 L=150000U W=800000U AS=212000000000P
+ AD=212000000000P PS=2130000U PD=2130000U
* device instance $849 m90 *1 66.1,-6.615 pfet_01v8
M$849 31 77 195 31 pfet_01v8 L=150000U W=1350000U AS=357750000000P
+ AD=357750000000P PS=3230000U PD=3230000U
* device instance $850 m90 *1 66.1,-8.235 pfet_01v8
M$850 194 77 31 31 pfet_01v8 L=150000U W=1350000U AS=357750000000P
+ AD=357750000000P PS=3230000U PD=3230000U
* device instance $851 m90 *1 66.1,-9.58 pfet_01v8
M$851 194 77 195 31 pfet_01v8 L=150000U W=800000U AS=212000000000P
+ AD=212000000000P PS=2130000U PD=2130000U
* device instance $852 r0 *1 67.3,-6.615 pfet_01v8
M$852 31 77 196 31 pfet_01v8 L=150000U W=1350000U AS=357750000000P
+ AD=357750000000P PS=3230000U PD=3230000U
* device instance $853 r0 *1 67.3,-8.235 pfet_01v8
M$853 197 77 31 31 pfet_01v8 L=150000U W=1350000U AS=357750000000P
+ AD=357750000000P PS=3230000U PD=3230000U
* device instance $854 r0 *1 67.3,-9.58 pfet_01v8
M$854 197 77 196 31 pfet_01v8 L=150000U W=800000U AS=212000000000P
+ AD=212000000000P PS=2130000U PD=2130000U
* device instance $855 r0 *1 71,-6.615 pfet_01v8
M$855 31 77 200 31 pfet_01v8 L=150000U W=1350000U AS=357750000000P
+ AD=357750000000P PS=3230000U PD=3230000U
* device instance $856 r0 *1 71,-8.235 pfet_01v8
M$856 201 77 31 31 pfet_01v8 L=150000U W=1350000U AS=357750000000P
+ AD=357750000000P PS=3230000U PD=3230000U
* device instance $857 r0 *1 71,-9.58 pfet_01v8
M$857 201 77 200 31 pfet_01v8 L=150000U W=800000U AS=212000000000P
+ AD=212000000000P PS=2130000U PD=2130000U
* device instance $858 m90 *1 69.8,-6.615 pfet_01v8
M$858 31 77 199 31 pfet_01v8 L=150000U W=1350000U AS=357750000000P
+ AD=357750000000P PS=3230000U PD=3230000U
* device instance $859 m90 *1 69.8,-8.235 pfet_01v8
M$859 198 77 31 31 pfet_01v8 L=150000U W=1350000U AS=357750000000P
+ AD=357750000000P PS=3230000U PD=3230000U
* device instance $860 m90 *1 69.8,-9.58 pfet_01v8
M$860 198 77 199 31 pfet_01v8 L=150000U W=800000U AS=212000000000P
+ AD=212000000000P PS=2130000U PD=2130000U
* device instance $861 m90 *1 72.2,-6.615 pfet_01v8
M$861 31 77 203 31 pfet_01v8 L=150000U W=1350000U AS=357750000000P
+ AD=357750000000P PS=3230000U PD=3230000U
* device instance $862 m90 *1 72.2,-8.235 pfet_01v8
M$862 202 77 31 31 pfet_01v8 L=150000U W=1350000U AS=357750000000P
+ AD=357750000000P PS=3230000U PD=3230000U
* device instance $863 m90 *1 72.2,-9.58 pfet_01v8
M$863 202 77 203 31 pfet_01v8 L=150000U W=800000U AS=212000000000P
+ AD=212000000000P PS=2130000U PD=2130000U
* device instance $864 r0 *1 73.4,-6.615 pfet_01v8
M$864 31 77 204 31 pfet_01v8 L=150000U W=1350000U AS=357750000000P
+ AD=357750000000P PS=3230000U PD=3230000U
* device instance $865 r0 *1 73.4,-8.235 pfet_01v8
M$865 205 77 31 31 pfet_01v8 L=150000U W=1350000U AS=357750000000P
+ AD=357750000000P PS=3230000U PD=3230000U
* device instance $866 r0 *1 73.4,-9.58 pfet_01v8
M$866 205 77 204 31 pfet_01v8 L=150000U W=800000U AS=212000000000P
+ AD=212000000000P PS=2130000U PD=2130000U
* device instance $867 m90 *1 74.6,-6.615 pfet_01v8
M$867 31 77 207 31 pfet_01v8 L=150000U W=1350000U AS=357750000000P
+ AD=357750000000P PS=3230000U PD=3230000U
* device instance $868 m90 *1 74.6,-8.235 pfet_01v8
M$868 206 77 31 31 pfet_01v8 L=150000U W=1350000U AS=357750000000P
+ AD=357750000000P PS=3230000U PD=3230000U
* device instance $869 m90 *1 74.6,-9.58 pfet_01v8
M$869 206 77 207 31 pfet_01v8 L=150000U W=800000U AS=212000000000P
+ AD=212000000000P PS=2130000U PD=2130000U
* device instance $870 r0 *1 75.8,-6.615 pfet_01v8
M$870 31 77 208 31 pfet_01v8 L=150000U W=1350000U AS=357750000000P
+ AD=357750000000P PS=3230000U PD=3230000U
* device instance $871 r0 *1 75.8,-8.235 pfet_01v8
M$871 209 77 31 31 pfet_01v8 L=150000U W=1350000U AS=357750000000P
+ AD=357750000000P PS=3230000U PD=3230000U
* device instance $872 r0 *1 75.8,-9.58 pfet_01v8
M$872 209 77 208 31 pfet_01v8 L=150000U W=800000U AS=212000000000P
+ AD=212000000000P PS=2130000U PD=2130000U
* device instance $873 m90 *1 77,-6.615 pfet_01v8
M$873 31 77 211 31 pfet_01v8 L=150000U W=1350000U AS=357750000000P
+ AD=357750000000P PS=3230000U PD=3230000U
* device instance $874 m90 *1 77,-8.235 pfet_01v8
M$874 210 77 31 31 pfet_01v8 L=150000U W=1350000U AS=357750000000P
+ AD=357750000000P PS=3230000U PD=3230000U
* device instance $875 m90 *1 77,-9.58 pfet_01v8
M$875 210 77 211 31 pfet_01v8 L=150000U W=800000U AS=212000000000P
+ AD=212000000000P PS=2130000U PD=2130000U
* device instance $876 r0 *1 78.2,-6.615 pfet_01v8
M$876 31 77 212 31 pfet_01v8 L=150000U W=1350000U AS=357750000000P
+ AD=357750000000P PS=3230000U PD=3230000U
* device instance $877 r0 *1 78.2,-8.235 pfet_01v8
M$877 213 77 31 31 pfet_01v8 L=150000U W=1350000U AS=357750000000P
+ AD=357750000000P PS=3230000U PD=3230000U
* device instance $878 r0 *1 78.2,-9.58 pfet_01v8
M$878 213 77 212 31 pfet_01v8 L=150000U W=800000U AS=212000000000P
+ AD=212000000000P PS=2130000U PD=2130000U
* device instance $879 r0 *1 81.9,-6.615 pfet_01v8
M$879 31 77 216 31 pfet_01v8 L=150000U W=1350000U AS=357750000000P
+ AD=357750000000P PS=3230000U PD=3230000U
* device instance $880 r0 *1 81.9,-8.235 pfet_01v8
M$880 217 77 31 31 pfet_01v8 L=150000U W=1350000U AS=357750000000P
+ AD=357750000000P PS=3230000U PD=3230000U
* device instance $881 r0 *1 81.9,-9.58 pfet_01v8
M$881 217 77 216 31 pfet_01v8 L=150000U W=800000U AS=212000000000P
+ AD=212000000000P PS=2130000U PD=2130000U
* device instance $882 m90 *1 80.7,-6.615 pfet_01v8
M$882 31 77 215 31 pfet_01v8 L=150000U W=1350000U AS=357750000000P
+ AD=357750000000P PS=3230000U PD=3230000U
* device instance $883 m90 *1 80.7,-8.235 pfet_01v8
M$883 214 77 31 31 pfet_01v8 L=150000U W=1350000U AS=357750000000P
+ AD=357750000000P PS=3230000U PD=3230000U
* device instance $884 m90 *1 80.7,-9.58 pfet_01v8
M$884 214 77 215 31 pfet_01v8 L=150000U W=800000U AS=212000000000P
+ AD=212000000000P PS=2130000U PD=2130000U
* device instance $885 m90 *1 83.1,-6.615 pfet_01v8
M$885 31 77 219 31 pfet_01v8 L=150000U W=1350000U AS=357750000000P
+ AD=357750000000P PS=3230000U PD=3230000U
* device instance $886 m90 *1 83.1,-8.235 pfet_01v8
M$886 218 77 31 31 pfet_01v8 L=150000U W=1350000U AS=357750000000P
+ AD=357750000000P PS=3230000U PD=3230000U
* device instance $887 m90 *1 83.1,-9.58 pfet_01v8
M$887 218 77 219 31 pfet_01v8 L=150000U W=800000U AS=212000000000P
+ AD=212000000000P PS=2130000U PD=2130000U
* device instance $888 r0 *1 84.3,-6.615 pfet_01v8
M$888 31 77 220 31 pfet_01v8 L=150000U W=1350000U AS=357750000000P
+ AD=357750000000P PS=3230000U PD=3230000U
* device instance $889 r0 *1 84.3,-8.235 pfet_01v8
M$889 221 77 31 31 pfet_01v8 L=150000U W=1350000U AS=357750000000P
+ AD=357750000000P PS=3230000U PD=3230000U
* device instance $890 r0 *1 84.3,-9.58 pfet_01v8
M$890 221 77 220 31 pfet_01v8 L=150000U W=800000U AS=212000000000P
+ AD=212000000000P PS=2130000U PD=2130000U
* device instance $891 m90 *1 85.5,-6.615 pfet_01v8
M$891 31 77 223 31 pfet_01v8 L=150000U W=1350000U AS=357750000000P
+ AD=357750000000P PS=3230000U PD=3230000U
* device instance $892 m90 *1 85.5,-8.235 pfet_01v8
M$892 222 77 31 31 pfet_01v8 L=150000U W=1350000U AS=357750000000P
+ AD=357750000000P PS=3230000U PD=3230000U
* device instance $893 m90 *1 85.5,-9.58 pfet_01v8
M$893 222 77 223 31 pfet_01v8 L=150000U W=800000U AS=212000000000P
+ AD=212000000000P PS=2130000U PD=2130000U
* device instance $894 r0 *1 86.7,-6.615 pfet_01v8
M$894 31 77 224 31 pfet_01v8 L=150000U W=1350000U AS=357750000000P
+ AD=357750000000P PS=3230000U PD=3230000U
* device instance $895 r0 *1 86.7,-8.235 pfet_01v8
M$895 225 77 31 31 pfet_01v8 L=150000U W=1350000U AS=357750000000P
+ AD=357750000000P PS=3230000U PD=3230000U
* device instance $896 r0 *1 86.7,-9.58 pfet_01v8
M$896 225 77 224 31 pfet_01v8 L=150000U W=800000U AS=212000000000P
+ AD=212000000000P PS=2130000U PD=2130000U
* device instance $897 m90 *1 87.9,-6.615 pfet_01v8
M$897 31 77 227 31 pfet_01v8 L=150000U W=1350000U AS=357750000000P
+ AD=357750000000P PS=3230000U PD=3230000U
* device instance $898 m90 *1 87.9,-8.235 pfet_01v8
M$898 226 77 31 31 pfet_01v8 L=150000U W=1350000U AS=357750000000P
+ AD=357750000000P PS=3230000U PD=3230000U
* device instance $899 m90 *1 87.9,-9.58 pfet_01v8
M$899 226 77 227 31 pfet_01v8 L=150000U W=800000U AS=212000000000P
+ AD=212000000000P PS=2130000U PD=2130000U
* device instance $900 r0 *1 89.1,-6.615 pfet_01v8
M$900 31 77 228 31 pfet_01v8 L=150000U W=1350000U AS=357750000000P
+ AD=357750000000P PS=3230000U PD=3230000U
* device instance $901 r0 *1 89.1,-8.235 pfet_01v8
M$901 229 77 31 31 pfet_01v8 L=150000U W=1350000U AS=357750000000P
+ AD=357750000000P PS=3230000U PD=3230000U
* device instance $902 r0 *1 89.1,-9.58 pfet_01v8
M$902 229 77 228 31 pfet_01v8 L=150000U W=800000U AS=212000000000P
+ AD=212000000000P PS=2130000U PD=2130000U
* device instance $903 m90 *1 12.8,-26.84 pfet_01v8
M$903 322 69 117 31 pfet_01v8 L=150000U W=1900000U AS=503500000000P
+ AD=503500000000P PS=4330000U PD=4330000U
* device instance $904 m90 *1 12.8,-29.01 pfet_01v8
M$904 116 69 320 31 pfet_01v8 L=150000U W=1900000U AS=503500000000P
+ AD=503500000000P PS=4330000U PD=4330000U
* device instance $905 m90 *1 12.8,-22.96 nfet_01v8
M$905 322 68 117 253 nfet_01v8 L=150000U W=1300000U AS=344500000000P
+ AD=344500000000P PS=3130000U PD=3130000U
* device instance $906 m90 *1 12.8,-24.53 nfet_01v8
M$906 116 68 320 253 nfet_01v8 L=150000U W=1300000U AS=344500000000P
+ AD=344500000000P PS=3130000U PD=3130000U
* device instance $907 m90 *1 23.7,-26.84 pfet_01v8
M$907 323 69 133 31 pfet_01v8 L=150000U W=1900000U AS=503500000000P
+ AD=503500000000P PS=4330000U PD=4330000U
* device instance $908 m90 *1 23.7,-29.01 pfet_01v8
M$908 132 69 321 31 pfet_01v8 L=150000U W=1900000U AS=503500000000P
+ AD=503500000000P PS=4330000U PD=4330000U
* device instance $909 m90 *1 23.7,-22.96 nfet_01v8
M$909 323 68 133 253 nfet_01v8 L=150000U W=1300000U AS=344500000000P
+ AD=344500000000P PS=3130000U PD=3130000U
* device instance $910 m90 *1 23.7,-24.53 nfet_01v8
M$910 132 68 321 253 nfet_01v8 L=150000U W=1300000U AS=344500000000P
+ AD=344500000000P PS=3130000U PD=3130000U
* device instance $911 m90 *1 34.6,-26.84 pfet_01v8
M$911 317 69 149 31 pfet_01v8 L=150000U W=1900000U AS=503500000000P
+ AD=503500000000P PS=4330000U PD=4330000U
* device instance $912 m90 *1 34.6,-29.01 pfet_01v8
M$912 148 69 311 31 pfet_01v8 L=150000U W=1900000U AS=503500000000P
+ AD=503500000000P PS=4330000U PD=4330000U
* device instance $913 m90 *1 34.6,-22.96 nfet_01v8
M$913 317 68 149 253 nfet_01v8 L=150000U W=1300000U AS=344500000000P
+ AD=344500000000P PS=3130000U PD=3130000U
* device instance $914 m90 *1 34.6,-24.53 nfet_01v8
M$914 148 68 311 253 nfet_01v8 L=150000U W=1300000U AS=344500000000P
+ AD=344500000000P PS=3130000U PD=3130000U
* device instance $915 m90 *1 45.5,-26.84 pfet_01v8
M$915 314 69 165 31 pfet_01v8 L=150000U W=1900000U AS=503500000000P
+ AD=503500000000P PS=4330000U PD=4330000U
* device instance $916 m90 *1 45.5,-29.01 pfet_01v8
M$916 164 69 308 31 pfet_01v8 L=150000U W=1900000U AS=503500000000P
+ AD=503500000000P PS=4330000U PD=4330000U
* device instance $917 m90 *1 45.5,-22.96 nfet_01v8
M$917 314 68 165 253 nfet_01v8 L=150000U W=1300000U AS=344500000000P
+ AD=344500000000P PS=3130000U PD=3130000U
* device instance $918 m90 *1 45.5,-24.53 nfet_01v8
M$918 164 68 308 253 nfet_01v8 L=150000U W=1300000U AS=344500000000P
+ AD=344500000000P PS=3130000U PD=3130000U
* device instance $919 m90 *1 56.4,-26.84 pfet_01v8
M$919 319 69 181 31 pfet_01v8 L=150000U W=1900000U AS=503500000000P
+ AD=503500000000P PS=4330000U PD=4330000U
* device instance $920 m90 *1 56.4,-29.01 pfet_01v8
M$920 180 69 313 31 pfet_01v8 L=150000U W=1900000U AS=503500000000P
+ AD=503500000000P PS=4330000U PD=4330000U
* device instance $921 m90 *1 56.4,-22.96 nfet_01v8
M$921 319 68 181 253 nfet_01v8 L=150000U W=1300000U AS=344500000000P
+ AD=344500000000P PS=3130000U PD=3130000U
* device instance $922 m90 *1 56.4,-24.53 nfet_01v8
M$922 180 68 313 253 nfet_01v8 L=150000U W=1300000U AS=344500000000P
+ AD=344500000000P PS=3130000U PD=3130000U
* device instance $923 m90 *1 67.3,-26.84 pfet_01v8
M$923 315 69 197 31 pfet_01v8 L=150000U W=1900000U AS=503500000000P
+ AD=503500000000P PS=4330000U PD=4330000U
* device instance $924 m90 *1 67.3,-29.01 pfet_01v8
M$924 196 69 309 31 pfet_01v8 L=150000U W=1900000U AS=503500000000P
+ AD=503500000000P PS=4330000U PD=4330000U
* device instance $925 m90 *1 67.3,-22.96 nfet_01v8
M$925 315 68 197 253 nfet_01v8 L=150000U W=1300000U AS=344500000000P
+ AD=344500000000P PS=3130000U PD=3130000U
* device instance $926 m90 *1 67.3,-24.53 nfet_01v8
M$926 196 68 309 253 nfet_01v8 L=150000U W=1300000U AS=344500000000P
+ AD=344500000000P PS=3130000U PD=3130000U
* device instance $927 m90 *1 78.2,-26.84 pfet_01v8
M$927 316 69 213 31 pfet_01v8 L=150000U W=1900000U AS=503500000000P
+ AD=503500000000P PS=4330000U PD=4330000U
* device instance $928 m90 *1 78.2,-29.01 pfet_01v8
M$928 212 69 310 31 pfet_01v8 L=150000U W=1900000U AS=503500000000P
+ AD=503500000000P PS=4330000U PD=4330000U
* device instance $929 m90 *1 78.2,-22.96 nfet_01v8
M$929 316 68 213 253 nfet_01v8 L=150000U W=1300000U AS=344500000000P
+ AD=344500000000P PS=3130000U PD=3130000U
* device instance $930 m90 *1 78.2,-24.53 nfet_01v8
M$930 212 68 310 253 nfet_01v8 L=150000U W=1300000U AS=344500000000P
+ AD=344500000000P PS=3130000U PD=3130000U
* device instance $931 m90 *1 89.1,-26.84 pfet_01v8
M$931 318 69 229 31 pfet_01v8 L=150000U W=1900000U AS=503500000000P
+ AD=503500000000P PS=4330000U PD=4330000U
* device instance $932 m90 *1 89.1,-29.01 pfet_01v8
M$932 228 69 312 31 pfet_01v8 L=150000U W=1900000U AS=503500000000P
+ AD=503500000000P PS=4330000U PD=4330000U
* device instance $933 m90 *1 89.1,-22.96 nfet_01v8
M$933 318 68 229 253 nfet_01v8 L=150000U W=1300000U AS=344500000000P
+ AD=344500000000P PS=3130000U PD=3130000U
* device instance $934 m90 *1 89.1,-24.53 nfet_01v8
M$934 228 68 312 253 nfet_01v8 L=150000U W=1300000U AS=344500000000P
+ AD=344500000000P PS=3130000U PD=3130000U
* device instance $935 r0 *1 11.6,-26.84 pfet_01v8
M$935 322 70 114 31 pfet_01v8 L=150000U W=1900000U AS=503500000000P
+ AD=503500000000P PS=4330000U PD=4330000U
* device instance $936 r0 *1 11.6,-29.01 pfet_01v8
M$936 115 70 320 31 pfet_01v8 L=150000U W=1900000U AS=503500000000P
+ AD=503500000000P PS=4330000U PD=4330000U
* device instance $937 r0 *1 11.6,-22.96 nfet_01v8
M$937 322 71 114 253 nfet_01v8 L=150000U W=1300000U AS=344500000000P
+ AD=344500000000P PS=3130000U PD=3130000U
* device instance $938 r0 *1 11.6,-24.53 nfet_01v8
M$938 115 71 320 253 nfet_01v8 L=150000U W=1300000U AS=344500000000P
+ AD=344500000000P PS=3130000U PD=3130000U
* device instance $939 r0 *1 22.5,-26.84 pfet_01v8
M$939 323 70 130 31 pfet_01v8 L=150000U W=1900000U AS=503500000000P
+ AD=503500000000P PS=4330000U PD=4330000U
* device instance $940 r0 *1 22.5,-29.01 pfet_01v8
M$940 131 70 321 31 pfet_01v8 L=150000U W=1900000U AS=503500000000P
+ AD=503500000000P PS=4330000U PD=4330000U
* device instance $941 r0 *1 22.5,-22.96 nfet_01v8
M$941 323 71 130 253 nfet_01v8 L=150000U W=1300000U AS=344500000000P
+ AD=344500000000P PS=3130000U PD=3130000U
* device instance $942 r0 *1 22.5,-24.53 nfet_01v8
M$942 131 71 321 253 nfet_01v8 L=150000U W=1300000U AS=344500000000P
+ AD=344500000000P PS=3130000U PD=3130000U
* device instance $943 r0 *1 33.4,-26.84 pfet_01v8
M$943 317 70 146 31 pfet_01v8 L=150000U W=1900000U AS=503500000000P
+ AD=503500000000P PS=4330000U PD=4330000U
* device instance $944 r0 *1 33.4,-29.01 pfet_01v8
M$944 147 70 311 31 pfet_01v8 L=150000U W=1900000U AS=503500000000P
+ AD=503500000000P PS=4330000U PD=4330000U
* device instance $945 r0 *1 33.4,-22.96 nfet_01v8
M$945 317 71 146 253 nfet_01v8 L=150000U W=1300000U AS=344500000000P
+ AD=344500000000P PS=3130000U PD=3130000U
* device instance $946 r0 *1 33.4,-24.53 nfet_01v8
M$946 147 71 311 253 nfet_01v8 L=150000U W=1300000U AS=344500000000P
+ AD=344500000000P PS=3130000U PD=3130000U
* device instance $947 r0 *1 44.3,-26.84 pfet_01v8
M$947 314 70 162 31 pfet_01v8 L=150000U W=1900000U AS=503500000000P
+ AD=503500000000P PS=4330000U PD=4330000U
* device instance $948 r0 *1 44.3,-29.01 pfet_01v8
M$948 163 70 308 31 pfet_01v8 L=150000U W=1900000U AS=503500000000P
+ AD=503500000000P PS=4330000U PD=4330000U
* device instance $949 r0 *1 44.3,-22.96 nfet_01v8
M$949 314 71 162 253 nfet_01v8 L=150000U W=1300000U AS=344500000000P
+ AD=344500000000P PS=3130000U PD=3130000U
* device instance $950 r0 *1 44.3,-24.53 nfet_01v8
M$950 163 71 308 253 nfet_01v8 L=150000U W=1300000U AS=344500000000P
+ AD=344500000000P PS=3130000U PD=3130000U
* device instance $951 r0 *1 55.2,-26.84 pfet_01v8
M$951 319 70 178 31 pfet_01v8 L=150000U W=1900000U AS=503500000000P
+ AD=503500000000P PS=4330000U PD=4330000U
* device instance $952 r0 *1 55.2,-29.01 pfet_01v8
M$952 179 70 313 31 pfet_01v8 L=150000U W=1900000U AS=503500000000P
+ AD=503500000000P PS=4330000U PD=4330000U
* device instance $953 r0 *1 55.2,-22.96 nfet_01v8
M$953 319 71 178 253 nfet_01v8 L=150000U W=1300000U AS=344500000000P
+ AD=344500000000P PS=3130000U PD=3130000U
* device instance $954 r0 *1 55.2,-24.53 nfet_01v8
M$954 179 71 313 253 nfet_01v8 L=150000U W=1300000U AS=344500000000P
+ AD=344500000000P PS=3130000U PD=3130000U
* device instance $955 r0 *1 66.1,-26.84 pfet_01v8
M$955 315 70 194 31 pfet_01v8 L=150000U W=1900000U AS=503500000000P
+ AD=503500000000P PS=4330000U PD=4330000U
* device instance $956 r0 *1 66.1,-29.01 pfet_01v8
M$956 195 70 309 31 pfet_01v8 L=150000U W=1900000U AS=503500000000P
+ AD=503500000000P PS=4330000U PD=4330000U
* device instance $957 r0 *1 66.1,-22.96 nfet_01v8
M$957 315 71 194 253 nfet_01v8 L=150000U W=1300000U AS=344500000000P
+ AD=344500000000P PS=3130000U PD=3130000U
* device instance $958 r0 *1 66.1,-24.53 nfet_01v8
M$958 195 71 309 253 nfet_01v8 L=150000U W=1300000U AS=344500000000P
+ AD=344500000000P PS=3130000U PD=3130000U
* device instance $959 r0 *1 77,-26.84 pfet_01v8
M$959 316 70 210 31 pfet_01v8 L=150000U W=1900000U AS=503500000000P
+ AD=503500000000P PS=4330000U PD=4330000U
* device instance $960 r0 *1 77,-29.01 pfet_01v8
M$960 211 70 310 31 pfet_01v8 L=150000U W=1900000U AS=503500000000P
+ AD=503500000000P PS=4330000U PD=4330000U
* device instance $961 r0 *1 77,-22.96 nfet_01v8
M$961 316 71 210 253 nfet_01v8 L=150000U W=1300000U AS=344500000000P
+ AD=344500000000P PS=3130000U PD=3130000U
* device instance $962 r0 *1 77,-24.53 nfet_01v8
M$962 211 71 310 253 nfet_01v8 L=150000U W=1300000U AS=344500000000P
+ AD=344500000000P PS=3130000U PD=3130000U
* device instance $963 r0 *1 87.9,-26.84 pfet_01v8
M$963 318 70 226 31 pfet_01v8 L=150000U W=1900000U AS=503500000000P
+ AD=503500000000P PS=4330000U PD=4330000U
* device instance $964 r0 *1 87.9,-29.01 pfet_01v8
M$964 227 70 312 31 pfet_01v8 L=150000U W=1900000U AS=503500000000P
+ AD=503500000000P PS=4330000U PD=4330000U
* device instance $965 r0 *1 87.9,-22.96 nfet_01v8
M$965 318 71 226 253 nfet_01v8 L=150000U W=1300000U AS=344500000000P
+ AD=344500000000P PS=3130000U PD=3130000U
* device instance $966 r0 *1 87.9,-24.53 nfet_01v8
M$966 227 71 312 253 nfet_01v8 L=150000U W=1300000U AS=344500000000P
+ AD=344500000000P PS=3130000U PD=3130000U
* device instance $967 m90 *1 10.4,-26.84 pfet_01v8
M$967 322 72 113 31 pfet_01v8 L=150000U W=1900000U AS=503500000000P
+ AD=503500000000P PS=4330000U PD=4330000U
* device instance $968 m90 *1 10.4,-29.01 pfet_01v8
M$968 112 72 320 31 pfet_01v8 L=150000U W=1900000U AS=503500000000P
+ AD=503500000000P PS=4330000U PD=4330000U
* device instance $969 m90 *1 10.4,-22.96 nfet_01v8
M$969 322 74 113 253 nfet_01v8 L=150000U W=1300000U AS=344500000000P
+ AD=344500000000P PS=3130000U PD=3130000U
* device instance $970 m90 *1 10.4,-24.53 nfet_01v8
M$970 112 74 320 253 nfet_01v8 L=150000U W=1300000U AS=344500000000P
+ AD=344500000000P PS=3130000U PD=3130000U
* device instance $971 m90 *1 21.3,-26.84 pfet_01v8
M$971 323 72 129 31 pfet_01v8 L=150000U W=1900000U AS=503500000000P
+ AD=503500000000P PS=4330000U PD=4330000U
* device instance $972 m90 *1 21.3,-29.01 pfet_01v8
M$972 128 72 321 31 pfet_01v8 L=150000U W=1900000U AS=503500000000P
+ AD=503500000000P PS=4330000U PD=4330000U
* device instance $973 m90 *1 21.3,-22.96 nfet_01v8
M$973 323 74 129 253 nfet_01v8 L=150000U W=1300000U AS=344500000000P
+ AD=344500000000P PS=3130000U PD=3130000U
* device instance $974 m90 *1 21.3,-24.53 nfet_01v8
M$974 128 74 321 253 nfet_01v8 L=150000U W=1300000U AS=344500000000P
+ AD=344500000000P PS=3130000U PD=3130000U
* device instance $975 m90 *1 32.2,-26.84 pfet_01v8
M$975 317 72 145 31 pfet_01v8 L=150000U W=1900000U AS=503500000000P
+ AD=503500000000P PS=4330000U PD=4330000U
* device instance $976 m90 *1 32.2,-29.01 pfet_01v8
M$976 144 72 311 31 pfet_01v8 L=150000U W=1900000U AS=503500000000P
+ AD=503500000000P PS=4330000U PD=4330000U
* device instance $977 m90 *1 32.2,-22.96 nfet_01v8
M$977 317 74 145 253 nfet_01v8 L=150000U W=1300000U AS=344500000000P
+ AD=344500000000P PS=3130000U PD=3130000U
* device instance $978 m90 *1 32.2,-24.53 nfet_01v8
M$978 144 74 311 253 nfet_01v8 L=150000U W=1300000U AS=344500000000P
+ AD=344500000000P PS=3130000U PD=3130000U
* device instance $979 m90 *1 43.1,-26.84 pfet_01v8
M$979 314 72 161 31 pfet_01v8 L=150000U W=1900000U AS=503500000000P
+ AD=503500000000P PS=4330000U PD=4330000U
* device instance $980 m90 *1 43.1,-29.01 pfet_01v8
M$980 160 72 308 31 pfet_01v8 L=150000U W=1900000U AS=503500000000P
+ AD=503500000000P PS=4330000U PD=4330000U
* device instance $981 m90 *1 43.1,-22.96 nfet_01v8
M$981 314 74 161 253 nfet_01v8 L=150000U W=1300000U AS=344500000000P
+ AD=344500000000P PS=3130000U PD=3130000U
* device instance $982 m90 *1 43.1,-24.53 nfet_01v8
M$982 160 74 308 253 nfet_01v8 L=150000U W=1300000U AS=344500000000P
+ AD=344500000000P PS=3130000U PD=3130000U
* device instance $983 m90 *1 54,-26.84 pfet_01v8
M$983 319 72 177 31 pfet_01v8 L=150000U W=1900000U AS=503500000000P
+ AD=503500000000P PS=4330000U PD=4330000U
* device instance $984 m90 *1 54,-29.01 pfet_01v8
M$984 176 72 313 31 pfet_01v8 L=150000U W=1900000U AS=503500000000P
+ AD=503500000000P PS=4330000U PD=4330000U
* device instance $985 m90 *1 54,-22.96 nfet_01v8
M$985 319 74 177 253 nfet_01v8 L=150000U W=1300000U AS=344500000000P
+ AD=344500000000P PS=3130000U PD=3130000U
* device instance $986 m90 *1 54,-24.53 nfet_01v8
M$986 176 74 313 253 nfet_01v8 L=150000U W=1300000U AS=344500000000P
+ AD=344500000000P PS=3130000U PD=3130000U
* device instance $987 m90 *1 64.9,-26.84 pfet_01v8
M$987 315 72 193 31 pfet_01v8 L=150000U W=1900000U AS=503500000000P
+ AD=503500000000P PS=4330000U PD=4330000U
* device instance $988 m90 *1 64.9,-29.01 pfet_01v8
M$988 192 72 309 31 pfet_01v8 L=150000U W=1900000U AS=503500000000P
+ AD=503500000000P PS=4330000U PD=4330000U
* device instance $989 m90 *1 64.9,-22.96 nfet_01v8
M$989 315 74 193 253 nfet_01v8 L=150000U W=1300000U AS=344500000000P
+ AD=344500000000P PS=3130000U PD=3130000U
* device instance $990 m90 *1 64.9,-24.53 nfet_01v8
M$990 192 74 309 253 nfet_01v8 L=150000U W=1300000U AS=344500000000P
+ AD=344500000000P PS=3130000U PD=3130000U
* device instance $991 m90 *1 75.8,-26.84 pfet_01v8
M$991 316 72 209 31 pfet_01v8 L=150000U W=1900000U AS=503500000000P
+ AD=503500000000P PS=4330000U PD=4330000U
* device instance $992 m90 *1 75.8,-29.01 pfet_01v8
M$992 208 72 310 31 pfet_01v8 L=150000U W=1900000U AS=503500000000P
+ AD=503500000000P PS=4330000U PD=4330000U
* device instance $993 m90 *1 75.8,-22.96 nfet_01v8
M$993 316 74 209 253 nfet_01v8 L=150000U W=1300000U AS=344500000000P
+ AD=344500000000P PS=3130000U PD=3130000U
* device instance $994 m90 *1 75.8,-24.53 nfet_01v8
M$994 208 74 310 253 nfet_01v8 L=150000U W=1300000U AS=344500000000P
+ AD=344500000000P PS=3130000U PD=3130000U
* device instance $995 m90 *1 86.7,-26.84 pfet_01v8
M$995 318 72 225 31 pfet_01v8 L=150000U W=1900000U AS=503500000000P
+ AD=503500000000P PS=4330000U PD=4330000U
* device instance $996 m90 *1 86.7,-29.01 pfet_01v8
M$996 224 72 312 31 pfet_01v8 L=150000U W=1900000U AS=503500000000P
+ AD=503500000000P PS=4330000U PD=4330000U
* device instance $997 m90 *1 86.7,-22.96 nfet_01v8
M$997 318 74 225 253 nfet_01v8 L=150000U W=1300000U AS=344500000000P
+ AD=344500000000P PS=3130000U PD=3130000U
* device instance $998 m90 *1 86.7,-24.53 nfet_01v8
M$998 224 74 312 253 nfet_01v8 L=150000U W=1300000U AS=344500000000P
+ AD=344500000000P PS=3130000U PD=3130000U
* device instance $999 r0 *1 9.2,-26.84 pfet_01v8
M$999 322 75 110 31 pfet_01v8 L=150000U W=1900000U AS=503500000000P
+ AD=503500000000P PS=4330000U PD=4330000U
* device instance $1000 r0 *1 9.2,-29.01 pfet_01v8
M$1000 111 75 320 31 pfet_01v8 L=150000U W=1900000U AS=503500000000P
+ AD=503500000000P PS=4330000U PD=4330000U
* device instance $1001 r0 *1 9.2,-22.96 nfet_01v8
M$1001 322 73 110 253 nfet_01v8 L=150000U W=1300000U AS=344500000000P
+ AD=344500000000P PS=3130000U PD=3130000U
* device instance $1002 r0 *1 9.2,-24.53 nfet_01v8
M$1002 111 73 320 253 nfet_01v8 L=150000U W=1300000U AS=344500000000P
+ AD=344500000000P PS=3130000U PD=3130000U
* device instance $1003 r0 *1 20.1,-26.84 pfet_01v8
M$1003 323 75 126 31 pfet_01v8 L=150000U W=1900000U AS=503500000000P
+ AD=503500000000P PS=4330000U PD=4330000U
* device instance $1004 r0 *1 20.1,-29.01 pfet_01v8
M$1004 127 75 321 31 pfet_01v8 L=150000U W=1900000U AS=503500000000P
+ AD=503500000000P PS=4330000U PD=4330000U
* device instance $1005 r0 *1 20.1,-22.96 nfet_01v8
M$1005 323 73 126 253 nfet_01v8 L=150000U W=1300000U AS=344500000000P
+ AD=344500000000P PS=3130000U PD=3130000U
* device instance $1006 r0 *1 20.1,-24.53 nfet_01v8
M$1006 127 73 321 253 nfet_01v8 L=150000U W=1300000U AS=344500000000P
+ AD=344500000000P PS=3130000U PD=3130000U
* device instance $1007 r0 *1 31,-26.84 pfet_01v8
M$1007 317 75 142 31 pfet_01v8 L=150000U W=1900000U AS=503500000000P
+ AD=503500000000P PS=4330000U PD=4330000U
* device instance $1008 r0 *1 31,-29.01 pfet_01v8
M$1008 143 75 311 31 pfet_01v8 L=150000U W=1900000U AS=503500000000P
+ AD=503500000000P PS=4330000U PD=4330000U
* device instance $1009 r0 *1 31,-22.96 nfet_01v8
M$1009 317 73 142 253 nfet_01v8 L=150000U W=1300000U AS=344500000000P
+ AD=344500000000P PS=3130000U PD=3130000U
* device instance $1010 r0 *1 31,-24.53 nfet_01v8
M$1010 143 73 311 253 nfet_01v8 L=150000U W=1300000U AS=344500000000P
+ AD=344500000000P PS=3130000U PD=3130000U
* device instance $1011 r0 *1 41.9,-26.84 pfet_01v8
M$1011 314 75 158 31 pfet_01v8 L=150000U W=1900000U AS=503500000000P
+ AD=503500000000P PS=4330000U PD=4330000U
* device instance $1012 r0 *1 41.9,-29.01 pfet_01v8
M$1012 159 75 308 31 pfet_01v8 L=150000U W=1900000U AS=503500000000P
+ AD=503500000000P PS=4330000U PD=4330000U
* device instance $1013 r0 *1 41.9,-22.96 nfet_01v8
M$1013 314 73 158 253 nfet_01v8 L=150000U W=1300000U AS=344500000000P
+ AD=344500000000P PS=3130000U PD=3130000U
* device instance $1014 r0 *1 41.9,-24.53 nfet_01v8
M$1014 159 73 308 253 nfet_01v8 L=150000U W=1300000U AS=344500000000P
+ AD=344500000000P PS=3130000U PD=3130000U
* device instance $1015 r0 *1 52.8,-26.84 pfet_01v8
M$1015 319 75 174 31 pfet_01v8 L=150000U W=1900000U AS=503500000000P
+ AD=503500000000P PS=4330000U PD=4330000U
* device instance $1016 r0 *1 52.8,-29.01 pfet_01v8
M$1016 175 75 313 31 pfet_01v8 L=150000U W=1900000U AS=503500000000P
+ AD=503500000000P PS=4330000U PD=4330000U
* device instance $1017 r0 *1 52.8,-22.96 nfet_01v8
M$1017 319 73 174 253 nfet_01v8 L=150000U W=1300000U AS=344500000000P
+ AD=344500000000P PS=3130000U PD=3130000U
* device instance $1018 r0 *1 52.8,-24.53 nfet_01v8
M$1018 175 73 313 253 nfet_01v8 L=150000U W=1300000U AS=344500000000P
+ AD=344500000000P PS=3130000U PD=3130000U
* device instance $1019 r0 *1 63.7,-26.84 pfet_01v8
M$1019 315 75 190 31 pfet_01v8 L=150000U W=1900000U AS=503500000000P
+ AD=503500000000P PS=4330000U PD=4330000U
* device instance $1020 r0 *1 63.7,-29.01 pfet_01v8
M$1020 191 75 309 31 pfet_01v8 L=150000U W=1900000U AS=503500000000P
+ AD=503500000000P PS=4330000U PD=4330000U
* device instance $1021 r0 *1 63.7,-22.96 nfet_01v8
M$1021 315 73 190 253 nfet_01v8 L=150000U W=1300000U AS=344500000000P
+ AD=344500000000P PS=3130000U PD=3130000U
* device instance $1022 r0 *1 63.7,-24.53 nfet_01v8
M$1022 191 73 309 253 nfet_01v8 L=150000U W=1300000U AS=344500000000P
+ AD=344500000000P PS=3130000U PD=3130000U
* device instance $1023 r0 *1 74.6,-26.84 pfet_01v8
M$1023 316 75 206 31 pfet_01v8 L=150000U W=1900000U AS=503500000000P
+ AD=503500000000P PS=4330000U PD=4330000U
* device instance $1024 r0 *1 74.6,-29.01 pfet_01v8
M$1024 207 75 310 31 pfet_01v8 L=150000U W=1900000U AS=503500000000P
+ AD=503500000000P PS=4330000U PD=4330000U
* device instance $1025 r0 *1 74.6,-22.96 nfet_01v8
M$1025 316 73 206 253 nfet_01v8 L=150000U W=1300000U AS=344500000000P
+ AD=344500000000P PS=3130000U PD=3130000U
* device instance $1026 r0 *1 74.6,-24.53 nfet_01v8
M$1026 207 73 310 253 nfet_01v8 L=150000U W=1300000U AS=344500000000P
+ AD=344500000000P PS=3130000U PD=3130000U
* device instance $1027 r0 *1 85.5,-26.84 pfet_01v8
M$1027 318 75 222 31 pfet_01v8 L=150000U W=1900000U AS=503500000000P
+ AD=503500000000P PS=4330000U PD=4330000U
* device instance $1028 r0 *1 85.5,-29.01 pfet_01v8
M$1028 223 75 312 31 pfet_01v8 L=150000U W=1900000U AS=503500000000P
+ AD=503500000000P PS=4330000U PD=4330000U
* device instance $1029 r0 *1 85.5,-22.96 nfet_01v8
M$1029 318 73 222 253 nfet_01v8 L=150000U W=1300000U AS=344500000000P
+ AD=344500000000P PS=3130000U PD=3130000U
* device instance $1030 r0 *1 85.5,-24.53 nfet_01v8
M$1030 223 73 312 253 nfet_01v8 L=150000U W=1300000U AS=344500000000P
+ AD=344500000000P PS=3130000U PD=3130000U
* device instance $1031 m90 *1 8,-26.84 pfet_01v8
M$1031 322 59 109 31 pfet_01v8 L=150000U W=1900000U AS=503500000000P
+ AD=503500000000P PS=4330000U PD=4330000U
* device instance $1032 m90 *1 8,-29.01 pfet_01v8
M$1032 108 59 320 31 pfet_01v8 L=150000U W=1900000U AS=503500000000P
+ AD=503500000000P PS=4330000U PD=4330000U
* device instance $1033 m90 *1 8,-22.96 nfet_01v8
M$1033 322 58 109 253 nfet_01v8 L=150000U W=1300000U AS=344500000000P
+ AD=344500000000P PS=3130000U PD=3130000U
* device instance $1034 m90 *1 8,-24.53 nfet_01v8
M$1034 108 58 320 253 nfet_01v8 L=150000U W=1300000U AS=344500000000P
+ AD=344500000000P PS=3130000U PD=3130000U
* device instance $1035 m90 *1 18.9,-26.84 pfet_01v8
M$1035 323 59 125 31 pfet_01v8 L=150000U W=1900000U AS=503500000000P
+ AD=503500000000P PS=4330000U PD=4330000U
* device instance $1036 m90 *1 18.9,-29.01 pfet_01v8
M$1036 124 59 321 31 pfet_01v8 L=150000U W=1900000U AS=503500000000P
+ AD=503500000000P PS=4330000U PD=4330000U
* device instance $1037 m90 *1 18.9,-22.96 nfet_01v8
M$1037 323 58 125 253 nfet_01v8 L=150000U W=1300000U AS=344500000000P
+ AD=344500000000P PS=3130000U PD=3130000U
* device instance $1038 m90 *1 18.9,-24.53 nfet_01v8
M$1038 124 58 321 253 nfet_01v8 L=150000U W=1300000U AS=344500000000P
+ AD=344500000000P PS=3130000U PD=3130000U
* device instance $1039 m90 *1 29.8,-26.84 pfet_01v8
M$1039 317 59 141 31 pfet_01v8 L=150000U W=1900000U AS=503500000000P
+ AD=503500000000P PS=4330000U PD=4330000U
* device instance $1040 m90 *1 29.8,-29.01 pfet_01v8
M$1040 140 59 311 31 pfet_01v8 L=150000U W=1900000U AS=503500000000P
+ AD=503500000000P PS=4330000U PD=4330000U
* device instance $1041 m90 *1 29.8,-22.96 nfet_01v8
M$1041 317 58 141 253 nfet_01v8 L=150000U W=1300000U AS=344500000000P
+ AD=344500000000P PS=3130000U PD=3130000U
* device instance $1042 m90 *1 29.8,-24.53 nfet_01v8
M$1042 140 58 311 253 nfet_01v8 L=150000U W=1300000U AS=344500000000P
+ AD=344500000000P PS=3130000U PD=3130000U
* device instance $1043 m90 *1 40.7,-26.84 pfet_01v8
M$1043 314 59 157 31 pfet_01v8 L=150000U W=1900000U AS=503500000000P
+ AD=503500000000P PS=4330000U PD=4330000U
* device instance $1044 m90 *1 40.7,-29.01 pfet_01v8
M$1044 156 59 308 31 pfet_01v8 L=150000U W=1900000U AS=503500000000P
+ AD=503500000000P PS=4330000U PD=4330000U
* device instance $1045 m90 *1 40.7,-22.96 nfet_01v8
M$1045 314 58 157 253 nfet_01v8 L=150000U W=1300000U AS=344500000000P
+ AD=344500000000P PS=3130000U PD=3130000U
* device instance $1046 m90 *1 40.7,-24.53 nfet_01v8
M$1046 156 58 308 253 nfet_01v8 L=150000U W=1300000U AS=344500000000P
+ AD=344500000000P PS=3130000U PD=3130000U
* device instance $1047 m90 *1 51.6,-26.84 pfet_01v8
M$1047 319 59 173 31 pfet_01v8 L=150000U W=1900000U AS=503500000000P
+ AD=503500000000P PS=4330000U PD=4330000U
* device instance $1048 m90 *1 51.6,-29.01 pfet_01v8
M$1048 172 59 313 31 pfet_01v8 L=150000U W=1900000U AS=503500000000P
+ AD=503500000000P PS=4330000U PD=4330000U
* device instance $1049 m90 *1 51.6,-22.96 nfet_01v8
M$1049 319 58 173 253 nfet_01v8 L=150000U W=1300000U AS=344500000000P
+ AD=344500000000P PS=3130000U PD=3130000U
* device instance $1050 m90 *1 51.6,-24.53 nfet_01v8
M$1050 172 58 313 253 nfet_01v8 L=150000U W=1300000U AS=344500000000P
+ AD=344500000000P PS=3130000U PD=3130000U
* device instance $1051 m90 *1 62.5,-26.84 pfet_01v8
M$1051 315 59 189 31 pfet_01v8 L=150000U W=1900000U AS=503500000000P
+ AD=503500000000P PS=4330000U PD=4330000U
* device instance $1052 m90 *1 62.5,-29.01 pfet_01v8
M$1052 188 59 309 31 pfet_01v8 L=150000U W=1900000U AS=503500000000P
+ AD=503500000000P PS=4330000U PD=4330000U
* device instance $1053 m90 *1 62.5,-22.96 nfet_01v8
M$1053 315 58 189 253 nfet_01v8 L=150000U W=1300000U AS=344500000000P
+ AD=344500000000P PS=3130000U PD=3130000U
* device instance $1054 m90 *1 62.5,-24.53 nfet_01v8
M$1054 188 58 309 253 nfet_01v8 L=150000U W=1300000U AS=344500000000P
+ AD=344500000000P PS=3130000U PD=3130000U
* device instance $1055 m90 *1 73.4,-26.84 pfet_01v8
M$1055 316 59 205 31 pfet_01v8 L=150000U W=1900000U AS=503500000000P
+ AD=503500000000P PS=4330000U PD=4330000U
* device instance $1056 m90 *1 73.4,-29.01 pfet_01v8
M$1056 204 59 310 31 pfet_01v8 L=150000U W=1900000U AS=503500000000P
+ AD=503500000000P PS=4330000U PD=4330000U
* device instance $1057 m90 *1 73.4,-22.96 nfet_01v8
M$1057 316 58 205 253 nfet_01v8 L=150000U W=1300000U AS=344500000000P
+ AD=344500000000P PS=3130000U PD=3130000U
* device instance $1058 m90 *1 73.4,-24.53 nfet_01v8
M$1058 204 58 310 253 nfet_01v8 L=150000U W=1300000U AS=344500000000P
+ AD=344500000000P PS=3130000U PD=3130000U
* device instance $1059 m90 *1 84.3,-26.84 pfet_01v8
M$1059 318 59 221 31 pfet_01v8 L=150000U W=1900000U AS=503500000000P
+ AD=503500000000P PS=4330000U PD=4330000U
* device instance $1060 m90 *1 84.3,-29.01 pfet_01v8
M$1060 220 59 312 31 pfet_01v8 L=150000U W=1900000U AS=503500000000P
+ AD=503500000000P PS=4330000U PD=4330000U
* device instance $1061 m90 *1 84.3,-22.96 nfet_01v8
M$1061 318 58 221 253 nfet_01v8 L=150000U W=1300000U AS=344500000000P
+ AD=344500000000P PS=3130000U PD=3130000U
* device instance $1062 m90 *1 84.3,-24.53 nfet_01v8
M$1062 220 58 312 253 nfet_01v8 L=150000U W=1300000U AS=344500000000P
+ AD=344500000000P PS=3130000U PD=3130000U
* device instance $1063 r0 *1 6.8,-26.84 pfet_01v8
M$1063 322 61 106 31 pfet_01v8 L=150000U W=1900000U AS=503500000000P
+ AD=503500000000P PS=4330000U PD=4330000U
* device instance $1064 r0 *1 6.8,-29.01 pfet_01v8
M$1064 107 61 320 31 pfet_01v8 L=150000U W=1900000U AS=503500000000P
+ AD=503500000000P PS=4330000U PD=4330000U
* device instance $1065 r0 *1 6.8,-22.96 nfet_01v8
M$1065 322 60 106 253 nfet_01v8 L=150000U W=1300000U AS=344500000000P
+ AD=344500000000P PS=3130000U PD=3130000U
* device instance $1066 r0 *1 6.8,-24.53 nfet_01v8
M$1066 107 60 320 253 nfet_01v8 L=150000U W=1300000U AS=344500000000P
+ AD=344500000000P PS=3130000U PD=3130000U
* device instance $1067 r0 *1 17.7,-26.84 pfet_01v8
M$1067 323 61 122 31 pfet_01v8 L=150000U W=1900000U AS=503500000000P
+ AD=503500000000P PS=4330000U PD=4330000U
* device instance $1068 r0 *1 17.7,-29.01 pfet_01v8
M$1068 123 61 321 31 pfet_01v8 L=150000U W=1900000U AS=503500000000P
+ AD=503500000000P PS=4330000U PD=4330000U
* device instance $1069 r0 *1 17.7,-22.96 nfet_01v8
M$1069 323 60 122 253 nfet_01v8 L=150000U W=1300000U AS=344500000000P
+ AD=344500000000P PS=3130000U PD=3130000U
* device instance $1070 r0 *1 17.7,-24.53 nfet_01v8
M$1070 123 60 321 253 nfet_01v8 L=150000U W=1300000U AS=344500000000P
+ AD=344500000000P PS=3130000U PD=3130000U
* device instance $1071 r0 *1 28.6,-26.84 pfet_01v8
M$1071 317 61 138 31 pfet_01v8 L=150000U W=1900000U AS=503500000000P
+ AD=503500000000P PS=4330000U PD=4330000U
* device instance $1072 r0 *1 28.6,-29.01 pfet_01v8
M$1072 139 61 311 31 pfet_01v8 L=150000U W=1900000U AS=503500000000P
+ AD=503500000000P PS=4330000U PD=4330000U
* device instance $1073 r0 *1 28.6,-22.96 nfet_01v8
M$1073 317 60 138 253 nfet_01v8 L=150000U W=1300000U AS=344500000000P
+ AD=344500000000P PS=3130000U PD=3130000U
* device instance $1074 r0 *1 28.6,-24.53 nfet_01v8
M$1074 139 60 311 253 nfet_01v8 L=150000U W=1300000U AS=344500000000P
+ AD=344500000000P PS=3130000U PD=3130000U
* device instance $1075 r0 *1 39.5,-26.84 pfet_01v8
M$1075 314 61 154 31 pfet_01v8 L=150000U W=1900000U AS=503500000000P
+ AD=503500000000P PS=4330000U PD=4330000U
* device instance $1076 r0 *1 39.5,-29.01 pfet_01v8
M$1076 155 61 308 31 pfet_01v8 L=150000U W=1900000U AS=503500000000P
+ AD=503500000000P PS=4330000U PD=4330000U
* device instance $1077 r0 *1 39.5,-22.96 nfet_01v8
M$1077 314 60 154 253 nfet_01v8 L=150000U W=1300000U AS=344500000000P
+ AD=344500000000P PS=3130000U PD=3130000U
* device instance $1078 r0 *1 39.5,-24.53 nfet_01v8
M$1078 155 60 308 253 nfet_01v8 L=150000U W=1300000U AS=344500000000P
+ AD=344500000000P PS=3130000U PD=3130000U
* device instance $1079 r0 *1 50.4,-26.84 pfet_01v8
M$1079 319 61 170 31 pfet_01v8 L=150000U W=1900000U AS=503500000000P
+ AD=503500000000P PS=4330000U PD=4330000U
* device instance $1080 r0 *1 50.4,-29.01 pfet_01v8
M$1080 171 61 313 31 pfet_01v8 L=150000U W=1900000U AS=503500000000P
+ AD=503500000000P PS=4330000U PD=4330000U
* device instance $1081 r0 *1 50.4,-22.96 nfet_01v8
M$1081 319 60 170 253 nfet_01v8 L=150000U W=1300000U AS=344500000000P
+ AD=344500000000P PS=3130000U PD=3130000U
* device instance $1082 r0 *1 50.4,-24.53 nfet_01v8
M$1082 171 60 313 253 nfet_01v8 L=150000U W=1300000U AS=344500000000P
+ AD=344500000000P PS=3130000U PD=3130000U
* device instance $1083 r0 *1 61.3,-26.84 pfet_01v8
M$1083 315 61 186 31 pfet_01v8 L=150000U W=1900000U AS=503500000000P
+ AD=503500000000P PS=4330000U PD=4330000U
* device instance $1084 r0 *1 61.3,-29.01 pfet_01v8
M$1084 187 61 309 31 pfet_01v8 L=150000U W=1900000U AS=503500000000P
+ AD=503500000000P PS=4330000U PD=4330000U
* device instance $1085 r0 *1 61.3,-22.96 nfet_01v8
M$1085 315 60 186 253 nfet_01v8 L=150000U W=1300000U AS=344500000000P
+ AD=344500000000P PS=3130000U PD=3130000U
* device instance $1086 r0 *1 61.3,-24.53 nfet_01v8
M$1086 187 60 309 253 nfet_01v8 L=150000U W=1300000U AS=344500000000P
+ AD=344500000000P PS=3130000U PD=3130000U
* device instance $1087 r0 *1 72.2,-26.84 pfet_01v8
M$1087 316 61 202 31 pfet_01v8 L=150000U W=1900000U AS=503500000000P
+ AD=503500000000P PS=4330000U PD=4330000U
* device instance $1088 r0 *1 72.2,-29.01 pfet_01v8
M$1088 203 61 310 31 pfet_01v8 L=150000U W=1900000U AS=503500000000P
+ AD=503500000000P PS=4330000U PD=4330000U
* device instance $1089 r0 *1 72.2,-22.96 nfet_01v8
M$1089 316 60 202 253 nfet_01v8 L=150000U W=1300000U AS=344500000000P
+ AD=344500000000P PS=3130000U PD=3130000U
* device instance $1090 r0 *1 72.2,-24.53 nfet_01v8
M$1090 203 60 310 253 nfet_01v8 L=150000U W=1300000U AS=344500000000P
+ AD=344500000000P PS=3130000U PD=3130000U
* device instance $1091 r0 *1 83.1,-26.84 pfet_01v8
M$1091 318 61 218 31 pfet_01v8 L=150000U W=1900000U AS=503500000000P
+ AD=503500000000P PS=4330000U PD=4330000U
* device instance $1092 r0 *1 83.1,-29.01 pfet_01v8
M$1092 219 61 312 31 pfet_01v8 L=150000U W=1900000U AS=503500000000P
+ AD=503500000000P PS=4330000U PD=4330000U
* device instance $1093 r0 *1 83.1,-22.96 nfet_01v8
M$1093 318 60 218 253 nfet_01v8 L=150000U W=1300000U AS=344500000000P
+ AD=344500000000P PS=3130000U PD=3130000U
* device instance $1094 r0 *1 83.1,-24.53 nfet_01v8
M$1094 219 60 312 253 nfet_01v8 L=150000U W=1300000U AS=344500000000P
+ AD=344500000000P PS=3130000U PD=3130000U
* device instance $1095 m90 *1 5.6,-26.84 pfet_01v8
M$1095 322 66 105 31 pfet_01v8 L=150000U W=1900000U AS=503500000000P
+ AD=503500000000P PS=4330000U PD=4330000U
* device instance $1096 m90 *1 5.6,-29.01 pfet_01v8
M$1096 104 66 320 31 pfet_01v8 L=150000U W=1900000U AS=503500000000P
+ AD=503500000000P PS=4330000U PD=4330000U
* device instance $1097 m90 *1 5.6,-22.96 nfet_01v8
M$1097 322 62 105 253 nfet_01v8 L=150000U W=1300000U AS=344500000000P
+ AD=344500000000P PS=3130000U PD=3130000U
* device instance $1098 m90 *1 5.6,-24.53 nfet_01v8
M$1098 104 62 320 253 nfet_01v8 L=150000U W=1300000U AS=344500000000P
+ AD=344500000000P PS=3130000U PD=3130000U
* device instance $1099 m90 *1 16.5,-26.84 pfet_01v8
M$1099 323 66 121 31 pfet_01v8 L=150000U W=1900000U AS=503500000000P
+ AD=503500000000P PS=4330000U PD=4330000U
* device instance $1100 m90 *1 16.5,-29.01 pfet_01v8
M$1100 120 66 321 31 pfet_01v8 L=150000U W=1900000U AS=503500000000P
+ AD=503500000000P PS=4330000U PD=4330000U
* device instance $1101 m90 *1 16.5,-22.96 nfet_01v8
M$1101 323 62 121 253 nfet_01v8 L=150000U W=1300000U AS=344500000000P
+ AD=344500000000P PS=3130000U PD=3130000U
* device instance $1102 m90 *1 16.5,-24.53 nfet_01v8
M$1102 120 62 321 253 nfet_01v8 L=150000U W=1300000U AS=344500000000P
+ AD=344500000000P PS=3130000U PD=3130000U
* device instance $1103 m90 *1 27.4,-26.84 pfet_01v8
M$1103 317 66 137 31 pfet_01v8 L=150000U W=1900000U AS=503500000000P
+ AD=503500000000P PS=4330000U PD=4330000U
* device instance $1104 m90 *1 27.4,-29.01 pfet_01v8
M$1104 136 66 311 31 pfet_01v8 L=150000U W=1900000U AS=503500000000P
+ AD=503500000000P PS=4330000U PD=4330000U
* device instance $1105 m90 *1 27.4,-22.96 nfet_01v8
M$1105 317 62 137 253 nfet_01v8 L=150000U W=1300000U AS=344500000000P
+ AD=344500000000P PS=3130000U PD=3130000U
* device instance $1106 m90 *1 27.4,-24.53 nfet_01v8
M$1106 136 62 311 253 nfet_01v8 L=150000U W=1300000U AS=344500000000P
+ AD=344500000000P PS=3130000U PD=3130000U
* device instance $1107 m90 *1 38.3,-26.84 pfet_01v8
M$1107 314 66 153 31 pfet_01v8 L=150000U W=1900000U AS=503500000000P
+ AD=503500000000P PS=4330000U PD=4330000U
* device instance $1108 m90 *1 38.3,-29.01 pfet_01v8
M$1108 152 66 308 31 pfet_01v8 L=150000U W=1900000U AS=503500000000P
+ AD=503500000000P PS=4330000U PD=4330000U
* device instance $1109 m90 *1 38.3,-22.96 nfet_01v8
M$1109 314 62 153 253 nfet_01v8 L=150000U W=1300000U AS=344500000000P
+ AD=344500000000P PS=3130000U PD=3130000U
* device instance $1110 m90 *1 38.3,-24.53 nfet_01v8
M$1110 152 62 308 253 nfet_01v8 L=150000U W=1300000U AS=344500000000P
+ AD=344500000000P PS=3130000U PD=3130000U
* device instance $1111 m90 *1 49.2,-26.84 pfet_01v8
M$1111 319 66 169 31 pfet_01v8 L=150000U W=1900000U AS=503500000000P
+ AD=503500000000P PS=4330000U PD=4330000U
* device instance $1112 m90 *1 49.2,-29.01 pfet_01v8
M$1112 168 66 313 31 pfet_01v8 L=150000U W=1900000U AS=503500000000P
+ AD=503500000000P PS=4330000U PD=4330000U
* device instance $1113 m90 *1 49.2,-22.96 nfet_01v8
M$1113 319 62 169 253 nfet_01v8 L=150000U W=1300000U AS=344500000000P
+ AD=344500000000P PS=3130000U PD=3130000U
* device instance $1114 m90 *1 49.2,-24.53 nfet_01v8
M$1114 168 62 313 253 nfet_01v8 L=150000U W=1300000U AS=344500000000P
+ AD=344500000000P PS=3130000U PD=3130000U
* device instance $1115 m90 *1 60.1,-26.84 pfet_01v8
M$1115 315 66 185 31 pfet_01v8 L=150000U W=1900000U AS=503500000000P
+ AD=503500000000P PS=4330000U PD=4330000U
* device instance $1116 m90 *1 60.1,-29.01 pfet_01v8
M$1116 184 66 309 31 pfet_01v8 L=150000U W=1900000U AS=503500000000P
+ AD=503500000000P PS=4330000U PD=4330000U
* device instance $1117 m90 *1 60.1,-22.96 nfet_01v8
M$1117 315 62 185 253 nfet_01v8 L=150000U W=1300000U AS=344500000000P
+ AD=344500000000P PS=3130000U PD=3130000U
* device instance $1118 m90 *1 60.1,-24.53 nfet_01v8
M$1118 184 62 309 253 nfet_01v8 L=150000U W=1300000U AS=344500000000P
+ AD=344500000000P PS=3130000U PD=3130000U
* device instance $1119 m90 *1 71,-26.84 pfet_01v8
M$1119 316 66 201 31 pfet_01v8 L=150000U W=1900000U AS=503500000000P
+ AD=503500000000P PS=4330000U PD=4330000U
* device instance $1120 m90 *1 71,-29.01 pfet_01v8
M$1120 200 66 310 31 pfet_01v8 L=150000U W=1900000U AS=503500000000P
+ AD=503500000000P PS=4330000U PD=4330000U
* device instance $1121 m90 *1 71,-22.96 nfet_01v8
M$1121 316 62 201 253 nfet_01v8 L=150000U W=1300000U AS=344500000000P
+ AD=344500000000P PS=3130000U PD=3130000U
* device instance $1122 m90 *1 71,-24.53 nfet_01v8
M$1122 200 62 310 253 nfet_01v8 L=150000U W=1300000U AS=344500000000P
+ AD=344500000000P PS=3130000U PD=3130000U
* device instance $1123 m90 *1 81.9,-26.84 pfet_01v8
M$1123 318 66 217 31 pfet_01v8 L=150000U W=1900000U AS=503500000000P
+ AD=503500000000P PS=4330000U PD=4330000U
* device instance $1124 m90 *1 81.9,-29.01 pfet_01v8
M$1124 216 66 312 31 pfet_01v8 L=150000U W=1900000U AS=503500000000P
+ AD=503500000000P PS=4330000U PD=4330000U
* device instance $1125 m90 *1 81.9,-22.96 nfet_01v8
M$1125 318 62 217 253 nfet_01v8 L=150000U W=1300000U AS=344500000000P
+ AD=344500000000P PS=3130000U PD=3130000U
* device instance $1126 m90 *1 81.9,-24.53 nfet_01v8
M$1126 216 62 312 253 nfet_01v8 L=150000U W=1300000U AS=344500000000P
+ AD=344500000000P PS=3130000U PD=3130000U
* device instance $1127 r0 *1 4.4,-26.84 pfet_01v8
M$1127 322 64 102 31 pfet_01v8 L=150000U W=1900000U AS=503500000000P
+ AD=503500000000P PS=4330000U PD=4330000U
* device instance $1128 r0 *1 4.4,-29.01 pfet_01v8
M$1128 103 64 320 31 pfet_01v8 L=150000U W=1900000U AS=503500000000P
+ AD=503500000000P PS=4330000U PD=4330000U
* device instance $1129 r0 *1 4.4,-22.96 nfet_01v8
M$1129 322 65 102 253 nfet_01v8 L=150000U W=1300000U AS=344500000000P
+ AD=344500000000P PS=3130000U PD=3130000U
* device instance $1130 r0 *1 4.4,-24.53 nfet_01v8
M$1130 103 65 320 253 nfet_01v8 L=150000U W=1300000U AS=344500000000P
+ AD=344500000000P PS=3130000U PD=3130000U
* device instance $1131 r0 *1 15.3,-26.84 pfet_01v8
M$1131 323 64 118 31 pfet_01v8 L=150000U W=1900000U AS=503500000000P
+ AD=503500000000P PS=4330000U PD=4330000U
* device instance $1132 r0 *1 15.3,-29.01 pfet_01v8
M$1132 119 64 321 31 pfet_01v8 L=150000U W=1900000U AS=503500000000P
+ AD=503500000000P PS=4330000U PD=4330000U
* device instance $1133 r0 *1 15.3,-22.96 nfet_01v8
M$1133 323 65 118 253 nfet_01v8 L=150000U W=1300000U AS=344500000000P
+ AD=344500000000P PS=3130000U PD=3130000U
* device instance $1134 r0 *1 15.3,-24.53 nfet_01v8
M$1134 119 65 321 253 nfet_01v8 L=150000U W=1300000U AS=344500000000P
+ AD=344500000000P PS=3130000U PD=3130000U
* device instance $1135 r0 *1 26.2,-26.84 pfet_01v8
M$1135 317 64 134 31 pfet_01v8 L=150000U W=1900000U AS=503500000000P
+ AD=503500000000P PS=4330000U PD=4330000U
* device instance $1136 r0 *1 26.2,-29.01 pfet_01v8
M$1136 135 64 311 31 pfet_01v8 L=150000U W=1900000U AS=503500000000P
+ AD=503500000000P PS=4330000U PD=4330000U
* device instance $1137 r0 *1 26.2,-22.96 nfet_01v8
M$1137 317 65 134 253 nfet_01v8 L=150000U W=1300000U AS=344500000000P
+ AD=344500000000P PS=3130000U PD=3130000U
* device instance $1138 r0 *1 26.2,-24.53 nfet_01v8
M$1138 135 65 311 253 nfet_01v8 L=150000U W=1300000U AS=344500000000P
+ AD=344500000000P PS=3130000U PD=3130000U
* device instance $1139 r0 *1 37.1,-26.84 pfet_01v8
M$1139 314 64 150 31 pfet_01v8 L=150000U W=1900000U AS=503500000000P
+ AD=503500000000P PS=4330000U PD=4330000U
* device instance $1140 r0 *1 37.1,-29.01 pfet_01v8
M$1140 151 64 308 31 pfet_01v8 L=150000U W=1900000U AS=503500000000P
+ AD=503500000000P PS=4330000U PD=4330000U
* device instance $1141 r0 *1 37.1,-22.96 nfet_01v8
M$1141 314 65 150 253 nfet_01v8 L=150000U W=1300000U AS=344500000000P
+ AD=344500000000P PS=3130000U PD=3130000U
* device instance $1142 r0 *1 37.1,-24.53 nfet_01v8
M$1142 151 65 308 253 nfet_01v8 L=150000U W=1300000U AS=344500000000P
+ AD=344500000000P PS=3130000U PD=3130000U
* device instance $1143 r0 *1 48,-26.84 pfet_01v8
M$1143 319 64 166 31 pfet_01v8 L=150000U W=1900000U AS=503500000000P
+ AD=503500000000P PS=4330000U PD=4330000U
* device instance $1144 r0 *1 48,-29.01 pfet_01v8
M$1144 167 64 313 31 pfet_01v8 L=150000U W=1900000U AS=503500000000P
+ AD=503500000000P PS=4330000U PD=4330000U
* device instance $1145 r0 *1 48,-22.96 nfet_01v8
M$1145 319 65 166 253 nfet_01v8 L=150000U W=1300000U AS=344500000000P
+ AD=344500000000P PS=3130000U PD=3130000U
* device instance $1146 r0 *1 48,-24.53 nfet_01v8
M$1146 167 65 313 253 nfet_01v8 L=150000U W=1300000U AS=344500000000P
+ AD=344500000000P PS=3130000U PD=3130000U
* device instance $1147 r0 *1 58.9,-26.84 pfet_01v8
M$1147 315 64 182 31 pfet_01v8 L=150000U W=1900000U AS=503500000000P
+ AD=503500000000P PS=4330000U PD=4330000U
* device instance $1148 r0 *1 58.9,-29.01 pfet_01v8
M$1148 183 64 309 31 pfet_01v8 L=150000U W=1900000U AS=503500000000P
+ AD=503500000000P PS=4330000U PD=4330000U
* device instance $1149 r0 *1 58.9,-22.96 nfet_01v8
M$1149 315 65 182 253 nfet_01v8 L=150000U W=1300000U AS=344500000000P
+ AD=344500000000P PS=3130000U PD=3130000U
* device instance $1150 r0 *1 58.9,-24.53 nfet_01v8
M$1150 183 65 309 253 nfet_01v8 L=150000U W=1300000U AS=344500000000P
+ AD=344500000000P PS=3130000U PD=3130000U
* device instance $1151 r0 *1 69.8,-26.84 pfet_01v8
M$1151 316 64 198 31 pfet_01v8 L=150000U W=1900000U AS=503500000000P
+ AD=503500000000P PS=4330000U PD=4330000U
* device instance $1152 r0 *1 69.8,-29.01 pfet_01v8
M$1152 199 64 310 31 pfet_01v8 L=150000U W=1900000U AS=503500000000P
+ AD=503500000000P PS=4330000U PD=4330000U
* device instance $1153 r0 *1 69.8,-22.96 nfet_01v8
M$1153 316 65 198 253 nfet_01v8 L=150000U W=1300000U AS=344500000000P
+ AD=344500000000P PS=3130000U PD=3130000U
* device instance $1154 r0 *1 69.8,-24.53 nfet_01v8
M$1154 199 65 310 253 nfet_01v8 L=150000U W=1300000U AS=344500000000P
+ AD=344500000000P PS=3130000U PD=3130000U
* device instance $1155 r0 *1 80.7,-26.84 pfet_01v8
M$1155 318 64 214 31 pfet_01v8 L=150000U W=1900000U AS=503500000000P
+ AD=503500000000P PS=4330000U PD=4330000U
* device instance $1156 r0 *1 80.7,-29.01 pfet_01v8
M$1156 215 64 312 31 pfet_01v8 L=150000U W=1900000U AS=503500000000P
+ AD=503500000000P PS=4330000U PD=4330000U
* device instance $1157 r0 *1 80.7,-22.96 nfet_01v8
M$1157 318 65 214 253 nfet_01v8 L=150000U W=1300000U AS=344500000000P
+ AD=344500000000P PS=3130000U PD=3130000U
* device instance $1158 r0 *1 80.7,-24.53 nfet_01v8
M$1158 215 65 312 253 nfet_01v8 L=150000U W=1300000U AS=344500000000P
+ AD=344500000000P PS=3130000U PD=3130000U
.ENDS sram22_inner

* cell precharge_1
* pin br_in,br_out
* pin en_b
* pin
* pin bl_in,bl_out
* pin vdd
.SUBCKT precharge_1 1 2 3 4 5
* net 1 br_in,br_out
* net 2 en_b
* net 4 bl_in,bl_out
* net 5 vdd
* device instance $1 r0 *1 0.6,3.14 pfet_01v8
M$1 5 2 1 3 pfet_01v8 L=150000U W=800000U AS=212000000000P AD=212000000000P
+ PS=2130000U PD=2130000U
* device instance $2 r0 *1 0.6,2.07 pfet_01v8
M$2 4 2 5 3 pfet_01v8 L=150000U W=800000U AS=212000000000P AD=212000000000P
+ PS=2130000U PD=2130000U
* device instance $3 r0 *1 0.6,1.15 pfet_01v8
M$3 4 2 1 3 pfet_01v8 L=150000U W=500000U AS=132500000000P AD=132500000000P
+ PS=1530000U PD=1530000U
.ENDS precharge_1

* cell decoder_stage
* pin y_b
* pin y
* pin vdd
* pin vdd
* pin vdd
* pin vdd
* pin predecode_0_0
* pin predecode_1_0
* pin vss
.SUBCKT decoder_stage 3 4 5 6 7 8 9 10 11
* net 3 y_b
* net 4 y
* net 5 vdd
* net 6 vdd
* net 7 vdd
* net 8 vdd
* net 9 predecode_0_0
* net 10 predecode_1_0
* net 11 vss
* device instance $1 r0 *1 -0.215,12.02 pfet_01v8
M$1 3 2 7 7 pfet_01v8 L=150000U W=2800000U AS=567000000000P AD=567000000000P
+ PS=5010000U PD=5010000U
* device instance $3 r0 *1 -0.215,10.525 nfet_01v8
M$3 3 2 11 11 nfet_01v8 L=150000U W=1100000U AS=222750000000P AD=222750000000P
+ PS=2460000U PD=2460000U
* device instance $5 r0 *1 -0.215,15.51 pfet_01v8
M$5 4 3 8 8 pfet_01v8 L=150000U W=2800000U AS=567000000000P AD=567000000000P
+ PS=5010000U PD=5010000U
* device instance $7 r0 *1 -0.215,14.015 nfet_01v8
M$7 4 3 11 11 nfet_01v8 L=150000U W=1100000U AS=222750000000P AD=222750000000P
+ PS=2460000U PD=2460000U
* device instance $9 r0 *1 -0.215,8.58 pfet_01v8
M$9 2 1 6 6 pfet_01v8 L=150000U W=2600000U AS=526500000000P AD=526500000000P
+ PS=4710000U PD=4710000U
* device instance $11 r0 *1 -0.215,7.145 nfet_01v8
M$11 2 1 11 11 nfet_01v8 L=150000U W=1060000U AS=214650000000P AD=214650000000P
+ PS=2400000U PD=2400000U
* device instance $13 r0 *1 -0.215,4.61 pfet_01v8
M$13 5 10 1 5 pfet_01v8 L=150000U W=2500000U AS=662500000000P AD=350000000000P
+ PS=5530000U PD=2780000U
* device instance $14 r0 *1 0.215,4.61 pfet_01v8
M$14 1 9 5 5 pfet_01v8 L=150000U W=2500000U AS=350000000000P AD=662500000000P
+ PS=2780000U PD=5530000U
* device instance $15 r0 *1 -0.215,1.84 nfet_01v8
M$15 12 10 1 11 nfet_01v8 L=150000U W=2000000U AS=530000000000P
+ AD=280000000000P PS=4530000U PD=2280000U
* device instance $16 r0 *1 0.215,1.84 nfet_01v8
M$16 11 9 12 11 nfet_01v8 L=150000U W=2000000U AS=280000000000P
+ AD=530000000000P PS=2280000U PD=4530000U
.ENDS decoder_stage

* cell diff_latch
* pin dout1
* pin din1
* pin din2
* pin vdd
* pin vdd
* pin vdd
* pin vss
* pin vss
* pin vss
* pin vss
* pin
* pin
* pin
* pin VNB
.SUBCKT diff_latch 4 5 6 7 8 9 10 11 12 13 14 15 16 19
* net 3 dout2
* net 4 dout1
* net 5 din1
* net 6 din2
* net 7 vdd
* net 8 vdd
* net 9 vdd
* net 10 vss
* net 11 vss
* net 12 vss
* net 13 vss
* net 19 VNB
* cell instance $3 r270 *1 0,-4.89
X$3 1 11 8 2 11 8 15 19 folded_inv
* cell instance $5 r270 *1 2.07,-4.89
X$5 2 11 8 1 11 8 15 19 folded_inv
* cell instance $6 r270 *1 2.07,-7.9
X$6 1 12 9 3 12 9 16 19 folded_inv
* cell instance $9 r270 *1 0,-7.9
X$9 2 12 9 4 12 9 16 19 folded_inv
* cell instance $12 r270 *1 0,0
X$12 5 10 7 17 10 7 14 19 folded_inv
* cell instance $14 r270 *1 2.07,0
X$14 6 10 7 18 10 7 14 19 folded_inv
* device instance $1 r270 *1 0.34,-3.51 nfet_01v8
M$1 1 17 13 19 nfet_01v8 L=150000U W=2000000U AS=405000000000P AD=405000000000P
+ PS=3810000U PD=3810000U
* device instance $3 r270 *1 2.41,-3.51 nfet_01v8
M$3 2 18 13 19 nfet_01v8 L=150000U W=2000000U AS=405000000000P AD=405000000000P
+ PS=3810000U PD=3810000U
.ENDS diff_latch

* cell write_driver
* pin data_b
* pin data
* pin bl
* pin br
* pin en
* pin vdd
* pin vss
* pin en_b
* pin
* pin VNB
.SUBCKT write_driver 1 2 3 4 5 6 7 8 9 10
* net 1 data_b
* net 2 data
* net 3 bl
* net 4 br
* net 5 en
* net 6 vdd
* net 7 vss
* net 8 en_b
* net 10 VNB
* cell instance $1 r90 *1 0,0
X$1 1 3 7 6 5 8 10 9 tristate_inv
* cell instance $2 m45 *1 0.53,0
X$2 2 4 7 6 5 8 10 9 tristate_inv
.ENDS write_driver

* cell sramgen_sp_sense_amp
* pin clk
* pin vss
* pin inp
* pin inn
* pin outp
* pin outn
* pin vdd
* pin
* pin VNB
.SUBCKT sramgen_sp_sense_amp 1 3 6 7 8 9 10 11 12
* net 1 clk
* net 3 vss
* net 6 inp
* net 7 inn
* net 8 outp
* net 9 outn
* net 10 vdd
* net 12 VNB
* device instance $1 r0 *1 3.475,24.375 pfet_01v8
M$1 5 1 10 11 pfet_01v8 L=150000U W=2000000U AS=495000000000P AD=495000000000P
+ PS=3990000U PD=3990000U
* device instance $3 r0 *1 0.895,24.375 pfet_01v8
M$3 4 1 10 11 pfet_01v8 L=150000U W=2000000U AS=495000000000P AD=495000000000P
+ PS=3990000U PD=3990000U
* device instance $5 r0 *1 0.895,18.69 pfet_01v8
M$5 9 8 10 11 pfet_01v8 L=150000U W=4000000U AS=990000000000P AD=990000000000P
+ PS=6990000U PD=6990000U
* device instance $7 r0 *1 3.475,21.13 pfet_01v8
M$7 9 1 10 11 pfet_01v8 L=150000U W=2000000U AS=495000000000P AD=495000000000P
+ PS=3990000U PD=3990000U
* device instance $9 r0 *1 3.475,18.69 pfet_01v8
M$9 8 9 10 11 pfet_01v8 L=150000U W=4000000U AS=990000000000P AD=990000000000P
+ PS=6990000U PD=6990000U
* device instance $11 r0 *1 0.895,21.13 pfet_01v8
M$11 8 1 10 11 pfet_01v8 L=150000U W=2000000U AS=495000000000P AD=495000000000P
+ PS=3990000U PD=3990000U
* device instance $13 r0 *1 3.475,15.765 nfet_01v8
M$13 8 9 5 12 nfet_01v8 L=150000U W=3360000U AS=831600000000P AD=831600000000P
+ PS=6030000U PD=6030000U
* device instance $15 r0 *1 0.895,15.765 nfet_01v8
M$15 9 8 4 12 nfet_01v8 L=150000U W=3360000U AS=831600000000P AD=831600000000P
+ PS=6030000U PD=6030000U
* device instance $17 r0 *1 0.895,9.825 nfet_01v8
M$17 2 1 3 12 nfet_01v8 L=150000U W=6720000U AS=1.6632e+12P AD=1.6632e+12P
+ PS=12060000U PD=12060000U
* device instance $19 r0 *1 0.895,11.975 nfet_01v8
M$19 2 6 4 12 nfet_01v8 L=150000U W=3360000U AS=831600000000P AD=831600000000P
+ PS=6030000U PD=6030000U
* device instance $21 r0 *1 3.475,11.975 nfet_01v8
M$21 2 7 5 12 nfet_01v8 L=150000U W=3360000U AS=831600000000P AD=831600000000P
+ PS=6030000U PD=6030000U
.ENDS sramgen_sp_sense_amp

* cell dff_array_10
* pin d[0]
* pin d[1]
* pin d[2]
* pin d[3]
* pin d[4]
* pin d[5]
* pin d[6]
* pin d[7]
* pin d[8]
* pin d[9]
* pin vdd
* pin q_n[0]
* pin vss
* pin vdd
* pin q_n[1]
* pin vss
* pin vdd
* pin q_n[2]
* pin vss
* pin vdd
* pin q_n[3]
* pin vss
* pin vdd
* pin q_n[4]
* pin vss
* pin rstb
* pin clk
* pin vdd
* pin q_n[5]
* pin vss
* pin vdd
* pin q_n[6]
* pin vss
* pin vdd
* pin q_n[7]
* pin vss
* pin vdd
* pin vss
* pin vdd
* pin vss
* pin q[0]
* pin q[1]
* pin q[2]
* pin q[3]
* pin q[4]
* pin q[5]
* pin q[6]
* pin q[7]
* pin q[8]
* pin q[9]
* pin VNB
.SUBCKT dff_array_10 1 2 3 4 5 6 7 8 9 10 11 12 13 14 15 16 17 18 19 20 21 22
+ 23 24 25 26 27 28 29 30 31 32 33 34 35 36 37 39 40 42 43 44 45 46 47 48 49 50
+ 51 52 53
* net 1 d[0]
* net 2 d[1]
* net 3 d[2]
* net 4 d[3]
* net 5 d[4]
* net 6 d[5]
* net 7 d[6]
* net 8 d[7]
* net 9 d[8]
* net 10 d[9]
* net 11 vdd
* net 12 q_n[0]
* net 13 vss
* net 14 vdd
* net 15 q_n[1]
* net 16 vss
* net 17 vdd
* net 18 q_n[2]
* net 19 vss
* net 20 vdd
* net 21 q_n[3]
* net 22 vss
* net 23 vdd
* net 24 q_n[4]
* net 25 vss
* net 26 rstb
* net 27 clk
* net 28 vdd
* net 29 q_n[5]
* net 30 vss
* net 31 vdd
* net 32 q_n[6]
* net 33 vss
* net 34 vdd
* net 35 q_n[7]
* net 36 vss
* net 37 vdd
* net 38 q_n[8]
* net 39 vss
* net 40 vdd
* net 41 q_n[9]
* net 42 vss
* net 43 q[0]
* net 44 q[1]
* net 45 q[2]
* net 46 q[3]
* net 47 q[4]
* net 48 q[5]
* net 49 q[6]
* net 50 q[7]
* net 51 q[8]
* net 52 q[9]
* net 53 VNB
* cell instance $11 r90 *1 4.715,0
X$11 13 43 1 12 26 27 11 11 53 sky130_fd_sc_hs__dfrbp_2
* cell instance $17 r90 *1 10.815,0
X$17 16 44 2 15 26 27 14 14 53 sky130_fd_sc_hs__dfrbp_2
* cell instance $23 r90 *1 16.915,0
X$23 19 45 3 18 26 27 17 17 53 sky130_fd_sc_hs__dfrbp_2
* cell instance $29 r90 *1 23.015,0
X$29 22 46 4 21 26 27 20 20 53 sky130_fd_sc_hs__dfrbp_2
* cell instance $35 r90 *1 29.115,0
X$35 25 47 5 24 26 27 23 23 53 sky130_fd_sc_hs__dfrbp_2
* cell instance $41 r90 *1 35.215,0
X$41 30 48 6 29 26 27 28 28 53 sky130_fd_sc_hs__dfrbp_2
* cell instance $47 r90 *1 41.315,0
X$47 33 49 7 32 26 27 31 31 53 sky130_fd_sc_hs__dfrbp_2
* cell instance $53 r90 *1 47.415,0
X$53 36 50 8 35 26 27 34 34 53 sky130_fd_sc_hs__dfrbp_2
* cell instance $59 r90 *1 53.515,0
X$59 39 51 9 38 26 27 37 37 53 sky130_fd_sc_hs__dfrbp_2
* cell instance $65 r90 *1 59.615,0
X$65 42 52 10 41 26 27 40 40 53 sky130_fd_sc_hs__dfrbp_2
.ENDS dff_array_10

* cell replica_column_mos
* pin bl
* pin vdd
* pin vss
.SUBCKT replica_column_mos 1 2 3
* net 1 bl
* net 2 vdd
* net 3 vss
* cell instance $1 r0 *1 1.3,-3.7
X$1 3 2 1 3 2 3 column_mos
.ENDS replica_column_mos

* cell decoder_stage_1
* pin wl_en
* pin in[0]
* pin in[1]
* pin in[2]
* pin in[3]
* pin in[4]
* pin in[5]
* pin in[6]
* pin in[7]
* pin in[8]
* pin in[9]
* pin vdd
* pin vdd
* pin y[0]
* pin y[1]
* pin y[2]
* pin y[3]
* pin y[4]
* pin y[5]
* pin y[6]
* pin y[7]
* pin y[8]
* pin y[9]
* pin vss
.SUBCKT decoder_stage_1 1 2 3 4 5 6 7 8 9 10 11 13 23 24 25 26 27 28 29 30 31
+ 32 33 34
* net 1 wl_en
* net 2 in[0]
* net 3 in[1]
* net 4 in[2]
* net 5 in[3]
* net 6 in[4]
* net 7 in[5]
* net 8 in[6]
* net 9 in[7]
* net 10 in[8]
* net 11 in[9]
* net 12 y_b[0]
* net 13 vdd
* net 14 y_b[1]
* net 15 y_b[2]
* net 16 y_b[3]
* net 17 y_b[4]
* net 18 y_b[5]
* net 19 y_b[6]
* net 20 y_b[7]
* net 21 y_b[8]
* net 22 y_b[9]
* net 23 vdd
* net 24 y[0]
* net 25 y[1]
* net 26 y[2]
* net 27 y[3]
* net 28 y[4]
* net 29 y[5]
* net 30 y[6]
* net 31 y[7]
* net 32 y[8]
* net 33 y[9]
* net 34 vss
* device instance $1 r0 *1 -8.325,11.9 pfet_01v8
M$1 24 12 23 23 pfet_01v8 L=150000U W=10000000U AS=2.025e+12P AD=2.025e+12P
+ PS=15810000U PD=15810000U
* device instance $3 r0 *1 -8.325,4.61 pfet_01v8
M$3 13 2 12 13 pfet_01v8 L=150000U W=2500000U AS=662500000000P AD=350000000000P
+ PS=5530000U PD=2780000U
* device instance $4 r0 *1 -7.895,4.61 pfet_01v8
M$4 12 1 13 13 pfet_01v8 L=150000U W=2500000U AS=350000000000P AD=662500000000P
+ PS=2780000U PD=5530000U
* device instance $5 r0 *1 -8.325,7.88 nfet_01v8
M$5 24 12 34 34 nfet_01v8 L=150000U W=4000000U AS=810000000000P
+ AD=810000000000P PS=6810000U PD=6810000U
* device instance $7 r0 *1 -8.325,1.84 nfet_01v8
M$7 35 2 12 34 nfet_01v8 L=150000U W=2000000U AS=530000000000P AD=280000000000P
+ PS=4530000U PD=2280000U
* device instance $8 r0 *1 -7.895,1.84 nfet_01v8
M$8 34 1 35 34 nfet_01v8 L=150000U W=2000000U AS=280000000000P AD=530000000000P
+ PS=2280000U PD=4530000U
* device instance $9 r0 *1 -6.745,11.9 pfet_01v8
M$9 25 14 23 23 pfet_01v8 L=150000U W=10000000U AS=2.025e+12P AD=2.025e+12P
+ PS=15810000U PD=15810000U
* device instance $11 r0 *1 -6.745,4.61 pfet_01v8
M$11 13 3 14 13 pfet_01v8 L=150000U W=2500000U AS=662500000000P
+ AD=350000000000P PS=5530000U PD=2780000U
* device instance $12 r0 *1 -6.315,4.61 pfet_01v8
M$12 14 1 13 13 pfet_01v8 L=150000U W=2500000U AS=350000000000P
+ AD=662500000000P PS=2780000U PD=5530000U
* device instance $13 r0 *1 -6.745,7.88 nfet_01v8
M$13 25 14 34 34 nfet_01v8 L=150000U W=4000000U AS=810000000000P
+ AD=810000000000P PS=6810000U PD=6810000U
* device instance $15 r0 *1 -6.745,1.84 nfet_01v8
M$15 36 3 14 34 nfet_01v8 L=150000U W=2000000U AS=530000000000P
+ AD=280000000000P PS=4530000U PD=2280000U
* device instance $16 r0 *1 -6.315,1.84 nfet_01v8
M$16 34 1 36 34 nfet_01v8 L=150000U W=2000000U AS=280000000000P
+ AD=530000000000P PS=2280000U PD=4530000U
* device instance $17 r0 *1 -5.165,11.9 pfet_01v8
M$17 26 15 23 23 pfet_01v8 L=150000U W=10000000U AS=2.025e+12P AD=2.025e+12P
+ PS=15810000U PD=15810000U
* device instance $19 r0 *1 -5.165,4.61 pfet_01v8
M$19 13 4 15 13 pfet_01v8 L=150000U W=2500000U AS=662500000000P
+ AD=350000000000P PS=5530000U PD=2780000U
* device instance $20 r0 *1 -4.735,4.61 pfet_01v8
M$20 15 1 13 13 pfet_01v8 L=150000U W=2500000U AS=350000000000P
+ AD=662500000000P PS=2780000U PD=5530000U
* device instance $21 r0 *1 -5.165,7.88 nfet_01v8
M$21 26 15 34 34 nfet_01v8 L=150000U W=4000000U AS=810000000000P
+ AD=810000000000P PS=6810000U PD=6810000U
* device instance $23 r0 *1 -5.165,1.84 nfet_01v8
M$23 37 4 15 34 nfet_01v8 L=150000U W=2000000U AS=530000000000P
+ AD=280000000000P PS=4530000U PD=2280000U
* device instance $24 r0 *1 -4.735,1.84 nfet_01v8
M$24 34 1 37 34 nfet_01v8 L=150000U W=2000000U AS=280000000000P
+ AD=530000000000P PS=2280000U PD=4530000U
* device instance $25 r0 *1 -3.585,11.9 pfet_01v8
M$25 27 16 23 23 pfet_01v8 L=150000U W=10000000U AS=2.025e+12P AD=2.025e+12P
+ PS=15810000U PD=15810000U
* device instance $27 r0 *1 -3.585,4.61 pfet_01v8
M$27 13 5 16 13 pfet_01v8 L=150000U W=2500000U AS=662500000000P
+ AD=350000000000P PS=5530000U PD=2780000U
* device instance $28 r0 *1 -3.155,4.61 pfet_01v8
M$28 16 1 13 13 pfet_01v8 L=150000U W=2500000U AS=350000000000P
+ AD=662500000000P PS=2780000U PD=5530000U
* device instance $29 r0 *1 -3.585,7.88 nfet_01v8
M$29 27 16 34 34 nfet_01v8 L=150000U W=4000000U AS=810000000000P
+ AD=810000000000P PS=6810000U PD=6810000U
* device instance $31 r0 *1 -3.585,1.84 nfet_01v8
M$31 38 5 16 34 nfet_01v8 L=150000U W=2000000U AS=530000000000P
+ AD=280000000000P PS=4530000U PD=2280000U
* device instance $32 r0 *1 -3.155,1.84 nfet_01v8
M$32 34 1 38 34 nfet_01v8 L=150000U W=2000000U AS=280000000000P
+ AD=530000000000P PS=2280000U PD=4530000U
* device instance $33 r0 *1 -1.005,11.9 pfet_01v8
M$33 28 17 23 23 pfet_01v8 L=150000U W=10000000U AS=2.025e+12P AD=2.025e+12P
+ PS=15810000U PD=15810000U
* device instance $35 r0 *1 -1.005,4.61 pfet_01v8
M$35 13 6 17 13 pfet_01v8 L=150000U W=2500000U AS=662500000000P
+ AD=350000000000P PS=5530000U PD=2780000U
* device instance $36 r0 *1 -0.575,4.61 pfet_01v8
M$36 17 1 13 13 pfet_01v8 L=150000U W=2500000U AS=350000000000P
+ AD=662500000000P PS=2780000U PD=5530000U
* device instance $37 r0 *1 -1.005,7.88 nfet_01v8
M$37 28 17 34 34 nfet_01v8 L=150000U W=4000000U AS=810000000000P
+ AD=810000000000P PS=6810000U PD=6810000U
* device instance $39 r0 *1 -1.005,1.84 nfet_01v8
M$39 39 6 17 34 nfet_01v8 L=150000U W=2000000U AS=530000000000P
+ AD=280000000000P PS=4530000U PD=2280000U
* device instance $40 r0 *1 -0.575,1.84 nfet_01v8
M$40 34 1 39 34 nfet_01v8 L=150000U W=2000000U AS=280000000000P
+ AD=530000000000P PS=2280000U PD=4530000U
* device instance $41 r0 *1 0.575,11.9 pfet_01v8
M$41 29 18 23 23 pfet_01v8 L=150000U W=10000000U AS=2.025e+12P AD=2.025e+12P
+ PS=15810000U PD=15810000U
* device instance $43 r0 *1 0.575,4.61 pfet_01v8
M$43 13 7 18 13 pfet_01v8 L=150000U W=2500000U AS=662500000000P
+ AD=350000000000P PS=5530000U PD=2780000U
* device instance $44 r0 *1 1.005,4.61 pfet_01v8
M$44 18 1 13 13 pfet_01v8 L=150000U W=2500000U AS=350000000000P
+ AD=662500000000P PS=2780000U PD=5530000U
* device instance $45 r0 *1 0.575,7.88 nfet_01v8
M$45 29 18 34 34 nfet_01v8 L=150000U W=4000000U AS=810000000000P
+ AD=810000000000P PS=6810000U PD=6810000U
* device instance $47 r0 *1 0.575,1.84 nfet_01v8
M$47 40 7 18 34 nfet_01v8 L=150000U W=2000000U AS=530000000000P
+ AD=280000000000P PS=4530000U PD=2280000U
* device instance $48 r0 *1 1.005,1.84 nfet_01v8
M$48 34 1 40 34 nfet_01v8 L=150000U W=2000000U AS=280000000000P
+ AD=530000000000P PS=2280000U PD=4530000U
* device instance $49 r0 *1 2.155,11.9 pfet_01v8
M$49 30 19 23 23 pfet_01v8 L=150000U W=10000000U AS=2.025e+12P AD=2.025e+12P
+ PS=15810000U PD=15810000U
* device instance $51 r0 *1 2.155,4.61 pfet_01v8
M$51 13 8 19 13 pfet_01v8 L=150000U W=2500000U AS=662500000000P
+ AD=350000000000P PS=5530000U PD=2780000U
* device instance $52 r0 *1 2.585,4.61 pfet_01v8
M$52 19 1 13 13 pfet_01v8 L=150000U W=2500000U AS=350000000000P
+ AD=662500000000P PS=2780000U PD=5530000U
* device instance $53 r0 *1 2.155,7.88 nfet_01v8
M$53 30 19 34 34 nfet_01v8 L=150000U W=4000000U AS=810000000000P
+ AD=810000000000P PS=6810000U PD=6810000U
* device instance $55 r0 *1 2.155,1.84 nfet_01v8
M$55 41 8 19 34 nfet_01v8 L=150000U W=2000000U AS=530000000000P
+ AD=280000000000P PS=4530000U PD=2280000U
* device instance $56 r0 *1 2.585,1.84 nfet_01v8
M$56 34 1 41 34 nfet_01v8 L=150000U W=2000000U AS=280000000000P
+ AD=530000000000P PS=2280000U PD=4530000U
* device instance $57 r0 *1 3.735,11.9 pfet_01v8
M$57 31 20 23 23 pfet_01v8 L=150000U W=10000000U AS=2.025e+12P AD=2.025e+12P
+ PS=15810000U PD=15810000U
* device instance $59 r0 *1 3.735,4.61 pfet_01v8
M$59 13 9 20 13 pfet_01v8 L=150000U W=2500000U AS=662500000000P
+ AD=350000000000P PS=5530000U PD=2780000U
* device instance $60 r0 *1 4.165,4.61 pfet_01v8
M$60 20 1 13 13 pfet_01v8 L=150000U W=2500000U AS=350000000000P
+ AD=662500000000P PS=2780000U PD=5530000U
* device instance $61 r0 *1 3.735,7.88 nfet_01v8
M$61 31 20 34 34 nfet_01v8 L=150000U W=4000000U AS=810000000000P
+ AD=810000000000P PS=6810000U PD=6810000U
* device instance $63 r0 *1 3.735,1.84 nfet_01v8
M$63 42 9 20 34 nfet_01v8 L=150000U W=2000000U AS=530000000000P
+ AD=280000000000P PS=4530000U PD=2280000U
* device instance $64 r0 *1 4.165,1.84 nfet_01v8
M$64 34 1 42 34 nfet_01v8 L=150000U W=2000000U AS=280000000000P
+ AD=530000000000P PS=2280000U PD=4530000U
* device instance $65 r0 *1 6.315,11.9 pfet_01v8
M$65 32 21 23 23 pfet_01v8 L=150000U W=10000000U AS=2.025e+12P AD=2.025e+12P
+ PS=15810000U PD=15810000U
* device instance $67 r0 *1 6.315,4.61 pfet_01v8
M$67 13 10 21 13 pfet_01v8 L=150000U W=2500000U AS=662500000000P
+ AD=350000000000P PS=5530000U PD=2780000U
* device instance $68 r0 *1 6.745,4.61 pfet_01v8
M$68 21 1 13 13 pfet_01v8 L=150000U W=2500000U AS=350000000000P
+ AD=662500000000P PS=2780000U PD=5530000U
* device instance $69 r0 *1 6.315,7.88 nfet_01v8
M$69 32 21 34 34 nfet_01v8 L=150000U W=4000000U AS=810000000000P
+ AD=810000000000P PS=6810000U PD=6810000U
* device instance $71 r0 *1 6.315,1.84 nfet_01v8
M$71 43 10 21 34 nfet_01v8 L=150000U W=2000000U AS=530000000000P
+ AD=280000000000P PS=4530000U PD=2280000U
* device instance $72 r0 *1 6.745,1.84 nfet_01v8
M$72 34 1 43 34 nfet_01v8 L=150000U W=2000000U AS=280000000000P
+ AD=530000000000P PS=2280000U PD=4530000U
* device instance $73 r0 *1 7.895,11.9 pfet_01v8
M$73 33 22 23 23 pfet_01v8 L=150000U W=10000000U AS=2.025e+12P AD=2.025e+12P
+ PS=15810000U PD=15810000U
* device instance $75 r0 *1 7.895,4.61 pfet_01v8
M$75 13 11 22 13 pfet_01v8 L=150000U W=2500000U AS=662500000000P
+ AD=350000000000P PS=5530000U PD=2780000U
* device instance $76 r0 *1 8.325,4.61 pfet_01v8
M$76 22 1 13 13 pfet_01v8 L=150000U W=2500000U AS=350000000000P
+ AD=662500000000P PS=2780000U PD=5530000U
* device instance $77 r0 *1 7.895,7.88 nfet_01v8
M$77 33 22 34 34 nfet_01v8 L=150000U W=4000000U AS=810000000000P
+ AD=810000000000P PS=6810000U PD=6810000U
* device instance $79 r0 *1 7.895,1.84 nfet_01v8
M$79 44 11 22 34 nfet_01v8 L=150000U W=2000000U AS=530000000000P
+ AD=280000000000P PS=4530000U PD=2280000U
* device instance $80 r0 *1 8.325,1.84 nfet_01v8
M$80 34 1 44 34 nfet_01v8 L=150000U W=2000000U AS=280000000000P
+ AD=530000000000P PS=2280000U PD=4530000U
.ENDS decoder_stage_1

* cell sp_cell_array
* pin br_dummy[0]
* pin bl_dummy[0]
* pin bl[0]
* pin br[0]
* pin br[1]
* pin bl[1]
* pin bl[2]
* pin br[2]
* pin br[3]
* pin bl[3]
* pin bl[4]
* pin br[4]
* pin br[5]
* pin bl[5]
* pin bl[6]
* pin br[6]
* pin br[7]
* pin bl[7]
* pin bl[8]
* pin br[8]
* pin br[9]
* pin bl[9]
* pin bl[10]
* pin br[10]
* pin br[11]
* pin bl[11]
* pin bl[12]
* pin br[12]
* pin br[13]
* pin bl[13]
* pin bl[14]
* pin br[14]
* pin br[15]
* pin bl[15]
* pin bl[16]
* pin br[16]
* pin br[17]
* pin bl[17]
* pin bl[18]
* pin br[18]
* pin br[19]
* pin bl[19]
* pin bl[20]
* pin br[20]
* pin br[21]
* pin bl[21]
* pin bl[22]
* pin br[22]
* pin br[23]
* pin bl[23]
* pin bl[24]
* pin br[24]
* pin br[25]
* pin bl[25]
* pin bl[26]
* pin br[26]
* pin br[27]
* pin bl[27]
* pin bl[28]
* pin br[28]
* pin br[29]
* pin bl[29]
* pin bl[30]
* pin br[30]
* pin br[31]
* pin bl[31]
* pin bl[32]
* pin br[32]
* pin br[33]
* pin bl[33]
* pin bl[34]
* pin br[34]
* pin br[35]
* pin bl[35]
* pin bl[36]
* pin br[36]
* pin br[37]
* pin bl[37]
* pin bl[38]
* pin br[38]
* pin br[39]
* pin bl[39]
* pin bl[40]
* pin br[40]
* pin br[41]
* pin bl[41]
* pin bl[42]
* pin br[42]
* pin br[43]
* pin bl[43]
* pin bl[44]
* pin br[44]
* pin br[45]
* pin bl[45]
* pin bl[46]
* pin br[46]
* pin br[47]
* pin bl[47]
* pin bl[48]
* pin br[48]
* pin br[49]
* pin bl[49]
* pin bl[50]
* pin br[50]
* pin br[51]
* pin bl[51]
* pin bl[52]
* pin br[52]
* pin br[53]
* pin bl[53]
* pin bl[54]
* pin br[54]
* pin br[55]
* pin bl[55]
* pin bl[56]
* pin br[56]
* pin br[57]
* pin bl[57]
* pin bl[58]
* pin br[58]
* pin br[59]
* pin bl[59]
* pin bl[60]
* pin br[60]
* pin br[61]
* pin bl[61]
* pin bl[62]
* pin br[62]
* pin br[63]
* pin bl[63]
* pin bl_dummy[1]
* pin br_dummy[1]
* pin wl_dummy[1]
* pin wl[31]
* pin wl[30]
* pin wl[29]
* pin wl[28]
* pin wl[27]
* pin wl[26]
* pin wl[25]
* pin wl[24]
* pin wl[23]
* pin wl[22]
* pin wl[21]
* pin wl[20]
* pin wl[19]
* pin wl[18]
* pin wl[17]
* pin wl[16]
* pin wl[15]
* pin wl[14]
* pin wl[13]
* pin wl[12]
* pin wl[11]
* pin wl[10]
* pin wl[9]
* pin wl[8]
* pin wl[7]
* pin wl[6]
* pin wl[5]
* pin wl[4]
* pin wl[3]
* pin wl[2]
* pin wl[1]
* pin wl[0]
* pin wl_dummy[0]
* pin vgnd,vnb
.SUBCKT sp_cell_array 1 2 3 4 5 6 7 8 9 10 11 12 13 14 15 16 17 18 19 20 21 22
+ 23 24 25 26 27 28 29 30 31 32 33 34 35 36 37 38 39 40 41 42 43 44 45 46 47 48
+ 49 50 51 52 53 54 55 56 57 58 59 60 61 62 63 64 65 66 67 68 69 70 71 72 73 74
+ 75 76 77 78 79 80 81 82 83 84 85 86 87 88 89 90 91 92 93 94 95 96 97 98 99
+ 100 101 102 103 104 105 106 107 108 109 110 111 112 113 114 115 116 117 118
+ 119 120 121 122 123 124 125 126 127 128 129 130 131 132 133 134 135 136 137
+ 138 139 140 141 142 143 144 145 146 147 148 149 150 151 152 153 154 155 156
+ 157 158 159 160 161 162 163 164 165 166 167
* net 1 br_dummy[0]
* net 2 bl_dummy[0]
* net 3 bl[0]
* net 4 br[0]
* net 5 br[1]
* net 6 bl[1]
* net 7 bl[2]
* net 8 br[2]
* net 9 br[3]
* net 10 bl[3]
* net 11 bl[4]
* net 12 br[4]
* net 13 br[5]
* net 14 bl[5]
* net 15 bl[6]
* net 16 br[6]
* net 17 br[7]
* net 18 bl[7]
* net 19 bl[8]
* net 20 br[8]
* net 21 br[9]
* net 22 bl[9]
* net 23 bl[10]
* net 24 br[10]
* net 25 br[11]
* net 26 bl[11]
* net 27 bl[12]
* net 28 br[12]
* net 29 br[13]
* net 30 bl[13]
* net 31 bl[14]
* net 32 br[14]
* net 33 br[15]
* net 34 bl[15]
* net 35 bl[16]
* net 36 br[16]
* net 37 br[17]
* net 38 bl[17]
* net 39 bl[18]
* net 40 br[18]
* net 41 br[19]
* net 42 bl[19]
* net 43 bl[20]
* net 44 br[20]
* net 45 br[21]
* net 46 bl[21]
* net 47 bl[22]
* net 48 br[22]
* net 49 br[23]
* net 50 bl[23]
* net 51 bl[24]
* net 52 br[24]
* net 53 br[25]
* net 54 bl[25]
* net 55 bl[26]
* net 56 br[26]
* net 57 br[27]
* net 58 bl[27]
* net 59 bl[28]
* net 60 br[28]
* net 61 br[29]
* net 62 bl[29]
* net 63 bl[30]
* net 64 br[30]
* net 65 br[31]
* net 66 bl[31]
* net 67 bl[32]
* net 68 br[32]
* net 69 br[33]
* net 70 bl[33]
* net 71 bl[34]
* net 72 br[34]
* net 73 br[35]
* net 74 bl[35]
* net 75 bl[36]
* net 76 br[36]
* net 77 br[37]
* net 78 bl[37]
* net 79 bl[38]
* net 80 br[38]
* net 81 br[39]
* net 82 bl[39]
* net 83 bl[40]
* net 84 br[40]
* net 85 br[41]
* net 86 bl[41]
* net 87 bl[42]
* net 88 br[42]
* net 89 br[43]
* net 90 bl[43]
* net 91 bl[44]
* net 92 br[44]
* net 93 br[45]
* net 94 bl[45]
* net 95 bl[46]
* net 96 br[46]
* net 97 br[47]
* net 98 bl[47]
* net 99 bl[48]
* net 100 br[48]
* net 101 br[49]
* net 102 bl[49]
* net 103 bl[50]
* net 104 br[50]
* net 105 br[51]
* net 106 bl[51]
* net 107 bl[52]
* net 108 br[52]
* net 109 br[53]
* net 110 bl[53]
* net 111 bl[54]
* net 112 br[54]
* net 113 br[55]
* net 114 bl[55]
* net 115 bl[56]
* net 116 br[56]
* net 117 br[57]
* net 118 bl[57]
* net 119 bl[58]
* net 120 br[58]
* net 121 br[59]
* net 122 bl[59]
* net 123 bl[60]
* net 124 br[60]
* net 125 br[61]
* net 126 bl[61]
* net 127 bl[62]
* net 128 br[62]
* net 129 br[63]
* net 130 bl[63]
* net 131 bl_dummy[1]
* net 132 br_dummy[1]
* net 133 wl_dummy[1]
* net 134 wl[31]
* net 135 wl[30]
* net 136 wl[29]
* net 137 wl[28]
* net 138 wl[27]
* net 139 wl[26]
* net 140 wl[25]
* net 141 wl[24]
* net 142 wl[23]
* net 143 wl[22]
* net 144 wl[21]
* net 145 wl[20]
* net 146 wl[19]
* net 147 wl[18]
* net 148 wl[17]
* net 149 wl[16]
* net 150 wl[15]
* net 151 wl[14]
* net 152 wl[13]
* net 153 wl[12]
* net 154 wl[11]
* net 155 wl[10]
* net 156 wl[9]
* net 157 wl[8]
* net 158 wl[7]
* net 159 wl[6]
* net 160 wl[5]
* net 161 wl[4]
* net 162 wl[3]
* net 163 wl[2]
* net 164 wl[1]
* net 165 wl[0]
* net 166 wl_dummy[0]
* net 167 vgnd,vnb
* cell instance $104 r0 *1 89.7,5.215
X$104 167 167 sram_sp_horiz_wlstrap_p2
* cell instance $110 r0 *1 2.5,5.215
X$110 167 167 sram_sp_horiz_wlstrap_p2
* cell instance $137 r0 *1 13.4,5.215
X$137 167 167 sram_sp_horiz_wlstrap_p2
* cell instance $164 r0 *1 24.3,5.215
X$164 167 167 sram_sp_horiz_wlstrap_p2
* cell instance $191 r0 *1 35.2,5.215
X$191 167 167 sram_sp_horiz_wlstrap_p2
* cell instance $218 r0 *1 46.1,5.215
X$218 167 167 sram_sp_horiz_wlstrap_p2
* cell instance $245 r0 *1 57,5.215
X$245 167 167 sram_sp_horiz_wlstrap_p2
* cell instance $272 r0 *1 67.9,5.215
X$272 167 167 sram_sp_horiz_wlstrap_p2
* cell instance $299 r0 *1 78.8,5.215
X$299 167 167 sram_sp_horiz_wlstrap_p2
* cell instance $332 r0 *1 89.7,13.115
X$332 167 167 sram_sp_horiz_wlstrap_p2
* cell instance $347 r0 *1 89.7,21.015
X$347 167 167 sram_sp_horiz_wlstrap_p2
* cell instance $362 r0 *1 89.7,28.915
X$362 167 167 sram_sp_horiz_wlstrap_p2
* cell instance $377 r0 *1 89.7,36.815
X$377 167 167 sram_sp_horiz_wlstrap_p2
* cell instance $392 r0 *1 89.7,44.715
X$392 167 167 sram_sp_horiz_wlstrap_p2
* cell instance $407 r0 *1 89.7,52.615
X$407 167 167 sram_sp_horiz_wlstrap_p2
* cell instance $422 r0 *1 89.7,60.515
X$422 167 167 sram_sp_horiz_wlstrap_p2
* cell instance $437 r0 *1 89.7,68.415
X$437 167 167 sram_sp_horiz_wlstrap_p2
* cell instance $452 r0 *1 2.5,13.115
X$452 167 167 sram_sp_horiz_wlstrap_p2
* cell instance $497 r0 *1 13.4,13.115
X$497 167 167 sram_sp_horiz_wlstrap_p2
* cell instance $542 r0 *1 24.3,13.115
X$542 167 167 sram_sp_horiz_wlstrap_p2
* cell instance $587 r0 *1 35.2,13.115
X$587 167 167 sram_sp_horiz_wlstrap_p2
* cell instance $632 r0 *1 46.1,13.115
X$632 167 167 sram_sp_horiz_wlstrap_p2
* cell instance $677 r0 *1 57,13.115
X$677 167 167 sram_sp_horiz_wlstrap_p2
* cell instance $722 r0 *1 67.9,13.115
X$722 167 167 sram_sp_horiz_wlstrap_p2
* cell instance $767 r0 *1 78.8,13.115
X$767 167 167 sram_sp_horiz_wlstrap_p2
* cell instance $812 r0 *1 2.5,21.015
X$812 167 167 sram_sp_horiz_wlstrap_p2
* cell instance $857 r0 *1 13.4,21.015
X$857 167 167 sram_sp_horiz_wlstrap_p2
* cell instance $902 r0 *1 24.3,21.015
X$902 167 167 sram_sp_horiz_wlstrap_p2
* cell instance $947 r0 *1 35.2,21.015
X$947 167 167 sram_sp_horiz_wlstrap_p2
* cell instance $992 r0 *1 46.1,21.015
X$992 167 167 sram_sp_horiz_wlstrap_p2
* cell instance $1037 r0 *1 57,21.015
X$1037 167 167 sram_sp_horiz_wlstrap_p2
* cell instance $1082 r0 *1 67.9,21.015
X$1082 167 167 sram_sp_horiz_wlstrap_p2
* cell instance $1127 r0 *1 78.8,21.015
X$1127 167 167 sram_sp_horiz_wlstrap_p2
* cell instance $1172 r0 *1 2.5,28.915
X$1172 167 167 sram_sp_horiz_wlstrap_p2
* cell instance $1217 r0 *1 13.4,28.915
X$1217 167 167 sram_sp_horiz_wlstrap_p2
* cell instance $1262 r0 *1 24.3,28.915
X$1262 167 167 sram_sp_horiz_wlstrap_p2
* cell instance $1307 r0 *1 35.2,28.915
X$1307 167 167 sram_sp_horiz_wlstrap_p2
* cell instance $1352 r0 *1 46.1,28.915
X$1352 167 167 sram_sp_horiz_wlstrap_p2
* cell instance $1397 r0 *1 57,28.915
X$1397 167 167 sram_sp_horiz_wlstrap_p2
* cell instance $1442 r0 *1 67.9,28.915
X$1442 167 167 sram_sp_horiz_wlstrap_p2
* cell instance $1487 r0 *1 78.8,28.915
X$1487 167 167 sram_sp_horiz_wlstrap_p2
* cell instance $1532 r0 *1 2.5,36.815
X$1532 167 167 sram_sp_horiz_wlstrap_p2
* cell instance $1577 r0 *1 13.4,36.815
X$1577 167 167 sram_sp_horiz_wlstrap_p2
* cell instance $1622 r0 *1 24.3,36.815
X$1622 167 167 sram_sp_horiz_wlstrap_p2
* cell instance $1667 r0 *1 35.2,36.815
X$1667 167 167 sram_sp_horiz_wlstrap_p2
* cell instance $1712 r0 *1 46.1,36.815
X$1712 167 167 sram_sp_horiz_wlstrap_p2
* cell instance $1757 r0 *1 57,36.815
X$1757 167 167 sram_sp_horiz_wlstrap_p2
* cell instance $1802 r0 *1 67.9,36.815
X$1802 167 167 sram_sp_horiz_wlstrap_p2
* cell instance $1847 r0 *1 78.8,36.815
X$1847 167 167 sram_sp_horiz_wlstrap_p2
* cell instance $1892 r0 *1 2.5,44.715
X$1892 167 167 sram_sp_horiz_wlstrap_p2
* cell instance $1937 r0 *1 13.4,44.715
X$1937 167 167 sram_sp_horiz_wlstrap_p2
* cell instance $1982 r0 *1 24.3,44.715
X$1982 167 167 sram_sp_horiz_wlstrap_p2
* cell instance $2027 r0 *1 35.2,44.715
X$2027 167 167 sram_sp_horiz_wlstrap_p2
* cell instance $2072 r0 *1 46.1,44.715
X$2072 167 167 sram_sp_horiz_wlstrap_p2
* cell instance $2117 r0 *1 57,44.715
X$2117 167 167 sram_sp_horiz_wlstrap_p2
* cell instance $2162 r0 *1 67.9,44.715
X$2162 167 167 sram_sp_horiz_wlstrap_p2
* cell instance $2207 r0 *1 78.8,44.715
X$2207 167 167 sram_sp_horiz_wlstrap_p2
* cell instance $2252 r0 *1 2.5,52.615
X$2252 167 167 sram_sp_horiz_wlstrap_p2
* cell instance $2297 r0 *1 13.4,52.615
X$2297 167 167 sram_sp_horiz_wlstrap_p2
* cell instance $2342 r0 *1 24.3,52.615
X$2342 167 167 sram_sp_horiz_wlstrap_p2
* cell instance $2387 r0 *1 35.2,52.615
X$2387 167 167 sram_sp_horiz_wlstrap_p2
* cell instance $2432 r0 *1 46.1,52.615
X$2432 167 167 sram_sp_horiz_wlstrap_p2
* cell instance $2477 r0 *1 57,52.615
X$2477 167 167 sram_sp_horiz_wlstrap_p2
* cell instance $2522 r0 *1 67.9,52.615
X$2522 167 167 sram_sp_horiz_wlstrap_p2
* cell instance $2567 r0 *1 78.8,52.615
X$2567 167 167 sram_sp_horiz_wlstrap_p2
* cell instance $2612 r0 *1 2.5,60.515
X$2612 167 167 sram_sp_horiz_wlstrap_p2
* cell instance $2657 r0 *1 13.4,60.515
X$2657 167 167 sram_sp_horiz_wlstrap_p2
* cell instance $2702 r0 *1 24.3,60.515
X$2702 167 167 sram_sp_horiz_wlstrap_p2
* cell instance $2747 r0 *1 35.2,60.515
X$2747 167 167 sram_sp_horiz_wlstrap_p2
* cell instance $2792 r0 *1 46.1,60.515
X$2792 167 167 sram_sp_horiz_wlstrap_p2
* cell instance $2837 r0 *1 57,60.515
X$2837 167 167 sram_sp_horiz_wlstrap_p2
* cell instance $2882 r0 *1 67.9,60.515
X$2882 167 167 sram_sp_horiz_wlstrap_p2
* cell instance $2927 r0 *1 78.8,60.515
X$2927 167 167 sram_sp_horiz_wlstrap_p2
* cell instance $2972 r0 *1 2.5,68.415
X$2972 167 167 sram_sp_horiz_wlstrap_p2
* cell instance $3017 r0 *1 13.4,68.415
X$3017 167 167 sram_sp_horiz_wlstrap_p2
* cell instance $3062 r0 *1 24.3,68.415
X$3062 167 167 sram_sp_horiz_wlstrap_p2
* cell instance $3107 r0 *1 35.2,68.415
X$3107 167 167 sram_sp_horiz_wlstrap_p2
* cell instance $3152 r0 *1 46.1,68.415
X$3152 167 167 sram_sp_horiz_wlstrap_p2
* cell instance $3197 r0 *1 57,68.415
X$3197 167 167 sram_sp_horiz_wlstrap_p2
* cell instance $3242 r0 *1 67.9,68.415
X$3242 167 167 sram_sp_horiz_wlstrap_p2
* cell instance $3287 r0 *1 78.8,68.415
X$3287 167 167 sram_sp_horiz_wlstrap_p2
* device instance $1 r0 *1 89.44,2.25 nfet_01v8
M$1 3565 133 129 167 nfet_01v8 L=150000U W=140000U AS=16800000000P
+ AD=21875000000P PS=380000U PD=460000U
* device instance $2 r0 *1 89.405,2.65 nfet_01v8
M$2 167 387 3565 167 nfet_01v8 L=150000U W=210000U AS=21875000000P
+ AD=51200000000P PS=460000U PD=775000U
* device instance $3 r0 *1 89.405,3.04 nfet_01v8
M$3 387 3565 167 167 nfet_01v8 L=150000U W=210000U AS=51200000000P
+ AD=21875000000P PS=775000U PD=460000U
* device instance $4 r0 *1 89.44,3.44 nfet_01v8
M$4 130 133 387 167 nfet_01v8 L=150000U W=140000U AS=21875000000P
+ AD=16800000000P PS=460000U PD=380000U
* device instance $5 r0 *1 78.54,2.25 nfet_01v8
M$5 3375 133 113 167 nfet_01v8 L=150000U W=140000U AS=16800000000P
+ AD=21875000000P PS=380000U PD=460000U
* device instance $6 r0 *1 78.505,2.65 nfet_01v8
M$6 167 455 3375 167 nfet_01v8 L=150000U W=210000U AS=21875000000P
+ AD=51200000000P PS=460000U PD=775000U
* device instance $7 r0 *1 78.505,3.04 nfet_01v8
M$7 455 3375 167 167 nfet_01v8 L=150000U W=210000U AS=51200000000P
+ AD=21875000000P PS=775000U PD=460000U
* device instance $8 r0 *1 78.54,3.44 nfet_01v8
M$8 114 133 455 167 nfet_01v8 L=150000U W=140000U AS=21875000000P
+ AD=16800000000P PS=460000U PD=380000U
* device instance $9 r0 *1 67.64,2.25 nfet_01v8
M$9 3348 133 97 167 nfet_01v8 L=150000U W=140000U AS=16800000000P
+ AD=21875000000P PS=380000U PD=460000U
* device instance $10 r0 *1 67.605,2.65 nfet_01v8
M$10 167 565 3348 167 nfet_01v8 L=150000U W=210000U AS=21875000000P
+ AD=51200000000P PS=460000U PD=775000U
* device instance $11 r0 *1 67.605,3.04 nfet_01v8
M$11 565 3348 167 167 nfet_01v8 L=150000U W=210000U AS=51200000000P
+ AD=21875000000P PS=775000U PD=460000U
* device instance $12 r0 *1 67.64,3.44 nfet_01v8
M$12 98 133 565 167 nfet_01v8 L=150000U W=140000U AS=21875000000P
+ AD=16800000000P PS=460000U PD=380000U
* device instance $13 r0 *1 56.74,2.25 nfet_01v8
M$13 3341 133 81 167 nfet_01v8 L=150000U W=140000U AS=16800000000P
+ AD=21875000000P PS=380000U PD=460000U
* device instance $14 r0 *1 56.705,2.65 nfet_01v8
M$14 167 484 3341 167 nfet_01v8 L=150000U W=210000U AS=21875000000P
+ AD=51200000000P PS=460000U PD=775000U
* device instance $15 r0 *1 56.705,3.04 nfet_01v8
M$15 484 3341 167 167 nfet_01v8 L=150000U W=210000U AS=51200000000P
+ AD=21875000000P PS=775000U PD=460000U
* device instance $16 r0 *1 56.74,3.44 nfet_01v8
M$16 82 133 484 167 nfet_01v8 L=150000U W=140000U AS=21875000000P
+ AD=16800000000P PS=460000U PD=380000U
* device instance $17 r0 *1 45.84,2.25 nfet_01v8
M$17 3229 133 65 167 nfet_01v8 L=150000U W=140000U AS=16800000000P
+ AD=21875000000P PS=380000U PD=460000U
* device instance $18 r0 *1 45.805,2.65 nfet_01v8
M$18 167 409 3229 167 nfet_01v8 L=150000U W=210000U AS=21875000000P
+ AD=51200000000P PS=460000U PD=775000U
* device instance $19 r0 *1 45.805,3.04 nfet_01v8
M$19 409 3229 167 167 nfet_01v8 L=150000U W=210000U AS=51200000000P
+ AD=21875000000P PS=775000U PD=460000U
* device instance $20 r0 *1 45.84,3.44 nfet_01v8
M$20 66 133 409 167 nfet_01v8 L=150000U W=140000U AS=21875000000P
+ AD=16800000000P PS=460000U PD=380000U
* device instance $21 r0 *1 34.94,2.25 nfet_01v8
M$21 290 133 49 167 nfet_01v8 L=150000U W=140000U AS=16800000000P
+ AD=21875000000P PS=380000U PD=460000U
* device instance $22 r0 *1 34.905,2.65 nfet_01v8
M$22 167 444 290 167 nfet_01v8 L=150000U W=210000U AS=21875000000P
+ AD=51200000000P PS=460000U PD=775000U
* device instance $23 r0 *1 34.905,3.04 nfet_01v8
M$23 444 290 167 167 nfet_01v8 L=150000U W=210000U AS=51200000000P
+ AD=21875000000P PS=775000U PD=460000U
* device instance $24 r0 *1 34.94,3.44 nfet_01v8
M$24 50 133 444 167 nfet_01v8 L=150000U W=140000U AS=21875000000P
+ AD=16800000000P PS=460000U PD=380000U
* device instance $25 r0 *1 24.04,2.25 nfet_01v8
M$25 345 133 33 167 nfet_01v8 L=150000U W=140000U AS=16800000000P
+ AD=21875000000P PS=380000U PD=460000U
* device instance $26 r0 *1 24.005,2.65 nfet_01v8
M$26 167 555 345 167 nfet_01v8 L=150000U W=210000U AS=21875000000P
+ AD=51200000000P PS=460000U PD=775000U
* device instance $27 r0 *1 24.005,3.04 nfet_01v8
M$27 555 345 167 167 nfet_01v8 L=150000U W=210000U AS=51200000000P
+ AD=21875000000P PS=775000U PD=460000U
* device instance $28 r0 *1 24.04,3.44 nfet_01v8
M$28 34 133 555 167 nfet_01v8 L=150000U W=140000U AS=21875000000P
+ AD=16800000000P PS=460000U PD=380000U
* device instance $29 r0 *1 2.24,2.25 nfet_01v8
M$29 246 133 1 167 nfet_01v8 L=150000U W=140000U AS=16800000000P
+ AD=21875000000P PS=380000U PD=460000U
* device instance $30 r0 *1 2.205,2.65 nfet_01v8
M$30 167 356 246 167 nfet_01v8 L=150000U W=210000U AS=21875000000P
+ AD=51200000000P PS=460000U PD=775000U
* device instance $31 r0 *1 2.205,3.04 nfet_01v8
M$31 356 246 167 167 nfet_01v8 L=150000U W=210000U AS=51200000000P
+ AD=21875000000P PS=775000U PD=460000U
* device instance $32 r0 *1 2.24,3.44 nfet_01v8
M$32 2 133 356 167 nfet_01v8 L=150000U W=140000U AS=21875000000P
+ AD=16800000000P PS=460000U PD=380000U
* device instance $33 r0 *1 13.14,2.25 nfet_01v8
M$33 251 133 17 167 nfet_01v8 L=150000U W=140000U AS=16800000000P
+ AD=21875000000P PS=380000U PD=460000U
* device instance $34 r0 *1 13.105,2.65 nfet_01v8
M$34 167 368 251 167 nfet_01v8 L=150000U W=210000U AS=21875000000P
+ AD=51200000000P PS=460000U PD=775000U
* device instance $35 r0 *1 13.105,3.04 nfet_01v8
M$35 368 251 167 167 nfet_01v8 L=150000U W=210000U AS=51200000000P
+ AD=21875000000P PS=775000U PD=460000U
* device instance $36 r0 *1 13.14,3.44 nfet_01v8
M$36 18 133 368 167 nfet_01v8 L=150000U W=140000U AS=21875000000P
+ AD=16800000000P PS=460000U PD=380000U
* device instance $37 r0 *1 91.26,37.01 nfet_01v8
M$37 3877 150 131 167 nfet_01v8 L=150000U W=140000U AS=16800000000P
+ AD=21875000000P PS=380000U PD=460000U
* device instance $38 r0 *1 91.295,37.41 nfet_01v8
M$38 167 4065 3877 167 nfet_01v8 L=150000U W=210000U AS=21875000000P
+ AD=51200000000P PS=460000U PD=775000U
* device instance $39 r0 *1 91.295,37.8 nfet_01v8
M$39 4065 3877 167 167 nfet_01v8 L=150000U W=210000U AS=51200000000P
+ AD=21875000000P PS=775000U PD=460000U
* device instance $40 r0 *1 91.26,38.2 nfet_01v8
M$40 132 150 4065 167 nfet_01v8 L=150000U W=140000U AS=21875000000P
+ AD=16800000000P PS=460000U PD=380000U
* device instance $41 r0 *1 91.26,38.59 nfet_01v8
M$41 4419 151 132 167 nfet_01v8 L=150000U W=140000U AS=16800000000P
+ AD=21875000000P PS=380000U PD=460000U
* device instance $42 r0 *1 91.295,38.99 nfet_01v8
M$42 167 3858 4419 167 nfet_01v8 L=150000U W=210000U AS=21875000000P
+ AD=51200000000P PS=460000U PD=775000U
* device instance $43 r0 *1 91.295,39.38 nfet_01v8
M$43 3858 4419 167 167 nfet_01v8 L=150000U W=210000U AS=51200000000P
+ AD=21875000000P PS=775000U PD=460000U
* device instance $44 r0 *1 91.26,39.78 nfet_01v8
M$44 131 151 3858 167 nfet_01v8 L=150000U W=140000U AS=21875000000P
+ AD=16800000000P PS=460000U PD=380000U
* device instance $45 r0 *1 91.26,40.17 nfet_01v8
M$45 3894 152 131 167 nfet_01v8 L=150000U W=140000U AS=16800000000P
+ AD=21875000000P PS=380000U PD=460000U
* device instance $46 r0 *1 91.295,40.57 nfet_01v8
M$46 167 4082 3894 167 nfet_01v8 L=150000U W=210000U AS=21875000000P
+ AD=51200000000P PS=460000U PD=775000U
* device instance $47 r0 *1 91.295,40.96 nfet_01v8
M$47 4082 3894 167 167 nfet_01v8 L=150000U W=210000U AS=51200000000P
+ AD=21875000000P PS=775000U PD=460000U
* device instance $48 r0 *1 91.26,41.36 nfet_01v8
M$48 132 152 4082 167 nfet_01v8 L=150000U W=140000U AS=21875000000P
+ AD=16800000000P PS=460000U PD=380000U
* device instance $49 r0 *1 91.26,41.75 nfet_01v8
M$49 3891 153 132 167 nfet_01v8 L=150000U W=140000U AS=16800000000P
+ AD=21875000000P PS=380000U PD=460000U
* device instance $50 r0 *1 91.295,42.15 nfet_01v8
M$50 167 4079 3891 167 nfet_01v8 L=150000U W=210000U AS=21875000000P
+ AD=51200000000P PS=460000U PD=775000U
* device instance $51 r0 *1 91.295,42.54 nfet_01v8
M$51 4079 3891 167 167 nfet_01v8 L=150000U W=210000U AS=51200000000P
+ AD=21875000000P PS=775000U PD=460000U
* device instance $52 r0 *1 91.26,42.94 nfet_01v8
M$52 131 153 4079 167 nfet_01v8 L=150000U W=140000U AS=21875000000P
+ AD=16800000000P PS=460000U PD=380000U
* device instance $53 r0 *1 91.26,29.11 nfet_01v8
M$53 3896 146 131 167 nfet_01v8 L=150000U W=140000U AS=16800000000P
+ AD=21875000000P PS=380000U PD=460000U
* device instance $54 r0 *1 91.295,29.51 nfet_01v8
M$54 167 4084 3896 167 nfet_01v8 L=150000U W=210000U AS=21875000000P
+ AD=51200000000P PS=460000U PD=775000U
* device instance $55 r0 *1 91.295,29.9 nfet_01v8
M$55 4084 3896 167 167 nfet_01v8 L=150000U W=210000U AS=51200000000P
+ AD=21875000000P PS=775000U PD=460000U
* device instance $56 r0 *1 91.26,30.3 nfet_01v8
M$56 132 146 4084 167 nfet_01v8 L=150000U W=140000U AS=21875000000P
+ AD=16800000000P PS=460000U PD=380000U
* device instance $57 r0 *1 91.26,30.69 nfet_01v8
M$57 4308 147 132 167 nfet_01v8 L=150000U W=140000U AS=16800000000P
+ AD=21875000000P PS=380000U PD=460000U
* device instance $58 r0 *1 91.295,31.09 nfet_01v8
M$58 167 4135 4308 167 nfet_01v8 L=150000U W=210000U AS=21875000000P
+ AD=51200000000P PS=460000U PD=775000U
* device instance $59 r0 *1 91.295,31.48 nfet_01v8
M$59 4135 4308 167 167 nfet_01v8 L=150000U W=210000U AS=51200000000P
+ AD=21875000000P PS=775000U PD=460000U
* device instance $60 r0 *1 91.26,31.88 nfet_01v8
M$60 131 147 4135 167 nfet_01v8 L=150000U W=140000U AS=21875000000P
+ AD=16800000000P PS=460000U PD=380000U
* device instance $61 r0 *1 91.26,32.27 nfet_01v8
M$61 3938 148 131 167 nfet_01v8 L=150000U W=140000U AS=16800000000P
+ AD=21875000000P PS=380000U PD=460000U
* device instance $62 r0 *1 91.295,32.67 nfet_01v8
M$62 167 4133 3938 167 nfet_01v8 L=150000U W=210000U AS=21875000000P
+ AD=51200000000P PS=460000U PD=775000U
* device instance $63 r0 *1 91.295,33.06 nfet_01v8
M$63 4133 3938 167 167 nfet_01v8 L=150000U W=210000U AS=51200000000P
+ AD=21875000000P PS=775000U PD=460000U
* device instance $64 r0 *1 91.26,33.46 nfet_01v8
M$64 132 148 4133 167 nfet_01v8 L=150000U W=140000U AS=21875000000P
+ AD=16800000000P PS=460000U PD=380000U
* device instance $65 r0 *1 91.26,33.85 nfet_01v8
M$65 3937 149 132 167 nfet_01v8 L=150000U W=140000U AS=16800000000P
+ AD=21875000000P PS=380000U PD=460000U
* device instance $66 r0 *1 91.295,34.25 nfet_01v8
M$66 167 4132 3937 167 nfet_01v8 L=150000U W=210000U AS=21875000000P
+ AD=51200000000P PS=460000U PD=775000U
* device instance $67 r0 *1 91.295,34.64 nfet_01v8
M$67 4132 3937 167 167 nfet_01v8 L=150000U W=210000U AS=51200000000P
+ AD=21875000000P PS=775000U PD=460000U
* device instance $68 r0 *1 91.26,35.04 nfet_01v8
M$68 131 149 4132 167 nfet_01v8 L=150000U W=140000U AS=21875000000P
+ AD=16800000000P PS=460000U PD=380000U
* device instance $69 r0 *1 91.26,44.91 nfet_01v8
M$69 3996 154 131 167 nfet_01v8 L=150000U W=140000U AS=16800000000P
+ AD=21875000000P PS=380000U PD=460000U
* device instance $70 r0 *1 91.295,45.31 nfet_01v8
M$70 167 4204 3996 167 nfet_01v8 L=150000U W=210000U AS=21875000000P
+ AD=51200000000P PS=460000U PD=775000U
* device instance $71 r0 *1 91.295,45.7 nfet_01v8
M$71 4204 3996 167 167 nfet_01v8 L=150000U W=210000U AS=51200000000P
+ AD=21875000000P PS=775000U PD=460000U
* device instance $72 r0 *1 91.26,46.1 nfet_01v8
M$72 132 154 4204 167 nfet_01v8 L=150000U W=140000U AS=21875000000P
+ AD=16800000000P PS=460000U PD=380000U
* device instance $73 r0 *1 91.26,46.49 nfet_01v8
M$73 4500 155 132 167 nfet_01v8 L=150000U W=140000U AS=16800000000P
+ AD=21875000000P PS=380000U PD=460000U
* device instance $74 r0 *1 91.295,46.89 nfet_01v8
M$74 167 4177 4500 167 nfet_01v8 L=150000U W=210000U AS=21875000000P
+ AD=51200000000P PS=460000U PD=775000U
* device instance $75 r0 *1 91.295,47.28 nfet_01v8
M$75 4177 4500 167 167 nfet_01v8 L=150000U W=210000U AS=51200000000P
+ AD=21875000000P PS=775000U PD=460000U
* device instance $76 r0 *1 91.26,47.68 nfet_01v8
M$76 131 155 4177 167 nfet_01v8 L=150000U W=140000U AS=21875000000P
+ AD=16800000000P PS=460000U PD=380000U
* device instance $77 r0 *1 91.26,48.07 nfet_01v8
M$77 3760 156 131 167 nfet_01v8 L=150000U W=140000U AS=16800000000P
+ AD=21875000000P PS=380000U PD=460000U
* device instance $78 r0 *1 91.295,48.47 nfet_01v8
M$78 167 3801 3760 167 nfet_01v8 L=150000U W=210000U AS=21875000000P
+ AD=51200000000P PS=460000U PD=775000U
* device instance $79 r0 *1 91.295,48.86 nfet_01v8
M$79 3801 3760 167 167 nfet_01v8 L=150000U W=210000U AS=51200000000P
+ AD=21875000000P PS=775000U PD=460000U
* device instance $80 r0 *1 91.26,49.26 nfet_01v8
M$80 132 156 3801 167 nfet_01v8 L=150000U W=140000U AS=21875000000P
+ AD=16800000000P PS=460000U PD=380000U
* device instance $81 r0 *1 91.26,49.65 nfet_01v8
M$81 3984 157 132 167 nfet_01v8 L=150000U W=140000U AS=16800000000P
+ AD=21875000000P PS=380000U PD=460000U
* device instance $82 r0 *1 91.295,50.05 nfet_01v8
M$82 167 4190 3984 167 nfet_01v8 L=150000U W=210000U AS=21875000000P
+ AD=51200000000P PS=460000U PD=775000U
* device instance $83 r0 *1 91.295,50.44 nfet_01v8
M$83 4190 3984 167 167 nfet_01v8 L=150000U W=210000U AS=51200000000P
+ AD=21875000000P PS=775000U PD=460000U
* device instance $84 r0 *1 91.26,50.84 nfet_01v8
M$84 131 157 4190 167 nfet_01v8 L=150000U W=140000U AS=21875000000P
+ AD=16800000000P PS=460000U PD=380000U
* device instance $85 r0 *1 91.26,21.21 nfet_01v8
M$85 3919 142 131 167 nfet_01v8 L=150000U W=140000U AS=16800000000P
+ AD=21875000000P PS=380000U PD=460000U
* device instance $86 r0 *1 91.295,21.61 nfet_01v8
M$86 167 4112 3919 167 nfet_01v8 L=150000U W=210000U AS=21875000000P
+ AD=51200000000P PS=460000U PD=775000U
* device instance $87 r0 *1 91.295,22 nfet_01v8
M$87 4112 3919 167 167 nfet_01v8 L=150000U W=210000U AS=51200000000P
+ AD=21875000000P PS=775000U PD=460000U
* device instance $88 r0 *1 91.26,22.4 nfet_01v8
M$88 132 142 4112 167 nfet_01v8 L=150000U W=140000U AS=21875000000P
+ AD=16800000000P PS=460000U PD=380000U
* device instance $89 r0 *1 91.26,22.79 nfet_01v8
M$89 4366 143 132 167 nfet_01v8 L=150000U W=140000U AS=16800000000P
+ AD=21875000000P PS=380000U PD=460000U
* device instance $90 r0 *1 91.295,23.19 nfet_01v8
M$90 167 3856 4366 167 nfet_01v8 L=150000U W=210000U AS=21875000000P
+ AD=51200000000P PS=460000U PD=775000U
* device instance $91 r0 *1 91.295,23.58 nfet_01v8
M$91 3856 4366 167 167 nfet_01v8 L=150000U W=210000U AS=51200000000P
+ AD=21875000000P PS=775000U PD=460000U
* device instance $92 r0 *1 91.26,23.98 nfet_01v8
M$92 131 143 3856 167 nfet_01v8 L=150000U W=140000U AS=21875000000P
+ AD=16800000000P PS=460000U PD=380000U
* device instance $93 r0 *1 91.26,24.37 nfet_01v8
M$93 3790 144 131 167 nfet_01v8 L=150000U W=140000U AS=16800000000P
+ AD=21875000000P PS=380000U PD=460000U
* device instance $94 r0 *1 91.295,24.77 nfet_01v8
M$94 167 3865 3790 167 nfet_01v8 L=150000U W=210000U AS=21875000000P
+ AD=51200000000P PS=460000U PD=775000U
* device instance $95 r0 *1 91.295,25.16 nfet_01v8
M$95 3865 3790 167 167 nfet_01v8 L=150000U W=210000U AS=51200000000P
+ AD=21875000000P PS=775000U PD=460000U
* device instance $96 r0 *1 91.26,25.56 nfet_01v8
M$96 132 144 3865 167 nfet_01v8 L=150000U W=140000U AS=21875000000P
+ AD=16800000000P PS=460000U PD=380000U
* device instance $97 r0 *1 91.26,25.95 nfet_01v8
M$97 3910 145 132 167 nfet_01v8 L=150000U W=140000U AS=16800000000P
+ AD=21875000000P PS=380000U PD=460000U
* device instance $98 r0 *1 91.295,26.35 nfet_01v8
M$98 167 4100 3910 167 nfet_01v8 L=150000U W=210000U AS=21875000000P
+ AD=51200000000P PS=460000U PD=775000U
* device instance $99 r0 *1 91.295,26.74 nfet_01v8
M$99 4100 3910 167 167 nfet_01v8 L=150000U W=210000U AS=51200000000P
+ AD=21875000000P PS=775000U PD=460000U
* device instance $100 r0 *1 91.26,27.14 nfet_01v8
M$100 131 145 4100 167 nfet_01v8 L=150000U W=140000U AS=21875000000P
+ AD=16800000000P PS=460000U PD=380000U
* device instance $101 r0 *1 91.26,13.31 nfet_01v8
M$101 4033 138 131 167 nfet_01v8 L=150000U W=140000U AS=16800000000P
+ AD=21875000000P PS=380000U PD=460000U
* device instance $102 r0 *1 91.295,13.71 nfet_01v8
M$102 167 4248 4033 167 nfet_01v8 L=150000U W=210000U AS=21875000000P
+ AD=51200000000P PS=460000U PD=775000U
* device instance $103 r0 *1 91.295,14.1 nfet_01v8
M$103 4248 4033 167 167 nfet_01v8 L=150000U W=210000U AS=51200000000P
+ AD=21875000000P PS=775000U PD=460000U
* device instance $104 r0 *1 91.26,14.5 nfet_01v8
M$104 132 138 4248 167 nfet_01v8 L=150000U W=140000U AS=21875000000P
+ AD=16800000000P PS=460000U PD=380000U
* device instance $105 r0 *1 91.26,14.89 nfet_01v8
M$105 4320 139 132 167 nfet_01v8 L=150000U W=140000U AS=16800000000P
+ AD=21875000000P PS=380000U PD=460000U
* device instance $106 r0 *1 91.295,15.29 nfet_01v8
M$106 167 4269 4320 167 nfet_01v8 L=150000U W=210000U AS=21875000000P
+ AD=51200000000P PS=460000U PD=775000U
* device instance $107 r0 *1 91.295,15.68 nfet_01v8
M$107 4269 4320 167 167 nfet_01v8 L=150000U W=210000U AS=51200000000P
+ AD=21875000000P PS=775000U PD=460000U
* device instance $108 r0 *1 91.26,16.08 nfet_01v8
M$108 131 139 4269 167 nfet_01v8 L=150000U W=140000U AS=21875000000P
+ AD=16800000000P PS=460000U PD=380000U
* device instance $109 r0 *1 91.26,16.47 nfet_01v8
M$109 4001 140 131 167 nfet_01v8 L=150000U W=140000U AS=16800000000P
+ AD=21875000000P PS=380000U PD=460000U
* device instance $110 r0 *1 91.295,16.87 nfet_01v8
M$110 167 4212 4001 167 nfet_01v8 L=150000U W=210000U AS=21875000000P
+ AD=51200000000P PS=460000U PD=775000U
* device instance $111 r0 *1 91.295,17.26 nfet_01v8
M$111 4212 4001 167 167 nfet_01v8 L=150000U W=210000U AS=51200000000P
+ AD=21875000000P PS=775000U PD=460000U
* device instance $112 r0 *1 91.26,17.66 nfet_01v8
M$112 132 140 4212 167 nfet_01v8 L=150000U W=140000U AS=21875000000P
+ AD=16800000000P PS=460000U PD=380000U
* device instance $113 r0 *1 91.26,18.05 nfet_01v8
M$113 4055 141 132 167 nfet_01v8 L=150000U W=140000U AS=16800000000P
+ AD=21875000000P PS=380000U PD=460000U
* device instance $114 r0 *1 91.295,18.45 nfet_01v8
M$114 167 4274 4055 167 nfet_01v8 L=150000U W=210000U AS=21875000000P
+ AD=51200000000P PS=460000U PD=775000U
* device instance $115 r0 *1 91.295,18.84 nfet_01v8
M$115 4274 4055 167 167 nfet_01v8 L=150000U W=210000U AS=51200000000P
+ AD=21875000000P PS=775000U PD=460000U
* device instance $116 r0 *1 91.26,19.24 nfet_01v8
M$116 131 141 4274 167 nfet_01v8 L=150000U W=140000U AS=21875000000P
+ AD=16800000000P PS=460000U PD=380000U
* device instance $117 r0 *1 91.26,5.41 nfet_01v8
M$117 4040 134 131 167 nfet_01v8 L=150000U W=140000U AS=16800000000P
+ AD=21875000000P PS=380000U PD=460000U
* device instance $118 r0 *1 91.295,5.81 nfet_01v8
M$118 167 4256 4040 167 nfet_01v8 L=150000U W=210000U AS=21875000000P
+ AD=51200000000P PS=460000U PD=775000U
* device instance $119 r0 *1 91.295,6.2 nfet_01v8
M$119 4256 4040 167 167 nfet_01v8 L=150000U W=210000U AS=51200000000P
+ AD=21875000000P PS=775000U PD=460000U
* device instance $120 r0 *1 91.26,6.6 nfet_01v8
M$120 132 134 4256 167 nfet_01v8 L=150000U W=140000U AS=21875000000P
+ AD=16800000000P PS=460000U PD=380000U
* device instance $121 r0 *1 91.26,6.99 nfet_01v8
M$121 4337 135 132 167 nfet_01v8 L=150000U W=140000U AS=16800000000P
+ AD=21875000000P PS=380000U PD=460000U
* device instance $122 r0 *1 91.295,7.39 nfet_01v8
M$122 167 3868 4337 167 nfet_01v8 L=150000U W=210000U AS=21875000000P
+ AD=51200000000P PS=460000U PD=775000U
* device instance $123 r0 *1 91.295,7.78 nfet_01v8
M$123 3868 4337 167 167 nfet_01v8 L=150000U W=210000U AS=51200000000P
+ AD=21875000000P PS=775000U PD=460000U
* device instance $124 r0 *1 91.26,8.18 nfet_01v8
M$124 131 135 3868 167 nfet_01v8 L=150000U W=140000U AS=21875000000P
+ AD=16800000000P PS=460000U PD=380000U
* device instance $125 r0 *1 91.26,8.57 nfet_01v8
M$125 4036 136 131 167 nfet_01v8 L=150000U W=140000U AS=16800000000P
+ AD=21875000000P PS=380000U PD=460000U
* device instance $126 r0 *1 91.295,8.97 nfet_01v8
M$126 167 4251 4036 167 nfet_01v8 L=150000U W=210000U AS=21875000000P
+ AD=51200000000P PS=460000U PD=775000U
* device instance $127 r0 *1 91.295,9.36 nfet_01v8
M$127 4251 4036 167 167 nfet_01v8 L=150000U W=210000U AS=51200000000P
+ AD=21875000000P PS=775000U PD=460000U
* device instance $128 r0 *1 91.26,9.76 nfet_01v8
M$128 132 136 4251 167 nfet_01v8 L=150000U W=140000U AS=21875000000P
+ AD=16800000000P PS=460000U PD=380000U
* device instance $129 r0 *1 91.26,10.15 nfet_01v8
M$129 4016 137 132 167 nfet_01v8 L=150000U W=140000U AS=16800000000P
+ AD=21875000000P PS=380000U PD=460000U
* device instance $130 r0 *1 91.295,10.55 nfet_01v8
M$130 167 4229 4016 167 nfet_01v8 L=150000U W=210000U AS=21875000000P
+ AD=51200000000P PS=460000U PD=775000U
* device instance $131 r0 *1 91.295,10.94 nfet_01v8
M$131 4229 4016 167 167 nfet_01v8 L=150000U W=210000U AS=51200000000P
+ AD=21875000000P PS=775000U PD=460000U
* device instance $132 r0 *1 91.26,11.34 nfet_01v8
M$132 131 137 4229 167 nfet_01v8 L=150000U W=140000U AS=21875000000P
+ AD=16800000000P PS=460000U PD=380000U
* device instance $133 r0 *1 91.26,52.81 nfet_01v8
M$133 4041 158 131 167 nfet_01v8 L=150000U W=140000U AS=16800000000P
+ AD=21875000000P PS=380000U PD=460000U
* device instance $134 r0 *1 91.295,53.21 nfet_01v8
M$134 167 4258 4041 167 nfet_01v8 L=150000U W=210000U AS=21875000000P
+ AD=51200000000P PS=460000U PD=775000U
* device instance $135 r0 *1 91.295,53.6 nfet_01v8
M$135 4258 4041 167 167 nfet_01v8 L=150000U W=210000U AS=51200000000P
+ AD=21875000000P PS=775000U PD=460000U
* device instance $136 r0 *1 91.26,54 nfet_01v8
M$136 132 158 4258 167 nfet_01v8 L=150000U W=140000U AS=21875000000P
+ AD=16800000000P PS=460000U PD=380000U
* device instance $137 r0 *1 91.26,54.39 nfet_01v8
M$137 4458 159 132 167 nfet_01v8 L=150000U W=140000U AS=16800000000P
+ AD=21875000000P PS=380000U PD=460000U
* device instance $138 r0 *1 91.295,54.79 nfet_01v8
M$138 167 3835 4458 167 nfet_01v8 L=150000U W=210000U AS=21875000000P
+ AD=51200000000P PS=460000U PD=775000U
* device instance $139 r0 *1 91.295,55.18 nfet_01v8
M$139 3835 4458 167 167 nfet_01v8 L=150000U W=210000U AS=51200000000P
+ AD=21875000000P PS=775000U PD=460000U
* device instance $140 r0 *1 91.26,55.58 nfet_01v8
M$140 131 159 3835 167 nfet_01v8 L=150000U W=140000U AS=21875000000P
+ AD=16800000000P PS=460000U PD=380000U
* device instance $141 r0 *1 91.26,55.97 nfet_01v8
M$141 4026 160 131 167 nfet_01v8 L=150000U W=140000U AS=16800000000P
+ AD=21875000000P PS=380000U PD=460000U
* device instance $142 r0 *1 91.295,56.37 nfet_01v8
M$142 167 4239 4026 167 nfet_01v8 L=150000U W=210000U AS=21875000000P
+ AD=51200000000P PS=460000U PD=775000U
* device instance $143 r0 *1 91.295,56.76 nfet_01v8
M$143 4239 4026 167 167 nfet_01v8 L=150000U W=210000U AS=51200000000P
+ AD=21875000000P PS=775000U PD=460000U
* device instance $144 r0 *1 91.26,57.16 nfet_01v8
M$144 132 160 4239 167 nfet_01v8 L=150000U W=140000U AS=21875000000P
+ AD=16800000000P PS=460000U PD=380000U
* device instance $145 r0 *1 91.26,57.55 nfet_01v8
M$145 4053 161 132 167 nfet_01v8 L=150000U W=140000U AS=16800000000P
+ AD=21875000000P PS=380000U PD=460000U
* device instance $146 r0 *1 91.295,57.95 nfet_01v8
M$146 167 4272 4053 167 nfet_01v8 L=150000U W=210000U AS=21875000000P
+ AD=51200000000P PS=460000U PD=775000U
* device instance $147 r0 *1 91.295,58.34 nfet_01v8
M$147 4272 4053 167 167 nfet_01v8 L=150000U W=210000U AS=51200000000P
+ AD=21875000000P PS=775000U PD=460000U
* device instance $148 r0 *1 91.26,58.74 nfet_01v8
M$148 131 161 4272 167 nfet_01v8 L=150000U W=140000U AS=21875000000P
+ AD=16800000000P PS=460000U PD=380000U
* device instance $149 r0 *1 25.86,60.71 nfet_01v8
M$149 3924 162 35 167 nfet_01v8 L=150000U W=140000U AS=16800000000P
+ AD=21875000000P PS=380000U PD=460000U
* device instance $150 r0 *1 25.895,61.11 nfet_01v8
M$150 167 4117 3924 167 nfet_01v8 L=150000U W=210000U AS=21875000000P
+ AD=51200000000P PS=460000U PD=775000U
* device instance $151 r0 *1 25.895,61.5 nfet_01v8
M$151 4117 3924 167 167 nfet_01v8 L=150000U W=210000U AS=51200000000P
+ AD=21875000000P PS=775000U PD=460000U
* device instance $152 r0 *1 25.86,61.9 nfet_01v8
M$152 36 162 4117 167 nfet_01v8 L=150000U W=140000U AS=21875000000P
+ AD=16800000000P PS=460000U PD=380000U
* device instance $153 r0 *1 25.86,62.29 nfet_01v8
M$153 4465 163 36 167 nfet_01v8 L=150000U W=140000U AS=16800000000P
+ AD=21875000000P PS=380000U PD=460000U
* device instance $154 r0 *1 25.895,62.69 nfet_01v8
M$154 167 4224 4465 167 nfet_01v8 L=150000U W=210000U AS=21875000000P
+ AD=51200000000P PS=460000U PD=775000U
* device instance $155 r0 *1 25.895,63.08 nfet_01v8
M$155 4224 4465 167 167 nfet_01v8 L=150000U W=210000U AS=51200000000P
+ AD=21875000000P PS=775000U PD=460000U
* device instance $156 r0 *1 25.86,63.48 nfet_01v8
M$156 35 163 4224 167 nfet_01v8 L=150000U W=140000U AS=21875000000P
+ AD=16800000000P PS=460000U PD=380000U
* device instance $157 r0 *1 25.86,63.87 nfet_01v8
M$157 3767 164 35 167 nfet_01v8 L=150000U W=140000U AS=16800000000P
+ AD=21875000000P PS=380000U PD=460000U
* device instance $158 r0 *1 25.895,64.27 nfet_01v8
M$158 167 3813 3767 167 nfet_01v8 L=150000U W=210000U AS=21875000000P
+ AD=51200000000P PS=460000U PD=775000U
* device instance $159 r0 *1 25.895,64.66 nfet_01v8
M$159 3813 3767 167 167 nfet_01v8 L=150000U W=210000U AS=51200000000P
+ AD=21875000000P PS=775000U PD=460000U
* device instance $160 r0 *1 25.86,65.06 nfet_01v8
M$160 36 164 3813 167 nfet_01v8 L=150000U W=140000U AS=21875000000P
+ AD=16800000000P PS=460000U PD=380000U
* device instance $161 r0 *1 25.86,65.45 nfet_01v8
M$161 4015 165 36 167 nfet_01v8 L=150000U W=140000U AS=16800000000P
+ AD=21875000000P PS=380000U PD=460000U
* device instance $162 r0 *1 25.895,65.85 nfet_01v8
M$162 167 4228 4015 167 nfet_01v8 L=150000U W=210000U AS=21875000000P
+ AD=51200000000P PS=460000U PD=775000U
* device instance $163 r0 *1 25.895,66.24 nfet_01v8
M$163 4228 4015 167 167 nfet_01v8 L=150000U W=210000U AS=51200000000P
+ AD=21875000000P PS=775000U PD=460000U
* device instance $164 r0 *1 25.86,66.64 nfet_01v8
M$164 35 165 4228 167 nfet_01v8 L=150000U W=140000U AS=21875000000P
+ AD=16800000000P PS=460000U PD=380000U
* device instance $165 r0 *1 80.36,37.01 nfet_01v8
M$165 3926 150 115 167 nfet_01v8 L=150000U W=140000U AS=16800000000P
+ AD=21875000000P PS=380000U PD=460000U
* device instance $166 r0 *1 80.395,37.41 nfet_01v8
M$166 167 4119 3926 167 nfet_01v8 L=150000U W=210000U AS=21875000000P
+ AD=51200000000P PS=460000U PD=775000U
* device instance $167 r0 *1 80.395,37.8 nfet_01v8
M$167 4119 3926 167 167 nfet_01v8 L=150000U W=210000U AS=51200000000P
+ AD=21875000000P PS=775000U PD=460000U
* device instance $168 r0 *1 80.36,38.2 nfet_01v8
M$168 116 150 4119 167 nfet_01v8 L=150000U W=140000U AS=21875000000P
+ AD=16800000000P PS=460000U PD=380000U
* device instance $169 r0 *1 80.36,38.59 nfet_01v8
M$169 4523 151 116 167 nfet_01v8 L=150000U W=140000U AS=16800000000P
+ AD=21875000000P PS=380000U PD=460000U
* device instance $170 r0 *1 80.395,38.99 nfet_01v8
M$170 167 3803 4523 167 nfet_01v8 L=150000U W=210000U AS=21875000000P
+ AD=51200000000P PS=460000U PD=775000U
* device instance $171 r0 *1 80.395,39.38 nfet_01v8
M$171 3803 4523 167 167 nfet_01v8 L=150000U W=210000U AS=51200000000P
+ AD=21875000000P PS=775000U PD=460000U
* device instance $172 r0 *1 80.36,39.78 nfet_01v8
M$172 115 151 3803 167 nfet_01v8 L=150000U W=140000U AS=21875000000P
+ AD=16800000000P PS=460000U PD=380000U
* device instance $173 r0 *1 80.36,40.17 nfet_01v8
M$173 3761 152 115 167 nfet_01v8 L=150000U W=140000U AS=16800000000P
+ AD=21875000000P PS=380000U PD=460000U
* device instance $174 r0 *1 80.395,40.57 nfet_01v8
M$174 167 3802 3761 167 nfet_01v8 L=150000U W=210000U AS=21875000000P
+ AD=51200000000P PS=460000U PD=775000U
* device instance $175 r0 *1 80.395,40.96 nfet_01v8
M$175 3802 3761 167 167 nfet_01v8 L=150000U W=210000U AS=51200000000P
+ AD=21875000000P PS=775000U PD=460000U
* device instance $176 r0 *1 80.36,41.36 nfet_01v8
M$176 116 152 3802 167 nfet_01v8 L=150000U W=140000U AS=21875000000P
+ AD=16800000000P PS=460000U PD=380000U
* device instance $177 r0 *1 80.36,41.75 nfet_01v8
M$177 3923 153 116 167 nfet_01v8 L=150000U W=140000U AS=16800000000P
+ AD=21875000000P PS=380000U PD=460000U
* device instance $178 r0 *1 80.395,42.15 nfet_01v8
M$178 167 4116 3923 167 nfet_01v8 L=150000U W=210000U AS=21875000000P
+ AD=51200000000P PS=460000U PD=775000U
* device instance $179 r0 *1 80.395,42.54 nfet_01v8
M$179 4116 3923 167 167 nfet_01v8 L=150000U W=210000U AS=51200000000P
+ AD=21875000000P PS=775000U PD=460000U
* device instance $180 r0 *1 80.36,42.94 nfet_01v8
M$180 115 153 4116 167 nfet_01v8 L=150000U W=140000U AS=21875000000P
+ AD=16800000000P PS=460000U PD=380000U
* device instance $181 r0 *1 69.46,37.01 nfet_01v8
M$181 4049 150 99 167 nfet_01v8 L=150000U W=140000U AS=16800000000P
+ AD=21875000000P PS=380000U PD=460000U
* device instance $182 r0 *1 69.495,37.41 nfet_01v8
M$182 167 4266 4049 167 nfet_01v8 L=150000U W=210000U AS=21875000000P
+ AD=51200000000P PS=460000U PD=775000U
* device instance $183 r0 *1 69.495,37.8 nfet_01v8
M$183 4266 4049 167 167 nfet_01v8 L=150000U W=210000U AS=51200000000P
+ AD=21875000000P PS=775000U PD=460000U
* device instance $184 r0 *1 69.46,38.2 nfet_01v8
M$184 100 150 4266 167 nfet_01v8 L=150000U W=140000U AS=21875000000P
+ AD=16800000000P PS=460000U PD=380000U
* device instance $185 r0 *1 69.46,38.59 nfet_01v8
M$185 4514 151 100 167 nfet_01v8 L=150000U W=140000U AS=16800000000P
+ AD=21875000000P PS=380000U PD=460000U
* device instance $186 r0 *1 69.495,38.99 nfet_01v8
M$186 167 3846 4514 167 nfet_01v8 L=150000U W=210000U AS=21875000000P
+ AD=51200000000P PS=460000U PD=775000U
* device instance $187 r0 *1 69.495,39.38 nfet_01v8
M$187 3846 4514 167 167 nfet_01v8 L=150000U W=210000U AS=51200000000P
+ AD=21875000000P PS=775000U PD=460000U
* device instance $188 r0 *1 69.46,39.78 nfet_01v8
M$188 99 151 3846 167 nfet_01v8 L=150000U W=140000U AS=21875000000P
+ AD=16800000000P PS=460000U PD=380000U
* device instance $189 r0 *1 69.46,40.17 nfet_01v8
M$189 4002 152 99 167 nfet_01v8 L=150000U W=140000U AS=16800000000P
+ AD=21875000000P PS=380000U PD=460000U
* device instance $190 r0 *1 69.495,40.57 nfet_01v8
M$190 167 4213 4002 167 nfet_01v8 L=150000U W=210000U AS=21875000000P
+ AD=51200000000P PS=460000U PD=775000U
* device instance $191 r0 *1 69.495,40.96 nfet_01v8
M$191 4213 4002 167 167 nfet_01v8 L=150000U W=210000U AS=51200000000P
+ AD=21875000000P PS=775000U PD=460000U
* device instance $192 r0 *1 69.46,41.36 nfet_01v8
M$192 100 152 4213 167 nfet_01v8 L=150000U W=140000U AS=21875000000P
+ AD=16800000000P PS=460000U PD=380000U
* device instance $193 r0 *1 69.46,41.75 nfet_01v8
M$193 4023 153 100 167 nfet_01v8 L=150000U W=140000U AS=16800000000P
+ AD=21875000000P PS=380000U PD=460000U
* device instance $194 r0 *1 69.495,42.15 nfet_01v8
M$194 167 4236 4023 167 nfet_01v8 L=150000U W=210000U AS=21875000000P
+ AD=51200000000P PS=460000U PD=775000U
* device instance $195 r0 *1 69.495,42.54 nfet_01v8
M$195 4236 4023 167 167 nfet_01v8 L=150000U W=210000U AS=51200000000P
+ AD=21875000000P PS=775000U PD=460000U
* device instance $196 r0 *1 69.46,42.94 nfet_01v8
M$196 99 153 4236 167 nfet_01v8 L=150000U W=140000U AS=21875000000P
+ AD=16800000000P PS=460000U PD=380000U
* device instance $197 r0 *1 58.56,37.01 nfet_01v8
M$197 3912 150 83 167 nfet_01v8 L=150000U W=140000U AS=16800000000P
+ AD=21875000000P PS=380000U PD=460000U
* device instance $198 r0 *1 58.595,37.41 nfet_01v8
M$198 167 4102 3912 167 nfet_01v8 L=150000U W=210000U AS=21875000000P
+ AD=51200000000P PS=460000U PD=775000U
* device instance $199 r0 *1 58.595,37.8 nfet_01v8
M$199 4102 3912 167 167 nfet_01v8 L=150000U W=210000U AS=51200000000P
+ AD=21875000000P PS=775000U PD=460000U
* device instance $200 r0 *1 58.56,38.2 nfet_01v8
M$200 84 150 4102 167 nfet_01v8 L=150000U W=140000U AS=21875000000P
+ AD=16800000000P PS=460000U PD=380000U
* device instance $201 r0 *1 58.56,38.59 nfet_01v8
M$201 4290 151 84 167 nfet_01v8 L=150000U W=140000U AS=16800000000P
+ AD=21875000000P PS=380000U PD=460000U
* device instance $202 r0 *1 58.595,38.99 nfet_01v8
M$202 167 3862 4290 167 nfet_01v8 L=150000U W=210000U AS=21875000000P
+ AD=51200000000P PS=460000U PD=775000U
* device instance $203 r0 *1 58.595,39.38 nfet_01v8
M$203 3862 4290 167 167 nfet_01v8 L=150000U W=210000U AS=51200000000P
+ AD=21875000000P PS=775000U PD=460000U
* device instance $204 r0 *1 58.56,39.78 nfet_01v8
M$204 83 151 3862 167 nfet_01v8 L=150000U W=140000U AS=21875000000P
+ AD=16800000000P PS=460000U PD=380000U
* device instance $205 r0 *1 58.56,40.17 nfet_01v8
M$205 3792 152 83 167 nfet_01v8 L=150000U W=140000U AS=16800000000P
+ AD=21875000000P PS=380000U PD=460000U
* device instance $206 r0 *1 58.595,40.57 nfet_01v8
M$206 167 3867 3792 167 nfet_01v8 L=150000U W=210000U AS=21875000000P
+ AD=51200000000P PS=460000U PD=775000U
* device instance $207 r0 *1 58.595,40.96 nfet_01v8
M$207 3867 3792 167 167 nfet_01v8 L=150000U W=210000U AS=51200000000P
+ AD=21875000000P PS=775000U PD=460000U
* device instance $208 r0 *1 58.56,41.36 nfet_01v8
M$208 84 152 3867 167 nfet_01v8 L=150000U W=140000U AS=21875000000P
+ AD=16800000000P PS=460000U PD=380000U
* device instance $209 r0 *1 58.56,41.75 nfet_01v8
M$209 3917 153 84 167 nfet_01v8 L=150000U W=140000U AS=16800000000P
+ AD=21875000000P PS=380000U PD=460000U
* device instance $210 r0 *1 58.595,42.15 nfet_01v8
M$210 167 4109 3917 167 nfet_01v8 L=150000U W=210000U AS=21875000000P
+ AD=51200000000P PS=460000U PD=775000U
* device instance $211 r0 *1 58.595,42.54 nfet_01v8
M$211 4109 3917 167 167 nfet_01v8 L=150000U W=210000U AS=51200000000P
+ AD=21875000000P PS=775000U PD=460000U
* device instance $212 r0 *1 58.56,42.94 nfet_01v8
M$212 83 153 4109 167 nfet_01v8 L=150000U W=140000U AS=21875000000P
+ AD=16800000000P PS=460000U PD=380000U
* device instance $213 r0 *1 47.66,37.01 nfet_01v8
M$213 3936 150 67 167 nfet_01v8 L=150000U W=140000U AS=16800000000P
+ AD=21875000000P PS=380000U PD=460000U
* device instance $214 r0 *1 47.695,37.41 nfet_01v8
M$214 167 4131 3936 167 nfet_01v8 L=150000U W=210000U AS=21875000000P
+ AD=51200000000P PS=460000U PD=775000U
* device instance $215 r0 *1 47.695,37.8 nfet_01v8
M$215 4131 3936 167 167 nfet_01v8 L=150000U W=210000U AS=51200000000P
+ AD=21875000000P PS=775000U PD=460000U
* device instance $216 r0 *1 47.66,38.2 nfet_01v8
M$216 68 150 4131 167 nfet_01v8 L=150000U W=140000U AS=21875000000P
+ AD=16800000000P PS=460000U PD=380000U
* device instance $217 r0 *1 47.66,38.59 nfet_01v8
M$217 4303 151 68 167 nfet_01v8 L=150000U W=140000U AS=16800000000P
+ AD=21875000000P PS=380000U PD=460000U
* device instance $218 r0 *1 47.695,38.99 nfet_01v8
M$218 167 3840 4303 167 nfet_01v8 L=150000U W=210000U AS=21875000000P
+ AD=51200000000P PS=460000U PD=775000U
* device instance $219 r0 *1 47.695,39.38 nfet_01v8
M$219 3840 4303 167 167 nfet_01v8 L=150000U W=210000U AS=51200000000P
+ AD=21875000000P PS=775000U PD=460000U
* device instance $220 r0 *1 47.66,39.78 nfet_01v8
M$220 67 151 3840 167 nfet_01v8 L=150000U W=140000U AS=21875000000P
+ AD=16800000000P PS=460000U PD=380000U
* device instance $221 r0 *1 47.66,40.17 nfet_01v8
M$221 3925 152 67 167 nfet_01v8 L=150000U W=140000U AS=16800000000P
+ AD=21875000000P PS=380000U PD=460000U
* device instance $222 r0 *1 47.695,40.57 nfet_01v8
M$222 167 4118 3925 167 nfet_01v8 L=150000U W=210000U AS=21875000000P
+ AD=51200000000P PS=460000U PD=775000U
* device instance $223 r0 *1 47.695,40.96 nfet_01v8
M$223 4118 3925 167 167 nfet_01v8 L=150000U W=210000U AS=51200000000P
+ AD=21875000000P PS=775000U PD=460000U
* device instance $224 r0 *1 47.66,41.36 nfet_01v8
M$224 68 152 4118 167 nfet_01v8 L=150000U W=140000U AS=21875000000P
+ AD=16800000000P PS=460000U PD=380000U
* device instance $225 r0 *1 47.66,41.75 nfet_01v8
M$225 3914 153 68 167 nfet_01v8 L=150000U W=140000U AS=16800000000P
+ AD=21875000000P PS=380000U PD=460000U
* device instance $226 r0 *1 47.695,42.15 nfet_01v8
M$226 167 4105 3914 167 nfet_01v8 L=150000U W=210000U AS=21875000000P
+ AD=51200000000P PS=460000U PD=775000U
* device instance $227 r0 *1 47.695,42.54 nfet_01v8
M$227 4105 3914 167 167 nfet_01v8 L=150000U W=210000U AS=51200000000P
+ AD=21875000000P PS=775000U PD=460000U
* device instance $228 r0 *1 47.66,42.94 nfet_01v8
M$228 67 153 4105 167 nfet_01v8 L=150000U W=140000U AS=21875000000P
+ AD=16800000000P PS=460000U PD=380000U
* device instance $229 r0 *1 69.46,60.71 nfet_01v8
M$229 4044 162 99 167 nfet_01v8 L=150000U W=140000U AS=16800000000P
+ AD=21875000000P PS=380000U PD=460000U
* device instance $230 r0 *1 69.495,61.11 nfet_01v8
M$230 167 4261 4044 167 nfet_01v8 L=150000U W=210000U AS=21875000000P
+ AD=51200000000P PS=460000U PD=775000U
* device instance $231 r0 *1 69.495,61.5 nfet_01v8
M$231 4261 4044 167 167 nfet_01v8 L=150000U W=210000U AS=51200000000P
+ AD=21875000000P PS=775000U PD=460000U
* device instance $232 r0 *1 69.46,61.9 nfet_01v8
M$232 100 162 4261 167 nfet_01v8 L=150000U W=140000U AS=21875000000P
+ AD=16800000000P PS=460000U PD=380000U
* device instance $233 r0 *1 69.46,62.29 nfet_01v8
M$233 4473 163 100 167 nfet_01v8 L=150000U W=140000U AS=16800000000P
+ AD=21875000000P PS=380000U PD=460000U
* device instance $234 r0 *1 69.495,62.69 nfet_01v8
M$234 167 4257 4473 167 nfet_01v8 L=150000U W=210000U AS=21875000000P
+ AD=51200000000P PS=460000U PD=775000U
* device instance $235 r0 *1 69.495,63.08 nfet_01v8
M$235 4257 4473 167 167 nfet_01v8 L=150000U W=210000U AS=51200000000P
+ AD=21875000000P PS=775000U PD=460000U
* device instance $236 r0 *1 69.46,63.48 nfet_01v8
M$236 99 163 4257 167 nfet_01v8 L=150000U W=140000U AS=21875000000P
+ AD=16800000000P PS=460000U PD=380000U
* device instance $237 r0 *1 69.46,63.87 nfet_01v8
M$237 3788 164 99 167 nfet_01v8 L=150000U W=140000U AS=16800000000P
+ AD=21875000000P PS=380000U PD=460000U
* device instance $238 r0 *1 69.495,64.27 nfet_01v8
M$238 167 3861 3788 167 nfet_01v8 L=150000U W=210000U AS=21875000000P
+ AD=51200000000P PS=460000U PD=775000U
* device instance $239 r0 *1 69.495,64.66 nfet_01v8
M$239 3861 3788 167 167 nfet_01v8 L=150000U W=210000U AS=51200000000P
+ AD=21875000000P PS=775000U PD=460000U
* device instance $240 r0 *1 69.46,65.06 nfet_01v8
M$240 100 164 3861 167 nfet_01v8 L=150000U W=140000U AS=21875000000P
+ AD=16800000000P PS=460000U PD=380000U
* device instance $241 r0 *1 69.46,65.45 nfet_01v8
M$241 4020 165 100 167 nfet_01v8 L=150000U W=140000U AS=16800000000P
+ AD=21875000000P PS=380000U PD=460000U
* device instance $242 r0 *1 69.495,65.85 nfet_01v8
M$242 167 4233 4020 167 nfet_01v8 L=150000U W=210000U AS=21875000000P
+ AD=51200000000P PS=460000U PD=775000U
* device instance $243 r0 *1 69.495,66.24 nfet_01v8
M$243 4233 4020 167 167 nfet_01v8 L=150000U W=210000U AS=51200000000P
+ AD=21875000000P PS=775000U PD=460000U
* device instance $244 r0 *1 69.46,66.64 nfet_01v8
M$244 99 165 4233 167 nfet_01v8 L=150000U W=140000U AS=21875000000P
+ AD=16800000000P PS=460000U PD=380000U
* device instance $245 r0 *1 36.76,37.01 nfet_01v8
M$245 4022 150 51 167 nfet_01v8 L=150000U W=140000U AS=16800000000P
+ AD=21875000000P PS=380000U PD=460000U
* device instance $246 r0 *1 36.795,37.41 nfet_01v8
M$246 167 4235 4022 167 nfet_01v8 L=150000U W=210000U AS=21875000000P
+ AD=51200000000P PS=460000U PD=775000U
* device instance $247 r0 *1 36.795,37.8 nfet_01v8
M$247 4235 4022 167 167 nfet_01v8 L=150000U W=210000U AS=51200000000P
+ AD=21875000000P PS=775000U PD=460000U
* device instance $248 r0 *1 36.76,38.2 nfet_01v8
M$248 52 150 4235 167 nfet_01v8 L=150000U W=140000U AS=21875000000P
+ AD=16800000000P PS=460000U PD=380000U
* device instance $249 r0 *1 36.76,38.59 nfet_01v8
M$249 4426 151 52 167 nfet_01v8 L=150000U W=140000U AS=16800000000P
+ AD=21875000000P PS=380000U PD=460000U
* device instance $250 r0 *1 36.795,38.99 nfet_01v8
M$250 167 3859 4426 167 nfet_01v8 L=150000U W=210000U AS=21875000000P
+ AD=51200000000P PS=460000U PD=775000U
* device instance $251 r0 *1 36.795,39.38 nfet_01v8
M$251 3859 4426 167 167 nfet_01v8 L=150000U W=210000U AS=51200000000P
+ AD=21875000000P PS=775000U PD=460000U
* device instance $252 r0 *1 36.76,39.78 nfet_01v8
M$252 51 151 3859 167 nfet_01v8 L=150000U W=140000U AS=21875000000P
+ AD=16800000000P PS=460000U PD=380000U
* device instance $253 r0 *1 36.76,40.17 nfet_01v8
M$253 3765 152 51 167 nfet_01v8 L=150000U W=140000U AS=16800000000P
+ AD=21875000000P PS=380000U PD=460000U
* device instance $254 r0 *1 36.795,40.57 nfet_01v8
M$254 167 3810 3765 167 nfet_01v8 L=150000U W=210000U AS=21875000000P
+ AD=51200000000P PS=460000U PD=775000U
* device instance $255 r0 *1 36.795,40.96 nfet_01v8
M$255 3810 3765 167 167 nfet_01v8 L=150000U W=210000U AS=51200000000P
+ AD=21875000000P PS=775000U PD=460000U
* device instance $256 r0 *1 36.76,41.36 nfet_01v8
M$256 52 152 3810 167 nfet_01v8 L=150000U W=140000U AS=21875000000P
+ AD=16800000000P PS=460000U PD=380000U
* device instance $257 r0 *1 36.76,41.75 nfet_01v8
M$257 4031 153 52 167 nfet_01v8 L=150000U W=140000U AS=16800000000P
+ AD=21875000000P PS=380000U PD=460000U
* device instance $258 r0 *1 36.795,42.15 nfet_01v8
M$258 167 4244 4031 167 nfet_01v8 L=150000U W=210000U AS=21875000000P
+ AD=51200000000P PS=460000U PD=775000U
* device instance $259 r0 *1 36.795,42.54 nfet_01v8
M$259 4244 4031 167 167 nfet_01v8 L=150000U W=210000U AS=51200000000P
+ AD=21875000000P PS=775000U PD=460000U
* device instance $260 r0 *1 36.76,42.94 nfet_01v8
M$260 51 153 4244 167 nfet_01v8 L=150000U W=140000U AS=21875000000P
+ AD=16800000000P PS=460000U PD=380000U
* device instance $261 r0 *1 25.86,37.01 nfet_01v8
M$261 4004 150 35 167 nfet_01v8 L=150000U W=140000U AS=16800000000P
+ AD=21875000000P PS=380000U PD=460000U
* device instance $262 r0 *1 25.895,37.41 nfet_01v8
M$262 167 4215 4004 167 nfet_01v8 L=150000U W=210000U AS=21875000000P
+ AD=51200000000P PS=460000U PD=775000U
* device instance $263 r0 *1 25.895,37.8 nfet_01v8
M$263 4215 4004 167 167 nfet_01v8 L=150000U W=210000U AS=51200000000P
+ AD=21875000000P PS=775000U PD=460000U
* device instance $264 r0 *1 25.86,38.2 nfet_01v8
M$264 36 150 4215 167 nfet_01v8 L=150000U W=140000U AS=21875000000P
+ AD=16800000000P PS=460000U PD=380000U
* device instance $265 r0 *1 25.86,38.59 nfet_01v8
M$265 4423 151 36 167 nfet_01v8 L=150000U W=140000U AS=16800000000P
+ AD=21875000000P PS=380000U PD=460000U
* device instance $266 r0 *1 25.895,38.99 nfet_01v8
M$266 167 4207 4423 167 nfet_01v8 L=150000U W=210000U AS=21875000000P
+ AD=51200000000P PS=460000U PD=775000U
* device instance $267 r0 *1 25.895,39.38 nfet_01v8
M$267 4207 4423 167 167 nfet_01v8 L=150000U W=210000U AS=51200000000P
+ AD=21875000000P PS=775000U PD=460000U
* device instance $268 r0 *1 25.86,39.78 nfet_01v8
M$268 35 151 4207 167 nfet_01v8 L=150000U W=140000U AS=21875000000P
+ AD=16800000000P PS=460000U PD=380000U
* device instance $269 r0 *1 25.86,40.17 nfet_01v8
M$269 4032 152 35 167 nfet_01v8 L=150000U W=140000U AS=16800000000P
+ AD=21875000000P PS=380000U PD=460000U
* device instance $270 r0 *1 25.895,40.57 nfet_01v8
M$270 167 4246 4032 167 nfet_01v8 L=150000U W=210000U AS=21875000000P
+ AD=51200000000P PS=460000U PD=775000U
* device instance $271 r0 *1 25.895,40.96 nfet_01v8
M$271 4246 4032 167 167 nfet_01v8 L=150000U W=210000U AS=51200000000P
+ AD=21875000000P PS=775000U PD=460000U
* device instance $272 r0 *1 25.86,41.36 nfet_01v8
M$272 36 152 4246 167 nfet_01v8 L=150000U W=140000U AS=21875000000P
+ AD=16800000000P PS=460000U PD=380000U
* device instance $273 r0 *1 25.86,41.75 nfet_01v8
M$273 4005 153 36 167 nfet_01v8 L=150000U W=140000U AS=16800000000P
+ AD=21875000000P PS=380000U PD=460000U
* device instance $274 r0 *1 25.895,42.15 nfet_01v8
M$274 167 4216 4005 167 nfet_01v8 L=150000U W=210000U AS=21875000000P
+ AD=51200000000P PS=460000U PD=775000U
* device instance $275 r0 *1 25.895,42.54 nfet_01v8
M$275 4216 4005 167 167 nfet_01v8 L=150000U W=210000U AS=51200000000P
+ AD=21875000000P PS=775000U PD=460000U
* device instance $276 r0 *1 25.86,42.94 nfet_01v8
M$276 35 153 4216 167 nfet_01v8 L=150000U W=140000U AS=21875000000P
+ AD=16800000000P PS=460000U PD=380000U
* device instance $277 r0 *1 14.96,37.01 nfet_01v8
M$277 4030 150 19 167 nfet_01v8 L=150000U W=140000U AS=16800000000P
+ AD=21875000000P PS=380000U PD=460000U
* device instance $278 r0 *1 14.995,37.41 nfet_01v8
M$278 167 4243 4030 167 nfet_01v8 L=150000U W=210000U AS=21875000000P
+ AD=51200000000P PS=460000U PD=775000U
* device instance $279 r0 *1 14.995,37.8 nfet_01v8
M$279 4243 4030 167 167 nfet_01v8 L=150000U W=210000U AS=51200000000P
+ AD=21875000000P PS=775000U PD=460000U
* device instance $280 r0 *1 14.96,38.2 nfet_01v8
M$280 20 150 4243 167 nfet_01v8 L=150000U W=140000U AS=21875000000P
+ AD=16800000000P PS=460000U PD=380000U
* device instance $281 r0 *1 14.96,38.59 nfet_01v8
M$281 4408 151 20 167 nfet_01v8 L=150000U W=140000U AS=16800000000P
+ AD=21875000000P PS=380000U PD=460000U
* device instance $282 r0 *1 14.995,38.99 nfet_01v8
M$282 167 4267 4408 167 nfet_01v8 L=150000U W=210000U AS=21875000000P
+ AD=51200000000P PS=460000U PD=775000U
* device instance $283 r0 *1 14.995,39.38 nfet_01v8
M$283 4267 4408 167 167 nfet_01v8 L=150000U W=210000U AS=51200000000P
+ AD=21875000000P PS=775000U PD=460000U
* device instance $284 r0 *1 14.96,39.78 nfet_01v8
M$284 19 151 4267 167 nfet_01v8 L=150000U W=140000U AS=21875000000P
+ AD=16800000000P PS=460000U PD=380000U
* device instance $285 r0 *1 14.96,40.17 nfet_01v8
M$285 4027 152 19 167 nfet_01v8 L=150000U W=140000U AS=16800000000P
+ AD=21875000000P PS=380000U PD=460000U
* device instance $286 r0 *1 14.995,40.57 nfet_01v8
M$286 167 4240 4027 167 nfet_01v8 L=150000U W=210000U AS=21875000000P
+ AD=51200000000P PS=460000U PD=775000U
* device instance $287 r0 *1 14.995,40.96 nfet_01v8
M$287 4240 4027 167 167 nfet_01v8 L=150000U W=210000U AS=51200000000P
+ AD=21875000000P PS=775000U PD=460000U
* device instance $288 r0 *1 14.96,41.36 nfet_01v8
M$288 20 152 4240 167 nfet_01v8 L=150000U W=140000U AS=21875000000P
+ AD=16800000000P PS=460000U PD=380000U
* device instance $289 r0 *1 14.96,41.75 nfet_01v8
M$289 4043 153 20 167 nfet_01v8 L=150000U W=140000U AS=16800000000P
+ AD=21875000000P PS=380000U PD=460000U
* device instance $290 r0 *1 14.995,42.15 nfet_01v8
M$290 167 4260 4043 167 nfet_01v8 L=150000U W=210000U AS=21875000000P
+ AD=51200000000P PS=460000U PD=775000U
* device instance $291 r0 *1 14.995,42.54 nfet_01v8
M$291 4260 4043 167 167 nfet_01v8 L=150000U W=210000U AS=51200000000P
+ AD=21875000000P PS=775000U PD=460000U
* device instance $292 r0 *1 14.96,42.94 nfet_01v8
M$292 19 153 4260 167 nfet_01v8 L=150000U W=140000U AS=21875000000P
+ AD=16800000000P PS=460000U PD=380000U
* device instance $293 r0 *1 4.06,37.01 nfet_01v8
M$293 4056 150 3 167 nfet_01v8 L=150000U W=140000U AS=16800000000P
+ AD=21875000000P PS=380000U PD=460000U
* device instance $294 r0 *1 4.095,37.41 nfet_01v8
M$294 167 4276 4056 167 nfet_01v8 L=150000U W=210000U AS=21875000000P
+ AD=51200000000P PS=460000U PD=775000U
* device instance $295 r0 *1 4.095,37.8 nfet_01v8
M$295 4276 4056 167 167 nfet_01v8 L=150000U W=210000U AS=51200000000P
+ AD=21875000000P PS=775000U PD=460000U
* device instance $296 r0 *1 4.06,38.2 nfet_01v8
M$296 4 150 4276 167 nfet_01v8 L=150000U W=140000U AS=21875000000P
+ AD=16800000000P PS=460000U PD=380000U
* device instance $297 r0 *1 4.06,38.59 nfet_01v8
M$297 4455 151 4 167 nfet_01v8 L=150000U W=140000U AS=16800000000P
+ AD=21875000000P PS=380000U PD=460000U
* device instance $298 r0 *1 4.095,38.99 nfet_01v8
M$298 167 4255 4455 167 nfet_01v8 L=150000U W=210000U AS=21875000000P
+ AD=51200000000P PS=460000U PD=775000U
* device instance $299 r0 *1 4.095,39.38 nfet_01v8
M$299 4255 4455 167 167 nfet_01v8 L=150000U W=210000U AS=51200000000P
+ AD=21875000000P PS=775000U PD=460000U
* device instance $300 r0 *1 4.06,39.78 nfet_01v8
M$300 3 151 4255 167 nfet_01v8 L=150000U W=140000U AS=21875000000P
+ AD=16800000000P PS=460000U PD=380000U
* device instance $301 r0 *1 4.06,40.17 nfet_01v8
M$301 4029 152 3 167 nfet_01v8 L=150000U W=140000U AS=16800000000P
+ AD=21875000000P PS=380000U PD=460000U
* device instance $302 r0 *1 4.095,40.57 nfet_01v8
M$302 167 4242 4029 167 nfet_01v8 L=150000U W=210000U AS=21875000000P
+ AD=51200000000P PS=460000U PD=775000U
* device instance $303 r0 *1 4.095,40.96 nfet_01v8
M$303 4242 4029 167 167 nfet_01v8 L=150000U W=210000U AS=51200000000P
+ AD=21875000000P PS=775000U PD=460000U
* device instance $304 r0 *1 4.06,41.36 nfet_01v8
M$304 4 152 4242 167 nfet_01v8 L=150000U W=140000U AS=21875000000P
+ AD=16800000000P PS=460000U PD=380000U
* device instance $305 r0 *1 4.06,41.75 nfet_01v8
M$305 4008 153 4 167 nfet_01v8 L=150000U W=140000U AS=16800000000P
+ AD=21875000000P PS=380000U PD=460000U
* device instance $306 r0 *1 4.095,42.15 nfet_01v8
M$306 167 4219 4008 167 nfet_01v8 L=150000U W=210000U AS=21875000000P
+ AD=51200000000P PS=460000U PD=775000U
* device instance $307 r0 *1 4.095,42.54 nfet_01v8
M$307 4219 4008 167 167 nfet_01v8 L=150000U W=210000U AS=51200000000P
+ AD=21875000000P PS=775000U PD=460000U
* device instance $308 r0 *1 4.06,42.94 nfet_01v8
M$308 3 153 4219 167 nfet_01v8 L=150000U W=140000U AS=21875000000P
+ AD=16800000000P PS=460000U PD=380000U
* device instance $309 r0 *1 36.76,60.71 nfet_01v8
M$309 4018 162 51 167 nfet_01v8 L=150000U W=140000U AS=16800000000P
+ AD=21875000000P PS=380000U PD=460000U
* device instance $310 r0 *1 36.795,61.11 nfet_01v8
M$310 167 4231 4018 167 nfet_01v8 L=150000U W=210000U AS=21875000000P
+ AD=51200000000P PS=460000U PD=775000U
* device instance $311 r0 *1 36.795,61.5 nfet_01v8
M$311 4231 4018 167 167 nfet_01v8 L=150000U W=210000U AS=51200000000P
+ AD=21875000000P PS=775000U PD=460000U
* device instance $312 r0 *1 36.76,61.9 nfet_01v8
M$312 52 162 4231 167 nfet_01v8 L=150000U W=140000U AS=21875000000P
+ AD=16800000000P PS=460000U PD=380000U
* device instance $313 r0 *1 36.76,62.29 nfet_01v8
M$313 4403 163 52 167 nfet_01v8 L=150000U W=140000U AS=16800000000P
+ AD=21875000000P PS=380000U PD=460000U
* device instance $314 r0 *1 36.795,62.69 nfet_01v8
M$314 167 3807 4403 167 nfet_01v8 L=150000U W=210000U AS=21875000000P
+ AD=51200000000P PS=460000U PD=775000U
* device instance $315 r0 *1 36.795,63.08 nfet_01v8
M$315 3807 4403 167 167 nfet_01v8 L=150000U W=210000U AS=51200000000P
+ AD=21875000000P PS=775000U PD=460000U
* device instance $316 r0 *1 36.76,63.48 nfet_01v8
M$316 51 163 3807 167 nfet_01v8 L=150000U W=140000U AS=21875000000P
+ AD=16800000000P PS=460000U PD=380000U
* device instance $317 r0 *1 36.76,63.87 nfet_01v8
M$317 3762 164 51 167 nfet_01v8 L=150000U W=140000U AS=16800000000P
+ AD=21875000000P PS=380000U PD=460000U
* device instance $318 r0 *1 36.795,64.27 nfet_01v8
M$318 167 3804 3762 167 nfet_01v8 L=150000U W=210000U AS=21875000000P
+ AD=51200000000P PS=460000U PD=775000U
* device instance $319 r0 *1 36.795,64.66 nfet_01v8
M$319 3804 3762 167 167 nfet_01v8 L=150000U W=210000U AS=51200000000P
+ AD=21875000000P PS=775000U PD=460000U
* device instance $320 r0 *1 36.76,65.06 nfet_01v8
M$320 52 164 3804 167 nfet_01v8 L=150000U W=140000U AS=21875000000P
+ AD=16800000000P PS=460000U PD=380000U
* device instance $321 r0 *1 36.76,65.45 nfet_01v8
M$321 4048 165 52 167 nfet_01v8 L=150000U W=140000U AS=16800000000P
+ AD=21875000000P PS=380000U PD=460000U
* device instance $322 r0 *1 36.795,65.85 nfet_01v8
M$322 167 4265 4048 167 nfet_01v8 L=150000U W=210000U AS=21875000000P
+ AD=51200000000P PS=460000U PD=775000U
* device instance $323 r0 *1 36.795,66.24 nfet_01v8
M$323 4265 4048 167 167 nfet_01v8 L=150000U W=210000U AS=51200000000P
+ AD=21875000000P PS=775000U PD=460000U
* device instance $324 r0 *1 36.76,66.64 nfet_01v8
M$324 51 165 4265 167 nfet_01v8 L=150000U W=140000U AS=21875000000P
+ AD=16800000000P PS=460000U PD=380000U
* device instance $325 r0 *1 80.36,44.91 nfet_01v8
M$325 3922 154 115 167 nfet_01v8 L=150000U W=140000U AS=16800000000P
+ AD=21875000000P PS=380000U PD=460000U
* device instance $326 r0 *1 80.395,45.31 nfet_01v8
M$326 167 4115 3922 167 nfet_01v8 L=150000U W=210000U AS=21875000000P
+ AD=51200000000P PS=460000U PD=775000U
* device instance $327 r0 *1 80.395,45.7 nfet_01v8
M$327 4115 3922 167 167 nfet_01v8 L=150000U W=210000U AS=51200000000P
+ AD=21875000000P PS=775000U PD=460000U
* device instance $328 r0 *1 80.36,46.1 nfet_01v8
M$328 116 154 4115 167 nfet_01v8 L=150000U W=140000U AS=21875000000P
+ AD=16800000000P PS=460000U PD=380000U
* device instance $329 r0 *1 80.36,46.49 nfet_01v8
M$329 4508 155 116 167 nfet_01v8 L=150000U W=140000U AS=16800000000P
+ AD=21875000000P PS=380000U PD=460000U
* device instance $330 r0 *1 80.395,46.89 nfet_01v8
M$330 167 4123 4508 167 nfet_01v8 L=150000U W=210000U AS=21875000000P
+ AD=51200000000P PS=460000U PD=775000U
* device instance $331 r0 *1 80.395,47.28 nfet_01v8
M$331 4123 4508 167 167 nfet_01v8 L=150000U W=210000U AS=51200000000P
+ AD=21875000000P PS=775000U PD=460000U
* device instance $332 r0 *1 80.36,47.68 nfet_01v8
M$332 115 155 4123 167 nfet_01v8 L=150000U W=140000U AS=21875000000P
+ AD=16800000000P PS=460000U PD=380000U
* device instance $333 r0 *1 80.36,48.07 nfet_01v8
M$333 3928 156 115 167 nfet_01v8 L=150000U W=140000U AS=16800000000P
+ AD=21875000000P PS=380000U PD=460000U
* device instance $334 r0 *1 80.395,48.47 nfet_01v8
M$334 167 4121 3928 167 nfet_01v8 L=150000U W=210000U AS=21875000000P
+ AD=51200000000P PS=460000U PD=775000U
* device instance $335 r0 *1 80.395,48.86 nfet_01v8
M$335 4121 3928 167 167 nfet_01v8 L=150000U W=210000U AS=51200000000P
+ AD=21875000000P PS=775000U PD=460000U
* device instance $336 r0 *1 80.36,49.26 nfet_01v8
M$336 116 156 4121 167 nfet_01v8 L=150000U W=140000U AS=21875000000P
+ AD=16800000000P PS=460000U PD=380000U
* device instance $337 r0 *1 80.36,49.65 nfet_01v8
M$337 3927 157 116 167 nfet_01v8 L=150000U W=140000U AS=16800000000P
+ AD=21875000000P PS=380000U PD=460000U
* device instance $338 r0 *1 80.395,50.05 nfet_01v8
M$338 167 4120 3927 167 nfet_01v8 L=150000U W=210000U AS=21875000000P
+ AD=51200000000P PS=460000U PD=775000U
* device instance $339 r0 *1 80.395,50.44 nfet_01v8
M$339 4120 3927 167 167 nfet_01v8 L=150000U W=210000U AS=51200000000P
+ AD=21875000000P PS=775000U PD=460000U
* device instance $340 r0 *1 80.36,50.84 nfet_01v8
M$340 115 157 4120 167 nfet_01v8 L=150000U W=140000U AS=21875000000P
+ AD=16800000000P PS=460000U PD=380000U
* device instance $341 r0 *1 69.46,44.91 nfet_01v8
M$341 4038 154 99 167 nfet_01v8 L=150000U W=140000U AS=16800000000P
+ AD=21875000000P PS=380000U PD=460000U
* device instance $342 r0 *1 69.495,45.31 nfet_01v8
M$342 167 4253 4038 167 nfet_01v8 L=150000U W=210000U AS=21875000000P
+ AD=51200000000P PS=460000U PD=775000U
* device instance $343 r0 *1 69.495,45.7 nfet_01v8
M$343 4253 4038 167 167 nfet_01v8 L=150000U W=210000U AS=51200000000P
+ AD=21875000000P PS=775000U PD=460000U
* device instance $344 r0 *1 69.46,46.1 nfet_01v8
M$344 100 154 4253 167 nfet_01v8 L=150000U W=140000U AS=21875000000P
+ AD=16800000000P PS=460000U PD=380000U
* device instance $345 r0 *1 69.46,46.49 nfet_01v8
M$345 4472 155 100 167 nfet_01v8 L=150000U W=140000U AS=16800000000P
+ AD=21875000000P PS=380000U PD=460000U
* device instance $346 r0 *1 69.495,46.89 nfet_01v8
M$346 167 4247 4472 167 nfet_01v8 L=150000U W=210000U AS=21875000000P
+ AD=51200000000P PS=460000U PD=775000U
* device instance $347 r0 *1 69.495,47.28 nfet_01v8
M$347 4247 4472 167 167 nfet_01v8 L=150000U W=210000U AS=51200000000P
+ AD=21875000000P PS=775000U PD=460000U
* device instance $348 r0 *1 69.46,47.68 nfet_01v8
M$348 99 155 4247 167 nfet_01v8 L=150000U W=140000U AS=21875000000P
+ AD=16800000000P PS=460000U PD=380000U
* device instance $349 r0 *1 69.46,48.07 nfet_01v8
M$349 3766 156 99 167 nfet_01v8 L=150000U W=140000U AS=16800000000P
+ AD=21875000000P PS=380000U PD=460000U
* device instance $350 r0 *1 69.495,48.47 nfet_01v8
M$350 167 3811 3766 167 nfet_01v8 L=150000U W=210000U AS=21875000000P
+ AD=51200000000P PS=460000U PD=775000U
* device instance $351 r0 *1 69.495,48.86 nfet_01v8
M$351 3811 3766 167 167 nfet_01v8 L=150000U W=210000U AS=51200000000P
+ AD=21875000000P PS=775000U PD=460000U
* device instance $352 r0 *1 69.46,49.26 nfet_01v8
M$352 100 156 3811 167 nfet_01v8 L=150000U W=140000U AS=21875000000P
+ AD=16800000000P PS=460000U PD=380000U
* device instance $353 r0 *1 69.46,49.65 nfet_01v8
M$353 4019 157 100 167 nfet_01v8 L=150000U W=140000U AS=16800000000P
+ AD=21875000000P PS=380000U PD=460000U
* device instance $354 r0 *1 69.495,50.05 nfet_01v8
M$354 167 4232 4019 167 nfet_01v8 L=150000U W=210000U AS=21875000000P
+ AD=51200000000P PS=460000U PD=775000U
* device instance $355 r0 *1 69.495,50.44 nfet_01v8
M$355 4232 4019 167 167 nfet_01v8 L=150000U W=210000U AS=51200000000P
+ AD=21875000000P PS=775000U PD=460000U
* device instance $356 r0 *1 69.46,50.84 nfet_01v8
M$356 99 157 4232 167 nfet_01v8 L=150000U W=140000U AS=21875000000P
+ AD=16800000000P PS=460000U PD=380000U
* device instance $357 r0 *1 14.96,52.81 nfet_01v8
M$357 3885 158 19 167 nfet_01v8 L=150000U W=140000U AS=16800000000P
+ AD=21875000000P PS=380000U PD=460000U
* device instance $358 r0 *1 14.995,53.21 nfet_01v8
M$358 167 4073 3885 167 nfet_01v8 L=150000U W=210000U AS=21875000000P
+ AD=51200000000P PS=460000U PD=775000U
* device instance $359 r0 *1 14.995,53.6 nfet_01v8
M$359 4073 3885 167 167 nfet_01v8 L=150000U W=210000U AS=51200000000P
+ AD=21875000000P PS=775000U PD=460000U
* device instance $360 r0 *1 14.96,54 nfet_01v8
M$360 20 158 4073 167 nfet_01v8 L=150000U W=140000U AS=21875000000P
+ AD=16800000000P PS=460000U PD=380000U
* device instance $361 r0 *1 14.96,54.39 nfet_01v8
M$361 4461 159 20 167 nfet_01v8 L=150000U W=140000U AS=16800000000P
+ AD=21875000000P PS=380000U PD=460000U
* device instance $362 r0 *1 14.995,54.79 nfet_01v8
M$362 167 4165 4461 167 nfet_01v8 L=150000U W=210000U AS=21875000000P
+ AD=51200000000P PS=460000U PD=775000U
* device instance $363 r0 *1 14.995,55.18 nfet_01v8
M$363 4165 4461 167 167 nfet_01v8 L=150000U W=210000U AS=51200000000P
+ AD=21875000000P PS=775000U PD=460000U
* device instance $364 r0 *1 14.96,55.58 nfet_01v8
M$364 19 159 4165 167 nfet_01v8 L=150000U W=140000U AS=21875000000P
+ AD=16800000000P PS=460000U PD=380000U
* device instance $365 r0 *1 14.96,55.97 nfet_01v8
M$365 3770 160 19 167 nfet_01v8 L=150000U W=140000U AS=16800000000P
+ AD=21875000000P PS=380000U PD=460000U
* device instance $366 r0 *1 14.995,56.37 nfet_01v8
M$366 167 3818 3770 167 nfet_01v8 L=150000U W=210000U AS=21875000000P
+ AD=51200000000P PS=460000U PD=775000U
* device instance $367 r0 *1 14.995,56.76 nfet_01v8
M$367 3818 3770 167 167 nfet_01v8 L=150000U W=210000U AS=51200000000P
+ AD=21875000000P PS=775000U PD=460000U
* device instance $368 r0 *1 14.96,57.16 nfet_01v8
M$368 20 160 3818 167 nfet_01v8 L=150000U W=140000U AS=21875000000P
+ AD=16800000000P PS=460000U PD=380000U
* device instance $369 r0 *1 14.96,57.55 nfet_01v8
M$369 3968 161 20 167 nfet_01v8 L=150000U W=140000U AS=16800000000P
+ AD=21875000000P PS=380000U PD=460000U
* device instance $370 r0 *1 14.995,57.95 nfet_01v8
M$370 167 4170 3968 167 nfet_01v8 L=150000U W=210000U AS=21875000000P
+ AD=51200000000P PS=460000U PD=775000U
* device instance $371 r0 *1 14.995,58.34 nfet_01v8
M$371 4170 3968 167 167 nfet_01v8 L=150000U W=210000U AS=51200000000P
+ AD=21875000000P PS=775000U PD=460000U
* device instance $372 r0 *1 14.96,58.74 nfet_01v8
M$372 19 161 4170 167 nfet_01v8 L=150000U W=140000U AS=21875000000P
+ AD=16800000000P PS=460000U PD=380000U
* device instance $373 r0 *1 25.86,52.81 nfet_01v8
M$373 3878 158 35 167 nfet_01v8 L=150000U W=140000U AS=16800000000P
+ AD=21875000000P PS=380000U PD=460000U
* device instance $374 r0 *1 25.895,53.21 nfet_01v8
M$374 167 4066 3878 167 nfet_01v8 L=150000U W=210000U AS=21875000000P
+ AD=51200000000P PS=460000U PD=775000U
* device instance $375 r0 *1 25.895,53.6 nfet_01v8
M$375 4066 3878 167 167 nfet_01v8 L=150000U W=210000U AS=51200000000P
+ AD=21875000000P PS=775000U PD=460000U
* device instance $376 r0 *1 25.86,54 nfet_01v8
M$376 36 158 4066 167 nfet_01v8 L=150000U W=140000U AS=21875000000P
+ AD=16800000000P PS=460000U PD=380000U
* device instance $377 r0 *1 25.86,54.39 nfet_01v8
M$377 4430 159 36 167 nfet_01v8 L=150000U W=140000U AS=16800000000P
+ AD=21875000000P PS=380000U PD=460000U
* device instance $378 r0 *1 25.895,54.79 nfet_01v8
M$378 167 4134 4430 167 nfet_01v8 L=150000U W=210000U AS=21875000000P
+ AD=51200000000P PS=460000U PD=775000U
* device instance $379 r0 *1 25.895,55.18 nfet_01v8
M$379 4134 4430 167 167 nfet_01v8 L=150000U W=210000U AS=51200000000P
+ AD=21875000000P PS=775000U PD=460000U
* device instance $380 r0 *1 25.86,55.58 nfet_01v8
M$380 35 159 4134 167 nfet_01v8 L=150000U W=140000U AS=21875000000P
+ AD=16800000000P PS=460000U PD=380000U
* device instance $381 r0 *1 25.86,55.97 nfet_01v8
M$381 3787 160 35 167 nfet_01v8 L=150000U W=140000U AS=16800000000P
+ AD=21875000000P PS=380000U PD=460000U
* device instance $382 r0 *1 25.895,56.37 nfet_01v8
M$382 167 3857 3787 167 nfet_01v8 L=150000U W=210000U AS=21875000000P
+ AD=51200000000P PS=460000U PD=775000U
* device instance $383 r0 *1 25.895,56.76 nfet_01v8
M$383 3857 3787 167 167 nfet_01v8 L=150000U W=210000U AS=51200000000P
+ AD=21875000000P PS=775000U PD=460000U
* device instance $384 r0 *1 25.86,57.16 nfet_01v8
M$384 36 160 3857 167 nfet_01v8 L=150000U W=140000U AS=21875000000P
+ AD=16800000000P PS=460000U PD=380000U
* device instance $385 r0 *1 25.86,57.55 nfet_01v8
M$385 3916 161 36 167 nfet_01v8 L=150000U W=140000U AS=16800000000P
+ AD=21875000000P PS=380000U PD=460000U
* device instance $386 r0 *1 25.895,57.95 nfet_01v8
M$386 167 4108 3916 167 nfet_01v8 L=150000U W=210000U AS=21875000000P
+ AD=51200000000P PS=460000U PD=775000U
* device instance $387 r0 *1 25.895,58.34 nfet_01v8
M$387 4108 3916 167 167 nfet_01v8 L=150000U W=210000U AS=51200000000P
+ AD=21875000000P PS=775000U PD=460000U
* device instance $388 r0 *1 25.86,58.74 nfet_01v8
M$388 35 161 4108 167 nfet_01v8 L=150000U W=140000U AS=21875000000P
+ AD=16800000000P PS=460000U PD=380000U
* device instance $389 r0 *1 36.76,52.81 nfet_01v8
M$389 3871 158 51 167 nfet_01v8 L=150000U W=140000U AS=16800000000P
+ AD=21875000000P PS=380000U PD=460000U
* device instance $390 r0 *1 36.795,53.21 nfet_01v8
M$390 167 4059 3871 167 nfet_01v8 L=150000U W=210000U AS=21875000000P
+ AD=51200000000P PS=460000U PD=775000U
* device instance $391 r0 *1 36.795,53.6 nfet_01v8
M$391 4059 3871 167 167 nfet_01v8 L=150000U W=210000U AS=51200000000P
+ AD=21875000000P PS=775000U PD=460000U
* device instance $392 r0 *1 36.76,54 nfet_01v8
M$392 52 158 4059 167 nfet_01v8 L=150000U W=140000U AS=21875000000P
+ AD=16800000000P PS=460000U PD=380000U
* device instance $393 r0 *1 36.76,54.39 nfet_01v8
M$393 4441 159 52 167 nfet_01v8 L=150000U W=140000U AS=16800000000P
+ AD=21875000000P PS=380000U PD=460000U
* device instance $394 r0 *1 36.795,54.79 nfet_01v8
M$394 167 4223 4441 167 nfet_01v8 L=150000U W=210000U AS=21875000000P
+ AD=51200000000P PS=460000U PD=775000U
* device instance $395 r0 *1 36.795,55.18 nfet_01v8
M$395 4223 4441 167 167 nfet_01v8 L=150000U W=210000U AS=51200000000P
+ AD=21875000000P PS=775000U PD=460000U
* device instance $396 r0 *1 36.76,55.58 nfet_01v8
M$396 51 159 4223 167 nfet_01v8 L=150000U W=140000U AS=21875000000P
+ AD=16800000000P PS=460000U PD=380000U
* device instance $397 r0 *1 36.76,55.97 nfet_01v8
M$397 3756 160 51 167 nfet_01v8 L=150000U W=140000U AS=16800000000P
+ AD=21875000000P PS=380000U PD=460000U
* device instance $398 r0 *1 36.795,56.37 nfet_01v8
M$398 167 3794 3756 167 nfet_01v8 L=150000U W=210000U AS=21875000000P
+ AD=51200000000P PS=460000U PD=775000U
* device instance $399 r0 *1 36.795,56.76 nfet_01v8
M$399 3794 3756 167 167 nfet_01v8 L=150000U W=210000U AS=51200000000P
+ AD=21875000000P PS=775000U PD=460000U
* device instance $400 r0 *1 36.76,57.16 nfet_01v8
M$400 52 160 3794 167 nfet_01v8 L=150000U W=140000U AS=21875000000P
+ AD=16800000000P PS=460000U PD=380000U
* device instance $401 r0 *1 36.76,57.55 nfet_01v8
M$401 4035 161 52 167 nfet_01v8 L=150000U W=140000U AS=16800000000P
+ AD=21875000000P PS=380000U PD=460000U
* device instance $402 r0 *1 36.795,57.95 nfet_01v8
M$402 167 4250 4035 167 nfet_01v8 L=150000U W=210000U AS=21875000000P
+ AD=51200000000P PS=460000U PD=775000U
* device instance $403 r0 *1 36.795,58.34 nfet_01v8
M$403 4250 4035 167 167 nfet_01v8 L=150000U W=210000U AS=51200000000P
+ AD=21875000000P PS=775000U PD=460000U
* device instance $404 r0 *1 36.76,58.74 nfet_01v8
M$404 51 161 4250 167 nfet_01v8 L=150000U W=140000U AS=21875000000P
+ AD=16800000000P PS=460000U PD=380000U
* device instance $405 r0 *1 47.66,52.81 nfet_01v8
M$405 3999 158 67 167 nfet_01v8 L=150000U W=140000U AS=16800000000P
+ AD=21875000000P PS=380000U PD=460000U
* device instance $406 r0 *1 47.695,53.21 nfet_01v8
M$406 167 4210 3999 167 nfet_01v8 L=150000U W=210000U AS=21875000000P
+ AD=51200000000P PS=460000U PD=775000U
* device instance $407 r0 *1 47.695,53.6 nfet_01v8
M$407 4210 3999 167 167 nfet_01v8 L=150000U W=210000U AS=51200000000P
+ AD=21875000000P PS=775000U PD=460000U
* device instance $408 r0 *1 47.66,54 nfet_01v8
M$408 68 158 4210 167 nfet_01v8 L=150000U W=140000U AS=21875000000P
+ AD=16800000000P PS=460000U PD=380000U
* device instance $409 r0 *1 47.66,54.39 nfet_01v8
M$409 4332 159 68 167 nfet_01v8 L=150000U W=140000U AS=16800000000P
+ AD=21875000000P PS=380000U PD=460000U
* device instance $410 r0 *1 47.695,54.79 nfet_01v8
M$410 167 4245 4332 167 nfet_01v8 L=150000U W=210000U AS=21875000000P
+ AD=51200000000P PS=460000U PD=775000U
* device instance $411 r0 *1 47.695,55.18 nfet_01v8
M$411 4245 4332 167 167 nfet_01v8 L=150000U W=210000U AS=51200000000P
+ AD=21875000000P PS=775000U PD=460000U
* device instance $412 r0 *1 47.66,55.58 nfet_01v8
M$412 67 159 4245 167 nfet_01v8 L=150000U W=140000U AS=21875000000P
+ AD=16800000000P PS=460000U PD=380000U
* device instance $413 r0 *1 47.66,55.97 nfet_01v8
M$413 3791 160 67 167 nfet_01v8 L=150000U W=140000U AS=16800000000P
+ AD=21875000000P PS=380000U PD=460000U
* device instance $414 r0 *1 47.695,56.37 nfet_01v8
M$414 167 3866 3791 167 nfet_01v8 L=150000U W=210000U AS=21875000000P
+ AD=51200000000P PS=460000U PD=775000U
* device instance $415 r0 *1 47.695,56.76 nfet_01v8
M$415 3866 3791 167 167 nfet_01v8 L=150000U W=210000U AS=51200000000P
+ AD=21875000000P PS=775000U PD=460000U
* device instance $416 r0 *1 47.66,57.16 nfet_01v8
M$416 68 160 3866 167 nfet_01v8 L=150000U W=140000U AS=21875000000P
+ AD=16800000000P PS=460000U PD=380000U
* device instance $417 r0 *1 47.66,57.55 nfet_01v8
M$417 3998 161 68 167 nfet_01v8 L=150000U W=140000U AS=16800000000P
+ AD=21875000000P PS=380000U PD=460000U
* device instance $418 r0 *1 47.695,57.95 nfet_01v8
M$418 167 4208 3998 167 nfet_01v8 L=150000U W=210000U AS=21875000000P
+ AD=51200000000P PS=460000U PD=775000U
* device instance $419 r0 *1 47.695,58.34 nfet_01v8
M$419 4208 3998 167 167 nfet_01v8 L=150000U W=210000U AS=51200000000P
+ AD=21875000000P PS=775000U PD=460000U
* device instance $420 r0 *1 47.66,58.74 nfet_01v8
M$420 67 161 4208 167 nfet_01v8 L=150000U W=140000U AS=21875000000P
+ AD=16800000000P PS=460000U PD=380000U
* device instance $421 r0 *1 58.56,52.81 nfet_01v8
M$421 4009 158 83 167 nfet_01v8 L=150000U W=140000U AS=16800000000P
+ AD=21875000000P PS=380000U PD=460000U
* device instance $422 r0 *1 58.595,53.21 nfet_01v8
M$422 167 4220 4009 167 nfet_01v8 L=150000U W=210000U AS=21875000000P
+ AD=51200000000P PS=460000U PD=775000U
* device instance $423 r0 *1 58.595,53.6 nfet_01v8
M$423 4220 4009 167 167 nfet_01v8 L=150000U W=210000U AS=51200000000P
+ AD=21875000000P PS=775000U PD=460000U
* device instance $424 r0 *1 58.56,54 nfet_01v8
M$424 84 158 4220 167 nfet_01v8 L=150000U W=140000U AS=21875000000P
+ AD=16800000000P PS=460000U PD=380000U
* device instance $425 r0 *1 58.56,54.39 nfet_01v8
M$425 4314 159 84 167 nfet_01v8 L=150000U W=140000U AS=16800000000P
+ AD=21875000000P PS=380000U PD=460000U
* device instance $426 r0 *1 58.595,54.79 nfet_01v8
M$426 167 3847 4314 167 nfet_01v8 L=150000U W=210000U AS=21875000000P
+ AD=51200000000P PS=460000U PD=775000U
* device instance $427 r0 *1 58.595,55.18 nfet_01v8
M$427 3847 4314 167 167 nfet_01v8 L=150000U W=210000U AS=51200000000P
+ AD=21875000000P PS=775000U PD=460000U
* device instance $428 r0 *1 58.56,55.58 nfet_01v8
M$428 83 159 3847 167 nfet_01v8 L=150000U W=140000U AS=21875000000P
+ AD=16800000000P PS=460000U PD=380000U
* device instance $429 r0 *1 58.56,55.97 nfet_01v8
M$429 3886 160 83 167 nfet_01v8 L=150000U W=140000U AS=16800000000P
+ AD=21875000000P PS=380000U PD=460000U
* device instance $430 r0 *1 58.595,56.37 nfet_01v8
M$430 167 4074 3886 167 nfet_01v8 L=150000U W=210000U AS=21875000000P
+ AD=51200000000P PS=460000U PD=775000U
* device instance $431 r0 *1 58.595,56.76 nfet_01v8
M$431 4074 3886 167 167 nfet_01v8 L=150000U W=210000U AS=51200000000P
+ AD=21875000000P PS=775000U PD=460000U
* device instance $432 r0 *1 58.56,57.16 nfet_01v8
M$432 84 160 4074 167 nfet_01v8 L=150000U W=140000U AS=21875000000P
+ AD=16800000000P PS=460000U PD=380000U
* device instance $433 r0 *1 58.56,57.55 nfet_01v8
M$433 4011 161 84 167 nfet_01v8 L=150000U W=140000U AS=16800000000P
+ AD=21875000000P PS=380000U PD=460000U
* device instance $434 r0 *1 58.595,57.95 nfet_01v8
M$434 167 4222 4011 167 nfet_01v8 L=150000U W=210000U AS=21875000000P
+ AD=51200000000P PS=460000U PD=775000U
* device instance $435 r0 *1 58.595,58.34 nfet_01v8
M$435 4222 4011 167 167 nfet_01v8 L=150000U W=210000U AS=51200000000P
+ AD=21875000000P PS=775000U PD=460000U
* device instance $436 r0 *1 58.56,58.74 nfet_01v8
M$436 83 161 4222 167 nfet_01v8 L=150000U W=140000U AS=21875000000P
+ AD=16800000000P PS=460000U PD=380000U
* device instance $437 r0 *1 4.06,52.81 nfet_01v8
M$437 4012 158 3 167 nfet_01v8 L=150000U W=140000U AS=16800000000P
+ AD=21875000000P PS=380000U PD=460000U
* device instance $438 r0 *1 4.095,53.21 nfet_01v8
M$438 167 4225 4012 167 nfet_01v8 L=150000U W=210000U AS=21875000000P
+ AD=51200000000P PS=460000U PD=775000U
* device instance $439 r0 *1 4.095,53.6 nfet_01v8
M$439 4225 4012 167 167 nfet_01v8 L=150000U W=210000U AS=51200000000P
+ AD=21875000000P PS=775000U PD=460000U
* device instance $440 r0 *1 4.06,54 nfet_01v8
M$440 4 158 4225 167 nfet_01v8 L=150000U W=140000U AS=21875000000P
+ AD=16800000000P PS=460000U PD=380000U
* device instance $441 r0 *1 4.06,54.39 nfet_01v8
M$441 4436 159 4 167 nfet_01v8 L=150000U W=140000U AS=16800000000P
+ AD=21875000000P PS=380000U PD=460000U
* device instance $442 r0 *1 4.095,54.79 nfet_01v8
M$442 167 3795 4436 167 nfet_01v8 L=150000U W=210000U AS=21875000000P
+ AD=51200000000P PS=460000U PD=775000U
* device instance $443 r0 *1 4.095,55.18 nfet_01v8
M$443 3795 4436 167 167 nfet_01v8 L=150000U W=210000U AS=51200000000P
+ AD=21875000000P PS=775000U PD=460000U
* device instance $444 r0 *1 4.06,55.58 nfet_01v8
M$444 3 159 3795 167 nfet_01v8 L=150000U W=140000U AS=21875000000P
+ AD=16800000000P PS=460000U PD=380000U
* device instance $445 r0 *1 4.06,55.97 nfet_01v8
M$445 3995 160 3 167 nfet_01v8 L=150000U W=140000U AS=16800000000P
+ AD=21875000000P PS=380000U PD=460000U
* device instance $446 r0 *1 4.095,56.37 nfet_01v8
M$446 167 4203 3995 167 nfet_01v8 L=150000U W=210000U AS=21875000000P
+ AD=51200000000P PS=460000U PD=775000U
* device instance $447 r0 *1 4.095,56.76 nfet_01v8
M$447 4203 3995 167 167 nfet_01v8 L=150000U W=210000U AS=51200000000P
+ AD=21875000000P PS=775000U PD=460000U
* device instance $448 r0 *1 4.06,57.16 nfet_01v8
M$448 4 160 4203 167 nfet_01v8 L=150000U W=140000U AS=21875000000P
+ AD=16800000000P PS=460000U PD=380000U
* device instance $449 r0 *1 4.06,57.55 nfet_01v8
M$449 3985 161 4 167 nfet_01v8 L=150000U W=140000U AS=16800000000P
+ AD=21875000000P PS=380000U PD=460000U
* device instance $450 r0 *1 4.095,57.95 nfet_01v8
M$450 167 4191 3985 167 nfet_01v8 L=150000U W=210000U AS=21875000000P
+ AD=51200000000P PS=460000U PD=775000U
* device instance $451 r0 *1 4.095,58.34 nfet_01v8
M$451 4191 3985 167 167 nfet_01v8 L=150000U W=210000U AS=51200000000P
+ AD=21875000000P PS=775000U PD=460000U
* device instance $452 r0 *1 4.06,58.74 nfet_01v8
M$452 3 161 4191 167 nfet_01v8 L=150000U W=140000U AS=21875000000P
+ AD=16800000000P PS=460000U PD=380000U
* device instance $453 r0 *1 69.46,52.81 nfet_01v8
M$453 4013 158 99 167 nfet_01v8 L=150000U W=140000U AS=16800000000P
+ AD=21875000000P PS=380000U PD=460000U
* device instance $454 r0 *1 69.495,53.21 nfet_01v8
M$454 167 4226 4013 167 nfet_01v8 L=150000U W=210000U AS=21875000000P
+ AD=51200000000P PS=460000U PD=775000U
* device instance $455 r0 *1 69.495,53.6 nfet_01v8
M$455 4226 4013 167 167 nfet_01v8 L=150000U W=210000U AS=51200000000P
+ AD=21875000000P PS=775000U PD=460000U
* device instance $456 r0 *1 69.46,54 nfet_01v8
M$456 100 158 4226 167 nfet_01v8 L=150000U W=140000U AS=21875000000P
+ AD=16800000000P PS=460000U PD=380000U
* device instance $457 r0 *1 69.46,54.39 nfet_01v8
M$457 4524 159 100 167 nfet_01v8 L=150000U W=140000U AS=16800000000P
+ AD=21875000000P PS=380000U PD=460000U
* device instance $458 r0 *1 69.495,54.79 nfet_01v8
M$458 167 3830 4524 167 nfet_01v8 L=150000U W=210000U AS=21875000000P
+ AD=51200000000P PS=460000U PD=775000U
* device instance $459 r0 *1 69.495,55.18 nfet_01v8
M$459 3830 4524 167 167 nfet_01v8 L=150000U W=210000U AS=51200000000P
+ AD=21875000000P PS=775000U PD=460000U
* device instance $460 r0 *1 69.46,55.58 nfet_01v8
M$460 99 159 3830 167 nfet_01v8 L=150000U W=140000U AS=21875000000P
+ AD=16800000000P PS=460000U PD=380000U
* device instance $461 r0 *1 69.46,55.97 nfet_01v8
M$461 3777 160 99 167 nfet_01v8 L=150000U W=140000U AS=16800000000P
+ AD=21875000000P PS=380000U PD=460000U
* device instance $462 r0 *1 69.495,56.37 nfet_01v8
M$462 167 3829 3777 167 nfet_01v8 L=150000U W=210000U AS=21875000000P
+ AD=51200000000P PS=460000U PD=775000U
* device instance $463 r0 *1 69.495,56.76 nfet_01v8
M$463 3829 3777 167 167 nfet_01v8 L=150000U W=210000U AS=51200000000P
+ AD=21875000000P PS=775000U PD=460000U
* device instance $464 r0 *1 69.46,57.16 nfet_01v8
M$464 100 160 3829 167 nfet_01v8 L=150000U W=140000U AS=21875000000P
+ AD=16800000000P PS=460000U PD=380000U
* device instance $465 r0 *1 69.46,57.55 nfet_01v8
M$465 4054 161 100 167 nfet_01v8 L=150000U W=140000U AS=16800000000P
+ AD=21875000000P PS=380000U PD=460000U
* device instance $466 r0 *1 69.495,57.95 nfet_01v8
M$466 167 4273 4054 167 nfet_01v8 L=150000U W=210000U AS=21875000000P
+ AD=51200000000P PS=460000U PD=775000U
* device instance $467 r0 *1 69.495,58.34 nfet_01v8
M$467 4273 4054 167 167 nfet_01v8 L=150000U W=210000U AS=51200000000P
+ AD=21875000000P PS=775000U PD=460000U
* device instance $468 r0 *1 69.46,58.74 nfet_01v8
M$468 99 161 4273 167 nfet_01v8 L=150000U W=140000U AS=21875000000P
+ AD=16800000000P PS=460000U PD=380000U
* device instance $469 r0 *1 58.56,44.91 nfet_01v8
M$469 3892 154 83 167 nfet_01v8 L=150000U W=140000U AS=16800000000P
+ AD=21875000000P PS=380000U PD=460000U
* device instance $470 r0 *1 58.595,45.31 nfet_01v8
M$470 167 4080 3892 167 nfet_01v8 L=150000U W=210000U AS=21875000000P
+ AD=51200000000P PS=460000U PD=775000U
* device instance $471 r0 *1 58.595,45.7 nfet_01v8
M$471 4080 3892 167 167 nfet_01v8 L=150000U W=210000U AS=51200000000P
+ AD=21875000000P PS=775000U PD=460000U
* device instance $472 r0 *1 58.56,46.1 nfet_01v8
M$472 84 154 4080 167 nfet_01v8 L=150000U W=140000U AS=21875000000P
+ AD=16800000000P PS=460000U PD=380000U
* device instance $473 r0 *1 58.56,46.49 nfet_01v8
M$473 4370 155 84 167 nfet_01v8 L=150000U W=140000U AS=16800000000P
+ AD=21875000000P PS=380000U PD=460000U
* device instance $474 r0 *1 58.595,46.89 nfet_01v8
M$474 167 4089 4370 167 nfet_01v8 L=150000U W=210000U AS=21875000000P
+ AD=51200000000P PS=460000U PD=775000U
* device instance $475 r0 *1 58.595,47.28 nfet_01v8
M$475 4089 4370 167 167 nfet_01v8 L=150000U W=210000U AS=51200000000P
+ AD=21875000000P PS=775000U PD=460000U
* device instance $476 r0 *1 58.56,47.68 nfet_01v8
M$476 83 155 4089 167 nfet_01v8 L=150000U W=140000U AS=21875000000P
+ AD=16800000000P PS=460000U PD=380000U
* device instance $477 r0 *1 58.56,48.07 nfet_01v8
M$477 3905 156 83 167 nfet_01v8 L=150000U W=140000U AS=16800000000P
+ AD=21875000000P PS=380000U PD=460000U
* device instance $478 r0 *1 58.595,48.47 nfet_01v8
M$478 167 4095 3905 167 nfet_01v8 L=150000U W=210000U AS=21875000000P
+ AD=51200000000P PS=460000U PD=775000U
* device instance $479 r0 *1 58.595,48.86 nfet_01v8
M$479 4095 3905 167 167 nfet_01v8 L=150000U W=210000U AS=51200000000P
+ AD=21875000000P PS=775000U PD=460000U
* device instance $480 r0 *1 58.56,49.26 nfet_01v8
M$480 84 156 4095 167 nfet_01v8 L=150000U W=140000U AS=21875000000P
+ AD=16800000000P PS=460000U PD=380000U
* device instance $481 r0 *1 58.56,49.65 nfet_01v8
M$481 3898 157 84 167 nfet_01v8 L=150000U W=140000U AS=16800000000P
+ AD=21875000000P PS=380000U PD=460000U
* device instance $482 r0 *1 58.595,50.05 nfet_01v8
M$482 167 4087 3898 167 nfet_01v8 L=150000U W=210000U AS=21875000000P
+ AD=51200000000P PS=460000U PD=775000U
* device instance $483 r0 *1 58.595,50.44 nfet_01v8
M$483 4087 3898 167 167 nfet_01v8 L=150000U W=210000U AS=51200000000P
+ AD=21875000000P PS=775000U PD=460000U
* device instance $484 r0 *1 58.56,50.84 nfet_01v8
M$484 83 157 4087 167 nfet_01v8 L=150000U W=140000U AS=21875000000P
+ AD=16800000000P PS=460000U PD=380000U
* device instance $485 r0 *1 4.06,29.11 nfet_01v8
M$485 3967 146 3 167 nfet_01v8 L=150000U W=140000U AS=16800000000P
+ AD=21875000000P PS=380000U PD=460000U
* device instance $486 r0 *1 4.095,29.51 nfet_01v8
M$486 167 4169 3967 167 nfet_01v8 L=150000U W=210000U AS=21875000000P
+ AD=51200000000P PS=460000U PD=775000U
* device instance $487 r0 *1 4.095,29.9 nfet_01v8
M$487 4169 3967 167 167 nfet_01v8 L=150000U W=210000U AS=51200000000P
+ AD=21875000000P PS=775000U PD=460000U
* device instance $488 r0 *1 4.06,30.3 nfet_01v8
M$488 4 146 4169 167 nfet_01v8 L=150000U W=140000U AS=21875000000P
+ AD=16800000000P PS=460000U PD=380000U
* device instance $489 r0 *1 4.06,30.69 nfet_01v8
M$489 4540 147 4 167 nfet_01v8 L=150000U W=140000U AS=16800000000P
+ AD=21875000000P PS=380000U PD=460000U
* device instance $490 r0 *1 4.095,31.09 nfet_01v8
M$490 167 4176 4540 167 nfet_01v8 L=150000U W=210000U AS=21875000000P
+ AD=51200000000P PS=460000U PD=775000U
* device instance $491 r0 *1 4.095,31.48 nfet_01v8
M$491 4176 4540 167 167 nfet_01v8 L=150000U W=210000U AS=51200000000P
+ AD=21875000000P PS=775000U PD=460000U
* device instance $492 r0 *1 4.06,31.88 nfet_01v8
M$492 3 147 4176 167 nfet_01v8 L=150000U W=140000U AS=21875000000P
+ AD=16800000000P PS=460000U PD=380000U
* device instance $493 r0 *1 4.06,32.27 nfet_01v8
M$493 3964 148 3 167 nfet_01v8 L=150000U W=140000U AS=16800000000P
+ AD=21875000000P PS=380000U PD=460000U
* device instance $494 r0 *1 4.095,32.67 nfet_01v8
M$494 167 4166 3964 167 nfet_01v8 L=150000U W=210000U AS=21875000000P
+ AD=51200000000P PS=460000U PD=775000U
* device instance $495 r0 *1 4.095,33.06 nfet_01v8
M$495 4166 3964 167 167 nfet_01v8 L=150000U W=210000U AS=51200000000P
+ AD=21875000000P PS=775000U PD=460000U
* device instance $496 r0 *1 4.06,33.46 nfet_01v8
M$496 4 148 4166 167 nfet_01v8 L=150000U W=140000U AS=21875000000P
+ AD=16800000000P PS=460000U PD=380000U
* device instance $497 r0 *1 4.06,33.85 nfet_01v8
M$497 3965 149 4 167 nfet_01v8 L=150000U W=140000U AS=16800000000P
+ AD=21875000000P PS=380000U PD=460000U
* device instance $498 r0 *1 4.095,34.25 nfet_01v8
M$498 167 4167 3965 167 nfet_01v8 L=150000U W=210000U AS=21875000000P
+ AD=51200000000P PS=460000U PD=775000U
* device instance $499 r0 *1 4.095,34.64 nfet_01v8
M$499 4167 3965 167 167 nfet_01v8 L=150000U W=210000U AS=51200000000P
+ AD=21875000000P PS=775000U PD=460000U
* device instance $500 r0 *1 4.06,35.04 nfet_01v8
M$500 3 149 4167 167 nfet_01v8 L=150000U W=140000U AS=21875000000P
+ AD=16800000000P PS=460000U PD=380000U
* device instance $501 r0 *1 47.66,60.71 nfet_01v8
M$501 4025 162 67 167 nfet_01v8 L=150000U W=140000U AS=16800000000P
+ AD=21875000000P PS=380000U PD=460000U
* device instance $502 r0 *1 47.695,61.11 nfet_01v8
M$502 167 4238 4025 167 nfet_01v8 L=150000U W=210000U AS=21875000000P
+ AD=51200000000P PS=460000U PD=775000U
* device instance $503 r0 *1 47.695,61.5 nfet_01v8
M$503 4238 4025 167 167 nfet_01v8 L=150000U W=210000U AS=51200000000P
+ AD=21875000000P PS=775000U PD=460000U
* device instance $504 r0 *1 47.66,61.9 nfet_01v8
M$504 68 162 4238 167 nfet_01v8 L=150000U W=140000U AS=21875000000P
+ AD=16800000000P PS=460000U PD=380000U
* device instance $505 r0 *1 47.66,62.29 nfet_01v8
M$505 4299 163 68 167 nfet_01v8 L=150000U W=140000U AS=16800000000P
+ AD=21875000000P PS=380000U PD=460000U
* device instance $506 r0 *1 47.695,62.69 nfet_01v8
M$506 167 3853 4299 167 nfet_01v8 L=150000U W=210000U AS=21875000000P
+ AD=51200000000P PS=460000U PD=775000U
* device instance $507 r0 *1 47.695,63.08 nfet_01v8
M$507 3853 4299 167 167 nfet_01v8 L=150000U W=210000U AS=51200000000P
+ AD=21875000000P PS=775000U PD=460000U
* device instance $508 r0 *1 47.66,63.48 nfet_01v8
M$508 67 163 3853 167 nfet_01v8 L=150000U W=140000U AS=21875000000P
+ AD=16800000000P PS=460000U PD=380000U
* device instance $509 r0 *1 47.66,63.87 nfet_01v8
M$509 3779 164 67 167 nfet_01v8 L=150000U W=140000U AS=16800000000P
+ AD=21875000000P PS=380000U PD=460000U
* device instance $510 r0 *1 47.695,64.27 nfet_01v8
M$510 167 3833 3779 167 nfet_01v8 L=150000U W=210000U AS=21875000000P
+ AD=51200000000P PS=460000U PD=775000U
* device instance $511 r0 *1 47.695,64.66 nfet_01v8
M$511 3833 3779 167 167 nfet_01v8 L=150000U W=210000U AS=51200000000P
+ AD=21875000000P PS=775000U PD=460000U
* device instance $512 r0 *1 47.66,65.06 nfet_01v8
M$512 68 164 3833 167 nfet_01v8 L=150000U W=140000U AS=21875000000P
+ AD=16800000000P PS=460000U PD=380000U
* device instance $513 r0 *1 47.66,65.45 nfet_01v8
M$513 3907 165 68 167 nfet_01v8 L=150000U W=140000U AS=16800000000P
+ AD=21875000000P PS=380000U PD=460000U
* device instance $514 r0 *1 47.695,65.85 nfet_01v8
M$514 167 4097 3907 167 nfet_01v8 L=150000U W=210000U AS=21875000000P
+ AD=51200000000P PS=460000U PD=775000U
* device instance $515 r0 *1 47.695,66.24 nfet_01v8
M$515 4097 3907 167 167 nfet_01v8 L=150000U W=210000U AS=51200000000P
+ AD=21875000000P PS=775000U PD=460000U
* device instance $516 r0 *1 47.66,66.64 nfet_01v8
M$516 67 165 4097 167 nfet_01v8 L=150000U W=140000U AS=21875000000P
+ AD=16800000000P PS=460000U PD=380000U
* device instance $517 r0 *1 4.06,44.91 nfet_01v8
M$517 4021 154 3 167 nfet_01v8 L=150000U W=140000U AS=16800000000P
+ AD=21875000000P PS=380000U PD=460000U
* device instance $518 r0 *1 4.095,45.31 nfet_01v8
M$518 167 4234 4021 167 nfet_01v8 L=150000U W=210000U AS=21875000000P
+ AD=51200000000P PS=460000U PD=775000U
* device instance $519 r0 *1 4.095,45.7 nfet_01v8
M$519 4234 4021 167 167 nfet_01v8 L=150000U W=210000U AS=51200000000P
+ AD=21875000000P PS=775000U PD=460000U
* device instance $520 r0 *1 4.06,46.1 nfet_01v8
M$520 4 154 4234 167 nfet_01v8 L=150000U W=140000U AS=21875000000P
+ AD=16800000000P PS=460000U PD=380000U
* device instance $521 r0 *1 4.06,46.49 nfet_01v8
M$521 4450 155 4 167 nfet_01v8 L=150000U W=140000U AS=16800000000P
+ AD=21875000000P PS=380000U PD=460000U
* device instance $522 r0 *1 4.095,46.89 nfet_01v8
M$522 167 4209 4450 167 nfet_01v8 L=150000U W=210000U AS=21875000000P
+ AD=51200000000P PS=460000U PD=775000U
* device instance $523 r0 *1 4.095,47.28 nfet_01v8
M$523 4209 4450 167 167 nfet_01v8 L=150000U W=210000U AS=51200000000P
+ AD=21875000000P PS=775000U PD=460000U
* device instance $524 r0 *1 4.06,47.68 nfet_01v8
M$524 3 155 4209 167 nfet_01v8 L=150000U W=140000U AS=21875000000P
+ AD=16800000000P PS=460000U PD=380000U
* device instance $525 r0 *1 4.06,48.07 nfet_01v8
M$525 3774 156 3 167 nfet_01v8 L=150000U W=140000U AS=16800000000P
+ AD=21875000000P PS=380000U PD=460000U
* device instance $526 r0 *1 4.095,48.47 nfet_01v8
M$526 167 3824 3774 167 nfet_01v8 L=150000U W=210000U AS=21875000000P
+ AD=51200000000P PS=460000U PD=775000U
* device instance $527 r0 *1 4.095,48.86 nfet_01v8
M$527 3824 3774 167 167 nfet_01v8 L=150000U W=210000U AS=51200000000P
+ AD=21875000000P PS=775000U PD=460000U
* device instance $528 r0 *1 4.06,49.26 nfet_01v8
M$528 4 156 3824 167 nfet_01v8 L=150000U W=140000U AS=21875000000P
+ AD=16800000000P PS=460000U PD=380000U
* device instance $529 r0 *1 4.06,49.65 nfet_01v8
M$529 4014 157 4 167 nfet_01v8 L=150000U W=140000U AS=16800000000P
+ AD=21875000000P PS=380000U PD=460000U
* device instance $530 r0 *1 4.095,50.05 nfet_01v8
M$530 167 4227 4014 167 nfet_01v8 L=150000U W=210000U AS=21875000000P
+ AD=51200000000P PS=460000U PD=775000U
* device instance $531 r0 *1 4.095,50.44 nfet_01v8
M$531 4227 4014 167 167 nfet_01v8 L=150000U W=210000U AS=51200000000P
+ AD=21875000000P PS=775000U PD=460000U
* device instance $532 r0 *1 4.06,50.84 nfet_01v8
M$532 3 157 4227 167 nfet_01v8 L=150000U W=140000U AS=21875000000P
+ AD=16800000000P PS=460000U PD=380000U
* device instance $533 r0 *1 14.96,44.91 nfet_01v8
M$533 4017 154 19 167 nfet_01v8 L=150000U W=140000U AS=16800000000P
+ AD=21875000000P PS=380000U PD=460000U
* device instance $534 r0 *1 14.995,45.31 nfet_01v8
M$534 167 4230 4017 167 nfet_01v8 L=150000U W=210000U AS=21875000000P
+ AD=51200000000P PS=460000U PD=775000U
* device instance $535 r0 *1 14.995,45.7 nfet_01v8
M$535 4230 4017 167 167 nfet_01v8 L=150000U W=210000U AS=51200000000P
+ AD=21875000000P PS=775000U PD=460000U
* device instance $536 r0 *1 14.96,46.1 nfet_01v8
M$536 20 154 4230 167 nfet_01v8 L=150000U W=140000U AS=21875000000P
+ AD=16800000000P PS=460000U PD=380000U
* device instance $537 r0 *1 14.96,46.49 nfet_01v8
M$537 4466 155 20 167 nfet_01v8 L=150000U W=140000U AS=16800000000P
+ AD=21875000000P PS=380000U PD=460000U
* device instance $538 r0 *1 14.995,46.89 nfet_01v8
M$538 167 3849 4466 167 nfet_01v8 L=150000U W=210000U AS=21875000000P
+ AD=51200000000P PS=460000U PD=775000U
* device instance $539 r0 *1 14.995,47.28 nfet_01v8
M$539 3849 4466 167 167 nfet_01v8 L=150000U W=210000U AS=51200000000P
+ AD=21875000000P PS=775000U PD=460000U
* device instance $540 r0 *1 14.96,47.68 nfet_01v8
M$540 19 155 3849 167 nfet_01v8 L=150000U W=140000U AS=21875000000P
+ AD=16800000000P PS=460000U PD=380000U
* device instance $541 r0 *1 14.96,48.07 nfet_01v8
M$541 4037 156 19 167 nfet_01v8 L=150000U W=140000U AS=16800000000P
+ AD=21875000000P PS=380000U PD=460000U
* device instance $542 r0 *1 14.995,48.47 nfet_01v8
M$542 167 4252 4037 167 nfet_01v8 L=150000U W=210000U AS=21875000000P
+ AD=51200000000P PS=460000U PD=775000U
* device instance $543 r0 *1 14.995,48.86 nfet_01v8
M$543 4252 4037 167 167 nfet_01v8 L=150000U W=210000U AS=51200000000P
+ AD=21875000000P PS=775000U PD=460000U
* device instance $544 r0 *1 14.96,49.26 nfet_01v8
M$544 20 156 4252 167 nfet_01v8 L=150000U W=140000U AS=21875000000P
+ AD=16800000000P PS=460000U PD=380000U
* device instance $545 r0 *1 14.96,49.65 nfet_01v8
M$545 3900 157 20 167 nfet_01v8 L=150000U W=140000U AS=16800000000P
+ AD=21875000000P PS=380000U PD=460000U
* device instance $546 r0 *1 14.995,50.05 nfet_01v8
M$546 167 4090 3900 167 nfet_01v8 L=150000U W=210000U AS=21875000000P
+ AD=51200000000P PS=460000U PD=775000U
* device instance $547 r0 *1 14.995,50.44 nfet_01v8
M$547 4090 3900 167 167 nfet_01v8 L=150000U W=210000U AS=51200000000P
+ AD=21875000000P PS=775000U PD=460000U
* device instance $548 r0 *1 14.96,50.84 nfet_01v8
M$548 19 157 4090 167 nfet_01v8 L=150000U W=140000U AS=21875000000P
+ AD=16800000000P PS=460000U PD=380000U
* device instance $549 r0 *1 25.86,44.91 nfet_01v8
M$549 4051 154 35 167 nfet_01v8 L=150000U W=140000U AS=16800000000P
+ AD=21875000000P PS=380000U PD=460000U
* device instance $550 r0 *1 25.895,45.31 nfet_01v8
M$550 167 4270 4051 167 nfet_01v8 L=150000U W=210000U AS=21875000000P
+ AD=51200000000P PS=460000U PD=775000U
* device instance $551 r0 *1 25.895,45.7 nfet_01v8
M$551 4270 4051 167 167 nfet_01v8 L=150000U W=210000U AS=51200000000P
+ AD=21875000000P PS=775000U PD=460000U
* device instance $552 r0 *1 25.86,46.1 nfet_01v8
M$552 36 154 4270 167 nfet_01v8 L=150000U W=140000U AS=21875000000P
+ AD=16800000000P PS=460000U PD=380000U
* device instance $553 r0 *1 25.86,46.49 nfet_01v8
M$553 4395 155 36 167 nfet_01v8 L=150000U W=140000U AS=16800000000P
+ AD=21875000000P PS=380000U PD=460000U
* device instance $554 r0 *1 25.895,46.89 nfet_01v8
M$554 167 4275 4395 167 nfet_01v8 L=150000U W=210000U AS=21875000000P
+ AD=51200000000P PS=460000U PD=775000U
* device instance $555 r0 *1 25.895,47.28 nfet_01v8
M$555 4275 4395 167 167 nfet_01v8 L=150000U W=210000U AS=51200000000P
+ AD=21875000000P PS=775000U PD=460000U
* device instance $556 r0 *1 25.86,47.68 nfet_01v8
M$556 35 155 4275 167 nfet_01v8 L=150000U W=140000U AS=21875000000P
+ AD=16800000000P PS=460000U PD=380000U
* device instance $557 r0 *1 25.86,48.07 nfet_01v8
M$557 4057 156 35 167 nfet_01v8 L=150000U W=140000U AS=16800000000P
+ AD=21875000000P PS=380000U PD=460000U
* device instance $558 r0 *1 25.895,48.47 nfet_01v8
M$558 167 4277 4057 167 nfet_01v8 L=150000U W=210000U AS=21875000000P
+ AD=51200000000P PS=460000U PD=775000U
* device instance $559 r0 *1 25.895,48.86 nfet_01v8
M$559 4277 4057 167 167 nfet_01v8 L=150000U W=210000U AS=51200000000P
+ AD=21875000000P PS=775000U PD=460000U
* device instance $560 r0 *1 25.86,49.26 nfet_01v8
M$560 36 156 4277 167 nfet_01v8 L=150000U W=140000U AS=21875000000P
+ AD=16800000000P PS=460000U PD=380000U
* device instance $561 r0 *1 25.86,49.65 nfet_01v8
M$561 4028 157 36 167 nfet_01v8 L=150000U W=140000U AS=16800000000P
+ AD=21875000000P PS=380000U PD=460000U
* device instance $562 r0 *1 25.895,50.05 nfet_01v8
M$562 167 4241 4028 167 nfet_01v8 L=150000U W=210000U AS=21875000000P
+ AD=51200000000P PS=460000U PD=775000U
* device instance $563 r0 *1 25.895,50.44 nfet_01v8
M$563 4241 4028 167 167 nfet_01v8 L=150000U W=210000U AS=51200000000P
+ AD=21875000000P PS=775000U PD=460000U
* device instance $564 r0 *1 25.86,50.84 nfet_01v8
M$564 35 157 4241 167 nfet_01v8 L=150000U W=140000U AS=21875000000P
+ AD=16800000000P PS=460000U PD=380000U
* device instance $565 r0 *1 36.76,44.91 nfet_01v8
M$565 4047 154 51 167 nfet_01v8 L=150000U W=140000U AS=16800000000P
+ AD=21875000000P PS=380000U PD=460000U
* device instance $566 r0 *1 36.795,45.31 nfet_01v8
M$566 167 4264 4047 167 nfet_01v8 L=150000U W=210000U AS=21875000000P
+ AD=51200000000P PS=460000U PD=775000U
* device instance $567 r0 *1 36.795,45.7 nfet_01v8
M$567 4264 4047 167 167 nfet_01v8 L=150000U W=210000U AS=51200000000P
+ AD=21875000000P PS=775000U PD=460000U
* device instance $568 r0 *1 36.76,46.1 nfet_01v8
M$568 52 154 4264 167 nfet_01v8 L=150000U W=140000U AS=21875000000P
+ AD=16800000000P PS=460000U PD=380000U
* device instance $569 r0 *1 36.76,46.49 nfet_01v8
M$569 4392 155 52 167 nfet_01v8 L=150000U W=140000U AS=16800000000P
+ AD=21875000000P PS=380000U PD=460000U
* device instance $570 r0 *1 36.795,46.89 nfet_01v8
M$570 167 3796 4392 167 nfet_01v8 L=150000U W=210000U AS=21875000000P
+ AD=51200000000P PS=460000U PD=775000U
* device instance $571 r0 *1 36.795,47.28 nfet_01v8
M$571 3796 4392 167 167 nfet_01v8 L=150000U W=210000U AS=51200000000P
+ AD=21875000000P PS=775000U PD=460000U
* device instance $572 r0 *1 36.76,47.68 nfet_01v8
M$572 51 155 3796 167 nfet_01v8 L=150000U W=140000U AS=21875000000P
+ AD=16800000000P PS=460000U PD=380000U
* device instance $573 r0 *1 36.76,48.07 nfet_01v8
M$573 4007 156 51 167 nfet_01v8 L=150000U W=140000U AS=16800000000P
+ AD=21875000000P PS=380000U PD=460000U
* device instance $574 r0 *1 36.795,48.47 nfet_01v8
M$574 167 4218 4007 167 nfet_01v8 L=150000U W=210000U AS=21875000000P
+ AD=51200000000P PS=460000U PD=775000U
* device instance $575 r0 *1 36.795,48.86 nfet_01v8
M$575 4218 4007 167 167 nfet_01v8 L=150000U W=210000U AS=51200000000P
+ AD=21875000000P PS=775000U PD=460000U
* device instance $576 r0 *1 36.76,49.26 nfet_01v8
M$576 52 156 4218 167 nfet_01v8 L=150000U W=140000U AS=21875000000P
+ AD=16800000000P PS=460000U PD=380000U
* device instance $577 r0 *1 36.76,49.65 nfet_01v8
M$577 4010 157 52 167 nfet_01v8 L=150000U W=140000U AS=16800000000P
+ AD=21875000000P PS=380000U PD=460000U
* device instance $578 r0 *1 36.795,50.05 nfet_01v8
M$578 167 4221 4010 167 nfet_01v8 L=150000U W=210000U AS=21875000000P
+ AD=51200000000P PS=460000U PD=775000U
* device instance $579 r0 *1 36.795,50.44 nfet_01v8
M$579 4221 4010 167 167 nfet_01v8 L=150000U W=210000U AS=51200000000P
+ AD=21875000000P PS=775000U PD=460000U
* device instance $580 r0 *1 36.76,50.84 nfet_01v8
M$580 51 157 4221 167 nfet_01v8 L=150000U W=140000U AS=21875000000P
+ AD=16800000000P PS=460000U PD=380000U
* device instance $581 r0 *1 47.66,44.91 nfet_01v8
M$581 3993 154 67 167 nfet_01v8 L=150000U W=140000U AS=16800000000P
+ AD=21875000000P PS=380000U PD=460000U
* device instance $582 r0 *1 47.695,45.31 nfet_01v8
M$582 167 4201 3993 167 nfet_01v8 L=150000U W=210000U AS=21875000000P
+ AD=51200000000P PS=460000U PD=775000U
* device instance $583 r0 *1 47.695,45.7 nfet_01v8
M$583 4201 3993 167 167 nfet_01v8 L=150000U W=210000U AS=51200000000P
+ AD=21875000000P PS=775000U PD=460000U
* device instance $584 r0 *1 47.66,46.1 nfet_01v8
M$584 68 154 4201 167 nfet_01v8 L=150000U W=140000U AS=21875000000P
+ AD=16800000000P PS=460000U PD=380000U
* device instance $585 r0 *1 47.66,46.49 nfet_01v8
M$585 4358 155 68 167 nfet_01v8 L=150000U W=140000U AS=16800000000P
+ AD=21875000000P PS=380000U PD=460000U
* device instance $586 r0 *1 47.695,46.89 nfet_01v8
M$586 167 4205 4358 167 nfet_01v8 L=150000U W=210000U AS=21875000000P
+ AD=51200000000P PS=460000U PD=775000U
* device instance $587 r0 *1 47.695,47.28 nfet_01v8
M$587 4205 4358 167 167 nfet_01v8 L=150000U W=210000U AS=51200000000P
+ AD=21875000000P PS=775000U PD=460000U
* device instance $588 r0 *1 47.66,47.68 nfet_01v8
M$588 67 155 4205 167 nfet_01v8 L=150000U W=140000U AS=21875000000P
+ AD=16800000000P PS=460000U PD=380000U
* device instance $589 r0 *1 47.66,48.07 nfet_01v8
M$589 3769 156 67 167 nfet_01v8 L=150000U W=140000U AS=16800000000P
+ AD=21875000000P PS=380000U PD=460000U
* device instance $590 r0 *1 47.695,48.47 nfet_01v8
M$590 167 3817 3769 167 nfet_01v8 L=150000U W=210000U AS=21875000000P
+ AD=51200000000P PS=460000U PD=775000U
* device instance $591 r0 *1 47.695,48.86 nfet_01v8
M$591 3817 3769 167 167 nfet_01v8 L=150000U W=210000U AS=51200000000P
+ AD=21875000000P PS=775000U PD=460000U
* device instance $592 r0 *1 47.66,49.26 nfet_01v8
M$592 68 156 3817 167 nfet_01v8 L=150000U W=140000U AS=21875000000P
+ AD=16800000000P PS=460000U PD=380000U
* device instance $593 r0 *1 47.66,49.65 nfet_01v8
M$593 3961 157 68 167 nfet_01v8 L=150000U W=140000U AS=16800000000P
+ AD=21875000000P PS=380000U PD=460000U
* device instance $594 r0 *1 47.695,50.05 nfet_01v8
M$594 167 4161 3961 167 nfet_01v8 L=150000U W=210000U AS=21875000000P
+ AD=51200000000P PS=460000U PD=775000U
* device instance $595 r0 *1 47.695,50.44 nfet_01v8
M$595 4161 3961 167 167 nfet_01v8 L=150000U W=210000U AS=51200000000P
+ AD=21875000000P PS=775000U PD=460000U
* device instance $596 r0 *1 47.66,50.84 nfet_01v8
M$596 67 157 4161 167 nfet_01v8 L=150000U W=140000U AS=21875000000P
+ AD=16800000000P PS=460000U PD=380000U
* device instance $597 r0 *1 58.56,60.71 nfet_01v8
M$597 4042 162 83 167 nfet_01v8 L=150000U W=140000U AS=16800000000P
+ AD=21875000000P PS=380000U PD=460000U
* device instance $598 r0 *1 58.595,61.11 nfet_01v8
M$598 167 4259 4042 167 nfet_01v8 L=150000U W=210000U AS=21875000000P
+ AD=51200000000P PS=460000U PD=775000U
* device instance $599 r0 *1 58.595,61.5 nfet_01v8
M$599 4259 4042 167 167 nfet_01v8 L=150000U W=210000U AS=51200000000P
+ AD=21875000000P PS=775000U PD=460000U
* device instance $600 r0 *1 58.56,61.9 nfet_01v8
M$600 84 162 4259 167 nfet_01v8 L=150000U W=140000U AS=21875000000P
+ AD=16800000000P PS=460000U PD=380000U
* device instance $601 r0 *1 58.56,62.29 nfet_01v8
M$601 4457 163 84 167 nfet_01v8 L=150000U W=140000U AS=16800000000P
+ AD=21875000000P PS=380000U PD=460000U
* device instance $602 r0 *1 58.595,62.69 nfet_01v8
M$602 167 3832 4457 167 nfet_01v8 L=150000U W=210000U AS=21875000000P
+ AD=51200000000P PS=460000U PD=775000U
* device instance $603 r0 *1 58.595,63.08 nfet_01v8
M$603 3832 4457 167 167 nfet_01v8 L=150000U W=210000U AS=51200000000P
+ AD=21875000000P PS=775000U PD=460000U
* device instance $604 r0 *1 58.56,63.48 nfet_01v8
M$604 83 163 3832 167 nfet_01v8 L=150000U W=140000U AS=21875000000P
+ AD=16800000000P PS=460000U PD=380000U
* device instance $605 r0 *1 58.56,63.87 nfet_01v8
M$605 4024 164 83 167 nfet_01v8 L=150000U W=140000U AS=16800000000P
+ AD=21875000000P PS=380000U PD=460000U
* device instance $606 r0 *1 58.595,64.27 nfet_01v8
M$606 167 4237 4024 167 nfet_01v8 L=150000U W=210000U AS=21875000000P
+ AD=51200000000P PS=460000U PD=775000U
* device instance $607 r0 *1 58.595,64.66 nfet_01v8
M$607 4237 4024 167 167 nfet_01v8 L=150000U W=210000U AS=51200000000P
+ AD=21875000000P PS=775000U PD=460000U
* device instance $608 r0 *1 58.56,65.06 nfet_01v8
M$608 84 164 4237 167 nfet_01v8 L=150000U W=140000U AS=21875000000P
+ AD=16800000000P PS=460000U PD=380000U
* device instance $609 r0 *1 58.56,65.45 nfet_01v8
M$609 3990 165 84 167 nfet_01v8 L=150000U W=140000U AS=16800000000P
+ AD=21875000000P PS=380000U PD=460000U
* device instance $610 r0 *1 58.595,65.85 nfet_01v8
M$610 167 4197 3990 167 nfet_01v8 L=150000U W=210000U AS=21875000000P
+ AD=51200000000P PS=460000U PD=775000U
* device instance $611 r0 *1 58.595,66.24 nfet_01v8
M$611 4197 3990 167 167 nfet_01v8 L=150000U W=210000U AS=51200000000P
+ AD=21875000000P PS=775000U PD=460000U
* device instance $612 r0 *1 58.56,66.64 nfet_01v8
M$612 83 165 4197 167 nfet_01v8 L=150000U W=140000U AS=21875000000P
+ AD=16800000000P PS=460000U PD=380000U
* device instance $613 r0 *1 80.36,52.81 nfet_01v8
M$613 4039 158 115 167 nfet_01v8 L=150000U W=140000U AS=16800000000P
+ AD=21875000000P PS=380000U PD=460000U
* device instance $614 r0 *1 80.395,53.21 nfet_01v8
M$614 167 4254 4039 167 nfet_01v8 L=150000U W=210000U AS=21875000000P
+ AD=51200000000P PS=460000U PD=775000U
* device instance $615 r0 *1 80.395,53.6 nfet_01v8
M$615 4254 4039 167 167 nfet_01v8 L=150000U W=210000U AS=51200000000P
+ AD=21875000000P PS=775000U PD=460000U
* device instance $616 r0 *1 80.36,54 nfet_01v8
M$616 116 158 4254 167 nfet_01v8 L=150000U W=140000U AS=21875000000P
+ AD=16800000000P PS=460000U PD=380000U
* device instance $617 r0 *1 80.36,54.39 nfet_01v8
M$617 4397 159 116 167 nfet_01v8 L=150000U W=140000U AS=16800000000P
+ AD=21875000000P PS=380000U PD=460000U
* device instance $618 r0 *1 80.395,54.79 nfet_01v8
M$618 167 3826 4397 167 nfet_01v8 L=150000U W=210000U AS=21875000000P
+ AD=51200000000P PS=460000U PD=775000U
* device instance $619 r0 *1 80.395,55.18 nfet_01v8
M$619 3826 4397 167 167 nfet_01v8 L=150000U W=210000U AS=51200000000P
+ AD=21875000000P PS=775000U PD=460000U
* device instance $620 r0 *1 80.36,55.58 nfet_01v8
M$620 115 159 3826 167 nfet_01v8 L=150000U W=140000U AS=21875000000P
+ AD=16800000000P PS=460000U PD=380000U
* device instance $621 r0 *1 80.36,55.97 nfet_01v8
M$621 3768 160 115 167 nfet_01v8 L=150000U W=140000U AS=16800000000P
+ AD=21875000000P PS=380000U PD=460000U
* device instance $622 r0 *1 80.395,56.37 nfet_01v8
M$622 167 3814 3768 167 nfet_01v8 L=150000U W=210000U AS=21875000000P
+ AD=51200000000P PS=460000U PD=775000U
* device instance $623 r0 *1 80.395,56.76 nfet_01v8
M$623 3814 3768 167 167 nfet_01v8 L=150000U W=210000U AS=51200000000P
+ AD=21875000000P PS=775000U PD=460000U
* device instance $624 r0 *1 80.36,57.16 nfet_01v8
M$624 116 160 3814 167 nfet_01v8 L=150000U W=140000U AS=21875000000P
+ AD=16800000000P PS=460000U PD=380000U
* device instance $625 r0 *1 80.36,57.55 nfet_01v8
M$625 3875 161 116 167 nfet_01v8 L=150000U W=140000U AS=16800000000P
+ AD=21875000000P PS=380000U PD=460000U
* device instance $626 r0 *1 80.395,57.95 nfet_01v8
M$626 167 4063 3875 167 nfet_01v8 L=150000U W=210000U AS=21875000000P
+ AD=51200000000P PS=460000U PD=775000U
* device instance $627 r0 *1 80.395,58.34 nfet_01v8
M$627 4063 3875 167 167 nfet_01v8 L=150000U W=210000U AS=51200000000P
+ AD=21875000000P PS=775000U PD=460000U
* device instance $628 r0 *1 80.36,58.74 nfet_01v8
M$628 115 161 4063 167 nfet_01v8 L=150000U W=140000U AS=21875000000P
+ AD=16800000000P PS=460000U PD=380000U
* device instance $629 r0 *1 80.36,60.71 nfet_01v8
M$629 3874 162 115 167 nfet_01v8 L=150000U W=140000U AS=16800000000P
+ AD=21875000000P PS=380000U PD=460000U
* device instance $630 r0 *1 80.395,61.11 nfet_01v8
M$630 167 4062 3874 167 nfet_01v8 L=150000U W=210000U AS=21875000000P
+ AD=51200000000P PS=460000U PD=775000U
* device instance $631 r0 *1 80.395,61.5 nfet_01v8
M$631 4062 3874 167 167 nfet_01v8 L=150000U W=210000U AS=51200000000P
+ AD=21875000000P PS=775000U PD=460000U
* device instance $632 r0 *1 80.36,61.9 nfet_01v8
M$632 116 162 4062 167 nfet_01v8 L=150000U W=140000U AS=21875000000P
+ AD=16800000000P PS=460000U PD=380000U
* device instance $633 r0 *1 80.36,62.29 nfet_01v8
M$633 4282 163 116 167 nfet_01v8 L=150000U W=140000U AS=16800000000P
+ AD=21875000000P PS=380000U PD=460000U
* device instance $634 r0 *1 80.395,62.69 nfet_01v8
M$634 167 4164 4282 167 nfet_01v8 L=150000U W=210000U AS=21875000000P
+ AD=51200000000P PS=460000U PD=775000U
* device instance $635 r0 *1 80.395,63.08 nfet_01v8
M$635 4164 4282 167 167 nfet_01v8 L=150000U W=210000U AS=51200000000P
+ AD=21875000000P PS=775000U PD=460000U
* device instance $636 r0 *1 80.36,63.48 nfet_01v8
M$636 115 163 4164 167 nfet_01v8 L=150000U W=140000U AS=21875000000P
+ AD=16800000000P PS=460000U PD=380000U
* device instance $637 r0 *1 80.36,63.87 nfet_01v8
M$637 3771 164 115 167 nfet_01v8 L=150000U W=140000U AS=16800000000P
+ AD=21875000000P PS=380000U PD=460000U
* device instance $638 r0 *1 80.395,64.27 nfet_01v8
M$638 167 3819 3771 167 nfet_01v8 L=150000U W=210000U AS=21875000000P
+ AD=51200000000P PS=460000U PD=775000U
* device instance $639 r0 *1 80.395,64.66 nfet_01v8
M$639 3819 3771 167 167 nfet_01v8 L=150000U W=210000U AS=51200000000P
+ AD=21875000000P PS=775000U PD=460000U
* device instance $640 r0 *1 80.36,65.06 nfet_01v8
M$640 116 164 3819 167 nfet_01v8 L=150000U W=140000U AS=21875000000P
+ AD=16800000000P PS=460000U PD=380000U
* device instance $641 r0 *1 80.36,65.45 nfet_01v8
M$641 3969 165 116 167 nfet_01v8 L=150000U W=140000U AS=16800000000P
+ AD=21875000000P PS=380000U PD=460000U
* device instance $642 r0 *1 80.395,65.85 nfet_01v8
M$642 167 4171 3969 167 nfet_01v8 L=150000U W=210000U AS=21875000000P
+ AD=51200000000P PS=460000U PD=775000U
* device instance $643 r0 *1 80.395,66.24 nfet_01v8
M$643 4171 3969 167 167 nfet_01v8 L=150000U W=210000U AS=51200000000P
+ AD=21875000000P PS=775000U PD=460000U
* device instance $644 r0 *1 80.36,66.64 nfet_01v8
M$644 115 165 4171 167 nfet_01v8 L=150000U W=140000U AS=21875000000P
+ AD=16800000000P PS=460000U PD=380000U
* device instance $645 r0 *1 14.96,13.31 nfet_01v8
M$645 3988 138 19 167 nfet_01v8 L=150000U W=140000U AS=16800000000P
+ AD=21875000000P PS=380000U PD=460000U
* device instance $646 r0 *1 14.995,13.71 nfet_01v8
M$646 167 4194 3988 167 nfet_01v8 L=150000U W=210000U AS=21875000000P
+ AD=51200000000P PS=460000U PD=775000U
* device instance $647 r0 *1 14.995,14.1 nfet_01v8
M$647 4194 3988 167 167 nfet_01v8 L=150000U W=210000U AS=51200000000P
+ AD=21875000000P PS=775000U PD=460000U
* device instance $648 r0 *1 14.96,14.5 nfet_01v8
M$648 20 138 4194 167 nfet_01v8 L=150000U W=140000U AS=21875000000P
+ AD=16800000000P PS=460000U PD=380000U
* device instance $649 r0 *1 14.96,14.89 nfet_01v8
M$649 4482 139 20 167 nfet_01v8 L=150000U W=140000U AS=16800000000P
+ AD=21875000000P PS=380000U PD=460000U
* device instance $650 r0 *1 14.995,15.29 nfet_01v8
M$650 167 3823 4482 167 nfet_01v8 L=150000U W=210000U AS=21875000000P
+ AD=51200000000P PS=460000U PD=775000U
* device instance $651 r0 *1 14.995,15.68 nfet_01v8
M$651 3823 4482 167 167 nfet_01v8 L=150000U W=210000U AS=51200000000P
+ AD=21875000000P PS=775000U PD=460000U
* device instance $652 r0 *1 14.96,16.08 nfet_01v8
M$652 19 139 3823 167 nfet_01v8 L=150000U W=140000U AS=21875000000P
+ AD=16800000000P PS=460000U PD=380000U
* device instance $653 r0 *1 14.96,16.47 nfet_01v8
M$653 3986 140 19 167 nfet_01v8 L=150000U W=140000U AS=16800000000P
+ AD=21875000000P PS=380000U PD=460000U
* device instance $654 r0 *1 14.995,16.87 nfet_01v8
M$654 167 4192 3986 167 nfet_01v8 L=150000U W=210000U AS=21875000000P
+ AD=51200000000P PS=460000U PD=775000U
* device instance $655 r0 *1 14.995,17.26 nfet_01v8
M$655 4192 3986 167 167 nfet_01v8 L=150000U W=210000U AS=51200000000P
+ AD=21875000000P PS=775000U PD=460000U
* device instance $656 r0 *1 14.96,17.66 nfet_01v8
M$656 20 140 4192 167 nfet_01v8 L=150000U W=140000U AS=21875000000P
+ AD=16800000000P PS=460000U PD=380000U
* device instance $657 r0 *1 14.96,18.05 nfet_01v8
M$657 3987 141 20 167 nfet_01v8 L=150000U W=140000U AS=16800000000P
+ AD=21875000000P PS=380000U PD=460000U
* device instance $658 r0 *1 14.995,18.45 nfet_01v8
M$658 167 4193 3987 167 nfet_01v8 L=150000U W=210000U AS=21875000000P
+ AD=51200000000P PS=460000U PD=775000U
* device instance $659 r0 *1 14.995,18.84 nfet_01v8
M$659 4193 3987 167 167 nfet_01v8 L=150000U W=210000U AS=51200000000P
+ AD=21875000000P PS=775000U PD=460000U
* device instance $660 r0 *1 14.96,19.24 nfet_01v8
M$660 19 141 4193 167 nfet_01v8 L=150000U W=140000U AS=21875000000P
+ AD=16800000000P PS=460000U PD=380000U
* device instance $661 r0 *1 25.86,13.31 nfet_01v8
M$661 3909 138 35 167 nfet_01v8 L=150000U W=140000U AS=16800000000P
+ AD=21875000000P PS=380000U PD=460000U
* device instance $662 r0 *1 25.895,13.71 nfet_01v8
M$662 167 4099 3909 167 nfet_01v8 L=150000U W=210000U AS=21875000000P
+ AD=51200000000P PS=460000U PD=775000U
* device instance $663 r0 *1 25.895,14.1 nfet_01v8
M$663 4099 3909 167 167 nfet_01v8 L=150000U W=210000U AS=51200000000P
+ AD=21875000000P PS=775000U PD=460000U
* device instance $664 r0 *1 25.86,14.5 nfet_01v8
M$664 36 138 4099 167 nfet_01v8 L=150000U W=140000U AS=21875000000P
+ AD=16800000000P PS=460000U PD=380000U
* device instance $665 r0 *1 25.86,14.89 nfet_01v8
M$665 4280 139 36 167 nfet_01v8 L=150000U W=140000U AS=16800000000P
+ AD=21875000000P PS=380000U PD=460000U
* device instance $666 r0 *1 25.895,15.29 nfet_01v8
M$666 167 3864 4280 167 nfet_01v8 L=150000U W=210000U AS=21875000000P
+ AD=51200000000P PS=460000U PD=775000U
* device instance $667 r0 *1 25.895,15.68 nfet_01v8
M$667 3864 4280 167 167 nfet_01v8 L=150000U W=210000U AS=51200000000P
+ AD=21875000000P PS=775000U PD=460000U
* device instance $668 r0 *1 25.86,16.08 nfet_01v8
M$668 35 139 3864 167 nfet_01v8 L=150000U W=140000U AS=21875000000P
+ AD=16800000000P PS=460000U PD=380000U
* device instance $669 r0 *1 25.86,16.47 nfet_01v8
M$669 3929 140 35 167 nfet_01v8 L=150000U W=140000U AS=16800000000P
+ AD=21875000000P PS=380000U PD=460000U
* device instance $670 r0 *1 25.895,16.87 nfet_01v8
M$670 167 4122 3929 167 nfet_01v8 L=150000U W=210000U AS=21875000000P
+ AD=51200000000P PS=460000U PD=775000U
* device instance $671 r0 *1 25.895,17.26 nfet_01v8
M$671 4122 3929 167 167 nfet_01v8 L=150000U W=210000U AS=51200000000P
+ AD=21875000000P PS=775000U PD=460000U
* device instance $672 r0 *1 25.86,17.66 nfet_01v8
M$672 36 140 4122 167 nfet_01v8 L=150000U W=140000U AS=21875000000P
+ AD=16800000000P PS=460000U PD=380000U
* device instance $673 r0 *1 25.86,18.05 nfet_01v8
M$673 3930 141 36 167 nfet_01v8 L=150000U W=140000U AS=16800000000P
+ AD=21875000000P PS=380000U PD=460000U
* device instance $674 r0 *1 25.895,18.45 nfet_01v8
M$674 167 4124 3930 167 nfet_01v8 L=150000U W=210000U AS=21875000000P
+ AD=51200000000P PS=460000U PD=775000U
* device instance $675 r0 *1 25.895,18.84 nfet_01v8
M$675 4124 3930 167 167 nfet_01v8 L=150000U W=210000U AS=51200000000P
+ AD=21875000000P PS=775000U PD=460000U
* device instance $676 r0 *1 25.86,19.24 nfet_01v8
M$676 35 141 4124 167 nfet_01v8 L=150000U W=140000U AS=21875000000P
+ AD=16800000000P PS=460000U PD=380000U
* device instance $677 r0 *1 36.76,13.31 nfet_01v8
M$677 3921 138 51 167 nfet_01v8 L=150000U W=140000U AS=16800000000P
+ AD=21875000000P PS=380000U PD=460000U
* device instance $678 r0 *1 36.795,13.71 nfet_01v8
M$678 167 4114 3921 167 nfet_01v8 L=150000U W=210000U AS=21875000000P
+ AD=51200000000P PS=460000U PD=775000U
* device instance $679 r0 *1 36.795,14.1 nfet_01v8
M$679 4114 3921 167 167 nfet_01v8 L=150000U W=210000U AS=51200000000P
+ AD=21875000000P PS=775000U PD=460000U
* device instance $680 r0 *1 36.76,14.5 nfet_01v8
M$680 52 138 4114 167 nfet_01v8 L=150000U W=140000U AS=21875000000P
+ AD=16800000000P PS=460000U PD=380000U
* device instance $681 r0 *1 36.76,14.89 nfet_01v8
M$681 4498 139 52 167 nfet_01v8 L=150000U W=140000U AS=16800000000P
+ AD=21875000000P PS=380000U PD=460000U
* device instance $682 r0 *1 36.795,15.29 nfet_01v8
M$682 167 4111 4498 167 nfet_01v8 L=150000U W=210000U AS=21875000000P
+ AD=51200000000P PS=460000U PD=775000U
* device instance $683 r0 *1 36.795,15.68 nfet_01v8
M$683 4111 4498 167 167 nfet_01v8 L=150000U W=210000U AS=51200000000P
+ AD=21875000000P PS=775000U PD=460000U
* device instance $684 r0 *1 36.76,16.08 nfet_01v8
M$684 51 139 4111 167 nfet_01v8 L=150000U W=140000U AS=21875000000P
+ AD=16800000000P PS=460000U PD=380000U
* device instance $685 r0 *1 36.76,16.47 nfet_01v8
M$685 3956 140 51 167 nfet_01v8 L=150000U W=140000U AS=16800000000P
+ AD=21875000000P PS=380000U PD=460000U
* device instance $686 r0 *1 36.795,16.87 nfet_01v8
M$686 167 4155 3956 167 nfet_01v8 L=150000U W=210000U AS=21875000000P
+ AD=51200000000P PS=460000U PD=775000U
* device instance $687 r0 *1 36.795,17.26 nfet_01v8
M$687 4155 3956 167 167 nfet_01v8 L=150000U W=210000U AS=51200000000P
+ AD=21875000000P PS=775000U PD=460000U
* device instance $688 r0 *1 36.76,17.66 nfet_01v8
M$688 52 140 4155 167 nfet_01v8 L=150000U W=140000U AS=21875000000P
+ AD=16800000000P PS=460000U PD=380000U
* device instance $689 r0 *1 36.76,18.05 nfet_01v8
M$689 3918 141 52 167 nfet_01v8 L=150000U W=140000U AS=16800000000P
+ AD=21875000000P PS=380000U PD=460000U
* device instance $690 r0 *1 36.795,18.45 nfet_01v8
M$690 167 4110 3918 167 nfet_01v8 L=150000U W=210000U AS=21875000000P
+ AD=51200000000P PS=460000U PD=775000U
* device instance $691 r0 *1 36.795,18.84 nfet_01v8
M$691 4110 3918 167 167 nfet_01v8 L=150000U W=210000U AS=51200000000P
+ AD=21875000000P PS=775000U PD=460000U
* device instance $692 r0 *1 36.76,19.24 nfet_01v8
M$692 51 141 4110 167 nfet_01v8 L=150000U W=140000U AS=21875000000P
+ AD=16800000000P PS=460000U PD=380000U
* device instance $693 r0 *1 47.66,13.31 nfet_01v8
M$693 3872 138 67 167 nfet_01v8 L=150000U W=140000U AS=16800000000P
+ AD=21875000000P PS=380000U PD=460000U
* device instance $694 r0 *1 47.695,13.71 nfet_01v8
M$694 167 4060 3872 167 nfet_01v8 L=150000U W=210000U AS=21875000000P
+ AD=51200000000P PS=460000U PD=775000U
* device instance $695 r0 *1 47.695,14.1 nfet_01v8
M$695 4060 3872 167 167 nfet_01v8 L=150000U W=210000U AS=51200000000P
+ AD=21875000000P PS=775000U PD=460000U
* device instance $696 r0 *1 47.66,14.5 nfet_01v8
M$696 68 138 4060 167 nfet_01v8 L=150000U W=140000U AS=21875000000P
+ AD=16800000000P PS=460000U PD=380000U
* device instance $697 r0 *1 47.66,14.89 nfet_01v8
M$697 4374 139 68 167 nfet_01v8 L=150000U W=140000U AS=16800000000P
+ AD=21875000000P PS=380000U PD=460000U
* device instance $698 r0 *1 47.695,15.29 nfet_01v8
M$698 167 4058 4374 167 nfet_01v8 L=150000U W=210000U AS=21875000000P
+ AD=51200000000P PS=460000U PD=775000U
* device instance $699 r0 *1 47.695,15.68 nfet_01v8
M$699 4058 4374 167 167 nfet_01v8 L=150000U W=210000U AS=51200000000P
+ AD=21875000000P PS=775000U PD=460000U
* device instance $700 r0 *1 47.66,16.08 nfet_01v8
M$700 67 139 4058 167 nfet_01v8 L=150000U W=140000U AS=21875000000P
+ AD=16800000000P PS=460000U PD=380000U
* device instance $701 r0 *1 47.66,16.47 nfet_01v8
M$701 3763 140 67 167 nfet_01v8 L=150000U W=140000U AS=16800000000P
+ AD=21875000000P PS=380000U PD=460000U
* device instance $702 r0 *1 47.695,16.87 nfet_01v8
M$702 167 3808 3763 167 nfet_01v8 L=150000U W=210000U AS=21875000000P
+ AD=51200000000P PS=460000U PD=775000U
* device instance $703 r0 *1 47.695,17.26 nfet_01v8
M$703 3808 3763 167 167 nfet_01v8 L=150000U W=210000U AS=51200000000P
+ AD=21875000000P PS=775000U PD=460000U
* device instance $704 r0 *1 47.66,17.66 nfet_01v8
M$704 68 140 3808 167 nfet_01v8 L=150000U W=140000U AS=21875000000P
+ AD=16800000000P PS=460000U PD=380000U
* device instance $705 r0 *1 47.66,18.05 nfet_01v8
M$705 3902 141 68 167 nfet_01v8 L=150000U W=140000U AS=16800000000P
+ AD=21875000000P PS=380000U PD=460000U
* device instance $706 r0 *1 47.695,18.45 nfet_01v8
M$706 167 4092 3902 167 nfet_01v8 L=150000U W=210000U AS=21875000000P
+ AD=51200000000P PS=460000U PD=775000U
* device instance $707 r0 *1 47.695,18.84 nfet_01v8
M$707 4092 3902 167 167 nfet_01v8 L=150000U W=210000U AS=51200000000P
+ AD=21875000000P PS=775000U PD=460000U
* device instance $708 r0 *1 47.66,19.24 nfet_01v8
M$708 67 141 4092 167 nfet_01v8 L=150000U W=140000U AS=21875000000P
+ AD=16800000000P PS=460000U PD=380000U
* device instance $709 r0 *1 58.56,13.31 nfet_01v8
M$709 3884 138 83 167 nfet_01v8 L=150000U W=140000U AS=16800000000P
+ AD=21875000000P PS=380000U PD=460000U
* device instance $710 r0 *1 58.595,13.71 nfet_01v8
M$710 167 4072 3884 167 nfet_01v8 L=150000U W=210000U AS=21875000000P
+ AD=51200000000P PS=460000U PD=775000U
* device instance $711 r0 *1 58.595,14.1 nfet_01v8
M$711 4072 3884 167 167 nfet_01v8 L=150000U W=210000U AS=51200000000P
+ AD=21875000000P PS=775000U PD=460000U
* device instance $712 r0 *1 58.56,14.5 nfet_01v8
M$712 84 138 4072 167 nfet_01v8 L=150000U W=140000U AS=21875000000P
+ AD=16800000000P PS=460000U PD=380000U
* device instance $713 r0 *1 58.56,14.89 nfet_01v8
M$713 4371 139 84 167 nfet_01v8 L=150000U W=140000U AS=16800000000P
+ AD=21875000000P PS=380000U PD=460000U
* device instance $714 r0 *1 58.595,15.29 nfet_01v8
M$714 167 3815 4371 167 nfet_01v8 L=150000U W=210000U AS=21875000000P
+ AD=51200000000P PS=460000U PD=775000U
* device instance $715 r0 *1 58.595,15.68 nfet_01v8
M$715 3815 4371 167 167 nfet_01v8 L=150000U W=210000U AS=51200000000P
+ AD=21875000000P PS=775000U PD=460000U
* device instance $716 r0 *1 58.56,16.08 nfet_01v8
M$716 83 139 3815 167 nfet_01v8 L=150000U W=140000U AS=21875000000P
+ AD=16800000000P PS=460000U PD=380000U
* device instance $717 r0 *1 58.56,16.47 nfet_01v8
M$717 3876 140 83 167 nfet_01v8 L=150000U W=140000U AS=16800000000P
+ AD=21875000000P PS=380000U PD=460000U
* device instance $718 r0 *1 58.595,16.87 nfet_01v8
M$718 167 4064 3876 167 nfet_01v8 L=150000U W=210000U AS=21875000000P
+ AD=51200000000P PS=460000U PD=775000U
* device instance $719 r0 *1 58.595,17.26 nfet_01v8
M$719 4064 3876 167 167 nfet_01v8 L=150000U W=210000U AS=51200000000P
+ AD=21875000000P PS=775000U PD=460000U
* device instance $720 r0 *1 58.56,17.66 nfet_01v8
M$720 84 140 4064 167 nfet_01v8 L=150000U W=140000U AS=21875000000P
+ AD=16800000000P PS=460000U PD=380000U
* device instance $721 r0 *1 58.56,18.05 nfet_01v8
M$721 3903 141 84 167 nfet_01v8 L=150000U W=140000U AS=16800000000P
+ AD=21875000000P PS=380000U PD=460000U
* device instance $722 r0 *1 58.595,18.45 nfet_01v8
M$722 167 4093 3903 167 nfet_01v8 L=150000U W=210000U AS=21875000000P
+ AD=51200000000P PS=460000U PD=775000U
* device instance $723 r0 *1 58.595,18.84 nfet_01v8
M$723 4093 3903 167 167 nfet_01v8 L=150000U W=210000U AS=51200000000P
+ AD=21875000000P PS=775000U PD=460000U
* device instance $724 r0 *1 58.56,19.24 nfet_01v8
M$724 83 141 4093 167 nfet_01v8 L=150000U W=140000U AS=21875000000P
+ AD=16800000000P PS=460000U PD=380000U
* device instance $725 r0 *1 69.46,13.31 nfet_01v8
M$725 3943 138 99 167 nfet_01v8 L=150000U W=140000U AS=16800000000P
+ AD=21875000000P PS=380000U PD=460000U
* device instance $726 r0 *1 69.495,13.71 nfet_01v8
M$726 167 4141 3943 167 nfet_01v8 L=150000U W=210000U AS=21875000000P
+ AD=51200000000P PS=460000U PD=775000U
* device instance $727 r0 *1 69.495,14.1 nfet_01v8
M$727 4141 3943 167 167 nfet_01v8 L=150000U W=210000U AS=51200000000P
+ AD=21875000000P PS=775000U PD=460000U
* device instance $728 r0 *1 69.46,14.5 nfet_01v8
M$728 100 138 4141 167 nfet_01v8 L=150000U W=140000U AS=21875000000P
+ AD=16800000000P PS=460000U PD=380000U
* device instance $729 r0 *1 69.46,14.89 nfet_01v8
M$729 4342 139 100 167 nfet_01v8 L=150000U W=140000U AS=16800000000P
+ AD=21875000000P PS=380000U PD=460000U
* device instance $730 r0 *1 69.495,15.29 nfet_01v8
M$730 167 3844 4342 167 nfet_01v8 L=150000U W=210000U AS=21875000000P
+ AD=51200000000P PS=460000U PD=775000U
* device instance $731 r0 *1 69.495,15.68 nfet_01v8
M$731 3844 4342 167 167 nfet_01v8 L=150000U W=210000U AS=51200000000P
+ AD=21875000000P PS=775000U PD=460000U
* device instance $732 r0 *1 69.46,16.08 nfet_01v8
M$732 99 139 3844 167 nfet_01v8 L=150000U W=140000U AS=21875000000P
+ AD=16800000000P PS=460000U PD=380000U
* device instance $733 r0 *1 69.46,16.47 nfet_01v8
M$733 3778 140 99 167 nfet_01v8 L=150000U W=140000U AS=16800000000P
+ AD=21875000000P PS=380000U PD=460000U
* device instance $734 r0 *1 69.495,16.87 nfet_01v8
M$734 167 3831 3778 167 nfet_01v8 L=150000U W=210000U AS=21875000000P
+ AD=51200000000P PS=460000U PD=775000U
* device instance $735 r0 *1 69.495,17.26 nfet_01v8
M$735 3831 3778 167 167 nfet_01v8 L=150000U W=210000U AS=51200000000P
+ AD=21875000000P PS=775000U PD=460000U
* device instance $736 r0 *1 69.46,17.66 nfet_01v8
M$736 100 140 3831 167 nfet_01v8 L=150000U W=140000U AS=21875000000P
+ AD=16800000000P PS=460000U PD=380000U
* device instance $737 r0 *1 69.46,18.05 nfet_01v8
M$737 3944 141 100 167 nfet_01v8 L=150000U W=140000U AS=16800000000P
+ AD=21875000000P PS=380000U PD=460000U
* device instance $738 r0 *1 69.495,18.45 nfet_01v8
M$738 167 4142 3944 167 nfet_01v8 L=150000U W=210000U AS=21875000000P
+ AD=51200000000P PS=460000U PD=775000U
* device instance $739 r0 *1 69.495,18.84 nfet_01v8
M$739 4142 3944 167 167 nfet_01v8 L=150000U W=210000U AS=51200000000P
+ AD=21875000000P PS=775000U PD=460000U
* device instance $740 r0 *1 69.46,19.24 nfet_01v8
M$740 99 141 4142 167 nfet_01v8 L=150000U W=140000U AS=21875000000P
+ AD=16800000000P PS=460000U PD=380000U
* device instance $741 r0 *1 4.06,5.41 nfet_01v8
M$741 3976 134 3 167 nfet_01v8 L=150000U W=140000U AS=16800000000P
+ AD=21875000000P PS=380000U PD=460000U
* device instance $742 r0 *1 4.095,5.81 nfet_01v8
M$742 167 4182 3976 167 nfet_01v8 L=150000U W=210000U AS=21875000000P
+ AD=51200000000P PS=460000U PD=775000U
* device instance $743 r0 *1 4.095,6.2 nfet_01v8
M$743 4182 3976 167 167 nfet_01v8 L=150000U W=210000U AS=51200000000P
+ AD=21875000000P PS=775000U PD=460000U
* device instance $744 r0 *1 4.06,6.6 nfet_01v8
M$744 4 134 4182 167 nfet_01v8 L=150000U W=140000U AS=21875000000P
+ AD=16800000000P PS=460000U PD=380000U
* device instance $745 r0 *1 4.06,6.99 nfet_01v8
M$745 4499 135 4 167 nfet_01v8 L=150000U W=140000U AS=16800000000P
+ AD=21875000000P PS=380000U PD=460000U
* device instance $746 r0 *1 4.095,7.39 nfet_01v8
M$746 167 4181 4499 167 nfet_01v8 L=150000U W=210000U AS=21875000000P
+ AD=51200000000P PS=460000U PD=775000U
* device instance $747 r0 *1 4.095,7.78 nfet_01v8
M$747 4181 4499 167 167 nfet_01v8 L=150000U W=210000U AS=51200000000P
+ AD=21875000000P PS=775000U PD=460000U
* device instance $748 r0 *1 4.06,8.18 nfet_01v8
M$748 3 135 4181 167 nfet_01v8 L=150000U W=140000U AS=21875000000P
+ AD=16800000000P PS=460000U PD=380000U
* device instance $749 r0 *1 4.06,8.57 nfet_01v8
M$749 3974 136 3 167 nfet_01v8 L=150000U W=140000U AS=16800000000P
+ AD=21875000000P PS=380000U PD=460000U
* device instance $750 r0 *1 4.095,8.97 nfet_01v8
M$750 167 4178 3974 167 nfet_01v8 L=150000U W=210000U AS=21875000000P
+ AD=51200000000P PS=460000U PD=775000U
* device instance $751 r0 *1 4.095,9.36 nfet_01v8
M$751 4178 3974 167 167 nfet_01v8 L=150000U W=210000U AS=51200000000P
+ AD=21875000000P PS=775000U PD=460000U
* device instance $752 r0 *1 4.06,9.76 nfet_01v8
M$752 4 136 4178 167 nfet_01v8 L=150000U W=140000U AS=21875000000P
+ AD=16800000000P PS=460000U PD=380000U
* device instance $753 r0 *1 4.06,10.15 nfet_01v8
M$753 3958 137 4 167 nfet_01v8 L=150000U W=140000U AS=16800000000P
+ AD=21875000000P PS=380000U PD=460000U
* device instance $754 r0 *1 4.095,10.55 nfet_01v8
M$754 167 4157 3958 167 nfet_01v8 L=150000U W=210000U AS=21875000000P
+ AD=51200000000P PS=460000U PD=775000U
* device instance $755 r0 *1 4.095,10.94 nfet_01v8
M$755 4157 3958 167 167 nfet_01v8 L=150000U W=210000U AS=51200000000P
+ AD=21875000000P PS=775000U PD=460000U
* device instance $756 r0 *1 4.06,11.34 nfet_01v8
M$756 3 137 4157 167 nfet_01v8 L=150000U W=140000U AS=21875000000P
+ AD=16800000000P PS=460000U PD=380000U
* device instance $757 r0 *1 14.96,5.41 nfet_01v8
M$757 3980 134 19 167 nfet_01v8 L=150000U W=140000U AS=16800000000P
+ AD=21875000000P PS=380000U PD=460000U
* device instance $758 r0 *1 14.995,5.81 nfet_01v8
M$758 167 4186 3980 167 nfet_01v8 L=150000U W=210000U AS=21875000000P
+ AD=51200000000P PS=460000U PD=775000U
* device instance $759 r0 *1 14.995,6.2 nfet_01v8
M$759 4186 3980 167 167 nfet_01v8 L=150000U W=210000U AS=51200000000P
+ AD=21875000000P PS=775000U PD=460000U
* device instance $760 r0 *1 14.96,6.6 nfet_01v8
M$760 20 134 4186 167 nfet_01v8 L=150000U W=140000U AS=21875000000P
+ AD=16800000000P PS=460000U PD=380000U
* device instance $761 r0 *1 14.96,6.99 nfet_01v8
M$761 4503 135 20 167 nfet_01v8 L=150000U W=140000U AS=16800000000P
+ AD=21875000000P PS=380000U PD=460000U
* device instance $762 r0 *1 14.995,7.39 nfet_01v8
M$762 167 3806 4503 167 nfet_01v8 L=150000U W=210000U AS=21875000000P
+ AD=51200000000P PS=460000U PD=775000U
* device instance $763 r0 *1 14.995,7.78 nfet_01v8
M$763 3806 4503 167 167 nfet_01v8 L=150000U W=210000U AS=51200000000P
+ AD=21875000000P PS=775000U PD=460000U
* device instance $764 r0 *1 14.96,8.18 nfet_01v8
M$764 19 135 3806 167 nfet_01v8 L=150000U W=140000U AS=21875000000P
+ AD=16800000000P PS=460000U PD=380000U
* device instance $765 r0 *1 14.96,8.57 nfet_01v8
M$765 3764 136 19 167 nfet_01v8 L=150000U W=140000U AS=16800000000P
+ AD=21875000000P PS=380000U PD=460000U
* device instance $766 r0 *1 14.995,8.97 nfet_01v8
M$766 167 3809 3764 167 nfet_01v8 L=150000U W=210000U AS=21875000000P
+ AD=51200000000P PS=460000U PD=775000U
* device instance $767 r0 *1 14.995,9.36 nfet_01v8
M$767 3809 3764 167 167 nfet_01v8 L=150000U W=210000U AS=51200000000P
+ AD=21875000000P PS=775000U PD=460000U
* device instance $768 r0 *1 14.96,9.76 nfet_01v8
M$768 20 136 3809 167 nfet_01v8 L=150000U W=140000U AS=21875000000P
+ AD=16800000000P PS=460000U PD=380000U
* device instance $769 r0 *1 14.96,10.15 nfet_01v8
M$769 3959 137 20 167 nfet_01v8 L=150000U W=140000U AS=16800000000P
+ AD=21875000000P PS=380000U PD=460000U
* device instance $770 r0 *1 14.995,10.55 nfet_01v8
M$770 167 4158 3959 167 nfet_01v8 L=150000U W=210000U AS=21875000000P
+ AD=51200000000P PS=460000U PD=775000U
* device instance $771 r0 *1 14.995,10.94 nfet_01v8
M$771 4158 3959 167 167 nfet_01v8 L=150000U W=210000U AS=51200000000P
+ AD=21875000000P PS=775000U PD=460000U
* device instance $772 r0 *1 14.96,11.34 nfet_01v8
M$772 19 137 4158 167 nfet_01v8 L=150000U W=140000U AS=21875000000P
+ AD=16800000000P PS=460000U PD=380000U
* device instance $773 r0 *1 25.86,5.41 nfet_01v8
M$773 3913 134 35 167 nfet_01v8 L=150000U W=140000U AS=16800000000P
+ AD=21875000000P PS=380000U PD=460000U
* device instance $774 r0 *1 25.895,5.81 nfet_01v8
M$774 167 4103 3913 167 nfet_01v8 L=150000U W=210000U AS=21875000000P
+ AD=51200000000P PS=460000U PD=775000U
* device instance $775 r0 *1 25.895,6.2 nfet_01v8
M$775 4103 3913 167 167 nfet_01v8 L=150000U W=210000U AS=51200000000P
+ AD=21875000000P PS=775000U PD=460000U
* device instance $776 r0 *1 25.86,6.6 nfet_01v8
M$776 36 134 4103 167 nfet_01v8 L=150000U W=140000U AS=21875000000P
+ AD=16800000000P PS=460000U PD=380000U
* device instance $777 r0 *1 25.86,6.99 nfet_01v8
M$777 4297 135 36 167 nfet_01v8 L=150000U W=140000U AS=16800000000P
+ AD=21875000000P PS=380000U PD=460000U
* device instance $778 r0 *1 25.895,7.39 nfet_01v8
M$778 167 4104 4297 167 nfet_01v8 L=150000U W=210000U AS=21875000000P
+ AD=51200000000P PS=460000U PD=775000U
* device instance $779 r0 *1 25.895,7.78 nfet_01v8
M$779 4104 4297 167 167 nfet_01v8 L=150000U W=210000U AS=51200000000P
+ AD=21875000000P PS=775000U PD=460000U
* device instance $780 r0 *1 25.86,8.18 nfet_01v8
M$780 35 135 4104 167 nfet_01v8 L=150000U W=140000U AS=21875000000P
+ AD=16800000000P PS=460000U PD=380000U
* device instance $781 r0 *1 25.86,8.57 nfet_01v8
M$781 3793 136 35 167 nfet_01v8 L=150000U W=140000U AS=16800000000P
+ AD=21875000000P PS=380000U PD=460000U
* device instance $782 r0 *1 25.895,8.97 nfet_01v8
M$782 167 3869 3793 167 nfet_01v8 L=150000U W=210000U AS=21875000000P
+ AD=51200000000P PS=460000U PD=775000U
* device instance $783 r0 *1 25.895,9.36 nfet_01v8
M$783 3869 3793 167 167 nfet_01v8 L=150000U W=210000U AS=51200000000P
+ AD=21875000000P PS=775000U PD=460000U
* device instance $784 r0 *1 25.86,9.76 nfet_01v8
M$784 36 136 3869 167 nfet_01v8 L=150000U W=140000U AS=21875000000P
+ AD=16800000000P PS=460000U PD=380000U
* device instance $785 r0 *1 25.86,10.15 nfet_01v8
M$785 3983 137 36 167 nfet_01v8 L=150000U W=140000U AS=16800000000P
+ AD=21875000000P PS=380000U PD=460000U
* device instance $786 r0 *1 25.895,10.55 nfet_01v8
M$786 167 4189 3983 167 nfet_01v8 L=150000U W=210000U AS=21875000000P
+ AD=51200000000P PS=460000U PD=775000U
* device instance $787 r0 *1 25.895,10.94 nfet_01v8
M$787 4189 3983 167 167 nfet_01v8 L=150000U W=210000U AS=51200000000P
+ AD=21875000000P PS=775000U PD=460000U
* device instance $788 r0 *1 25.86,11.34 nfet_01v8
M$788 35 137 4189 167 nfet_01v8 L=150000U W=140000U AS=21875000000P
+ AD=16800000000P PS=460000U PD=380000U
* device instance $789 r0 *1 36.76,5.41 nfet_01v8
M$789 3940 134 51 167 nfet_01v8 L=150000U W=140000U AS=16800000000P
+ AD=21875000000P PS=380000U PD=460000U
* device instance $790 r0 *1 36.795,5.81 nfet_01v8
M$790 167 4137 3940 167 nfet_01v8 L=150000U W=210000U AS=21875000000P
+ AD=51200000000P PS=460000U PD=775000U
* device instance $791 r0 *1 36.795,6.2 nfet_01v8
M$791 4137 3940 167 167 nfet_01v8 L=150000U W=210000U AS=51200000000P
+ AD=21875000000P PS=775000U PD=460000U
* device instance $792 r0 *1 36.76,6.6 nfet_01v8
M$792 52 134 4137 167 nfet_01v8 L=150000U W=140000U AS=21875000000P
+ AD=16800000000P PS=460000U PD=380000U
* device instance $793 r0 *1 36.76,6.99 nfet_01v8
M$793 4298 135 52 167 nfet_01v8 L=150000U W=140000U AS=16800000000P
+ AD=21875000000P PS=380000U PD=460000U
* device instance $794 r0 *1 36.795,7.39 nfet_01v8
M$794 167 4106 4298 167 nfet_01v8 L=150000U W=210000U AS=21875000000P
+ AD=51200000000P PS=460000U PD=775000U
* device instance $795 r0 *1 36.795,7.78 nfet_01v8
M$795 4106 4298 167 167 nfet_01v8 L=150000U W=210000U AS=51200000000P
+ AD=21875000000P PS=775000U PD=460000U
* device instance $796 r0 *1 36.76,8.18 nfet_01v8
M$796 51 135 4106 167 nfet_01v8 L=150000U W=140000U AS=21875000000P
+ AD=16800000000P PS=460000U PD=380000U
* device instance $797 r0 *1 36.76,8.57 nfet_01v8
M$797 3915 136 51 167 nfet_01v8 L=150000U W=140000U AS=16800000000P
+ AD=21875000000P PS=380000U PD=460000U
* device instance $798 r0 *1 36.795,8.97 nfet_01v8
M$798 167 4107 3915 167 nfet_01v8 L=150000U W=210000U AS=21875000000P
+ AD=51200000000P PS=460000U PD=775000U
* device instance $799 r0 *1 36.795,9.36 nfet_01v8
M$799 4107 3915 167 167 nfet_01v8 L=150000U W=210000U AS=51200000000P
+ AD=21875000000P PS=775000U PD=460000U
* device instance $800 r0 *1 36.76,9.76 nfet_01v8
M$800 52 136 4107 167 nfet_01v8 L=150000U W=140000U AS=21875000000P
+ AD=16800000000P PS=460000U PD=380000U
* device instance $801 r0 *1 36.76,10.15 nfet_01v8
M$801 3982 137 52 167 nfet_01v8 L=150000U W=140000U AS=16800000000P
+ AD=21875000000P PS=380000U PD=460000U
* device instance $802 r0 *1 36.795,10.55 nfet_01v8
M$802 167 4188 3982 167 nfet_01v8 L=150000U W=210000U AS=21875000000P
+ AD=51200000000P PS=460000U PD=775000U
* device instance $803 r0 *1 36.795,10.94 nfet_01v8
M$803 4188 3982 167 167 nfet_01v8 L=150000U W=210000U AS=51200000000P
+ AD=21875000000P PS=775000U PD=460000U
* device instance $804 r0 *1 36.76,11.34 nfet_01v8
M$804 51 137 4188 167 nfet_01v8 L=150000U W=140000U AS=21875000000P
+ AD=16800000000P PS=460000U PD=380000U
* device instance $805 r0 *1 47.66,5.41 nfet_01v8
M$805 3908 134 67 167 nfet_01v8 L=150000U W=140000U AS=16800000000P
+ AD=21875000000P PS=380000U PD=460000U
* device instance $806 r0 *1 47.695,5.81 nfet_01v8
M$806 167 4098 3908 167 nfet_01v8 L=150000U W=210000U AS=21875000000P
+ AD=51200000000P PS=460000U PD=775000U
* device instance $807 r0 *1 47.695,6.2 nfet_01v8
M$807 4098 3908 167 167 nfet_01v8 L=150000U W=210000U AS=51200000000P
+ AD=21875000000P PS=775000U PD=460000U
* device instance $808 r0 *1 47.66,6.6 nfet_01v8
M$808 68 134 4098 167 nfet_01v8 L=150000U W=140000U AS=21875000000P
+ AD=16800000000P PS=460000U PD=380000U
* device instance $809 r0 *1 47.66,6.99 nfet_01v8
M$809 4326 135 68 167 nfet_01v8 L=150000U W=140000U AS=16800000000P
+ AD=21875000000P PS=380000U PD=460000U
* device instance $810 r0 *1 47.695,7.39 nfet_01v8
M$810 167 4086 4326 167 nfet_01v8 L=150000U W=210000U AS=21875000000P
+ AD=51200000000P PS=460000U PD=775000U
* device instance $811 r0 *1 47.695,7.78 nfet_01v8
M$811 4086 4326 167 167 nfet_01v8 L=150000U W=210000U AS=51200000000P
+ AD=21875000000P PS=775000U PD=460000U
* device instance $812 r0 *1 47.66,8.18 nfet_01v8
M$812 67 135 4086 167 nfet_01v8 L=150000U W=140000U AS=21875000000P
+ AD=16800000000P PS=460000U PD=380000U
* device instance $813 r0 *1 47.66,8.57 nfet_01v8
M$813 3893 136 67 167 nfet_01v8 L=150000U W=140000U AS=16800000000P
+ AD=21875000000P PS=380000U PD=460000U
* device instance $814 r0 *1 47.695,8.97 nfet_01v8
M$814 167 4081 3893 167 nfet_01v8 L=150000U W=210000U AS=21875000000P
+ AD=51200000000P PS=460000U PD=775000U
* device instance $815 r0 *1 47.695,9.36 nfet_01v8
M$815 4081 3893 167 167 nfet_01v8 L=150000U W=210000U AS=51200000000P
+ AD=21875000000P PS=775000U PD=460000U
* device instance $816 r0 *1 47.66,9.76 nfet_01v8
M$816 68 136 4081 167 nfet_01v8 L=150000U W=140000U AS=21875000000P
+ AD=16800000000P PS=460000U PD=380000U
* device instance $817 r0 *1 47.66,10.15 nfet_01v8
M$817 3887 137 68 167 nfet_01v8 L=150000U W=140000U AS=16800000000P
+ AD=21875000000P PS=380000U PD=460000U
* device instance $818 r0 *1 47.695,10.55 nfet_01v8
M$818 167 4075 3887 167 nfet_01v8 L=150000U W=210000U AS=21875000000P
+ AD=51200000000P PS=460000U PD=775000U
* device instance $819 r0 *1 47.695,10.94 nfet_01v8
M$819 4075 3887 167 167 nfet_01v8 L=150000U W=210000U AS=51200000000P
+ AD=21875000000P PS=775000U PD=460000U
* device instance $820 r0 *1 47.66,11.34 nfet_01v8
M$820 67 137 4075 167 nfet_01v8 L=150000U W=140000U AS=21875000000P
+ AD=16800000000P PS=460000U PD=380000U
* device instance $821 r0 *1 58.56,5.41 nfet_01v8
M$821 3880 134 83 167 nfet_01v8 L=150000U W=140000U AS=16800000000P
+ AD=21875000000P PS=380000U PD=460000U
* device instance $822 r0 *1 58.595,5.81 nfet_01v8
M$822 167 4068 3880 167 nfet_01v8 L=150000U W=210000U AS=21875000000P
+ AD=51200000000P PS=460000U PD=775000U
* device instance $823 r0 *1 58.595,6.2 nfet_01v8
M$823 4068 3880 167 167 nfet_01v8 L=150000U W=210000U AS=51200000000P
+ AD=21875000000P PS=775000U PD=460000U
* device instance $824 r0 *1 58.56,6.6 nfet_01v8
M$824 84 134 4068 167 nfet_01v8 L=150000U W=140000U AS=21875000000P
+ AD=16800000000P PS=460000U PD=380000U
* device instance $825 r0 *1 58.56,6.99 nfet_01v8
M$825 4315 135 84 167 nfet_01v8 L=150000U W=140000U AS=16800000000P
+ AD=21875000000P PS=380000U PD=460000U
* device instance $826 r0 *1 58.595,7.39 nfet_01v8
M$826 167 3837 4315 167 nfet_01v8 L=150000U W=210000U AS=21875000000P
+ AD=51200000000P PS=460000U PD=775000U
* device instance $827 r0 *1 58.595,7.78 nfet_01v8
M$827 3837 4315 167 167 nfet_01v8 L=150000U W=210000U AS=51200000000P
+ AD=21875000000P PS=775000U PD=460000U
* device instance $828 r0 *1 58.56,8.18 nfet_01v8
M$828 83 135 3837 167 nfet_01v8 L=150000U W=140000U AS=21875000000P
+ AD=16800000000P PS=460000U PD=380000U
* device instance $829 r0 *1 58.56,8.57 nfet_01v8
M$829 3901 136 83 167 nfet_01v8 L=150000U W=140000U AS=16800000000P
+ AD=21875000000P PS=380000U PD=460000U
* device instance $830 r0 *1 58.595,8.97 nfet_01v8
M$830 167 4091 3901 167 nfet_01v8 L=150000U W=210000U AS=21875000000P
+ AD=51200000000P PS=460000U PD=775000U
* device instance $831 r0 *1 58.595,9.36 nfet_01v8
M$831 4091 3901 167 167 nfet_01v8 L=150000U W=210000U AS=51200000000P
+ AD=21875000000P PS=775000U PD=460000U
* device instance $832 r0 *1 58.56,9.76 nfet_01v8
M$832 84 136 4091 167 nfet_01v8 L=150000U W=140000U AS=21875000000P
+ AD=16800000000P PS=460000U PD=380000U
* device instance $833 r0 *1 58.56,10.15 nfet_01v8
M$833 3881 137 84 167 nfet_01v8 L=150000U W=140000U AS=16800000000P
+ AD=21875000000P PS=380000U PD=460000U
* device instance $834 r0 *1 58.595,10.55 nfet_01v8
M$834 167 4069 3881 167 nfet_01v8 L=150000U W=210000U AS=21875000000P
+ AD=51200000000P PS=460000U PD=775000U
* device instance $835 r0 *1 58.595,10.94 nfet_01v8
M$835 4069 3881 167 167 nfet_01v8 L=150000U W=210000U AS=51200000000P
+ AD=21875000000P PS=775000U PD=460000U
* device instance $836 r0 *1 58.56,11.34 nfet_01v8
M$836 83 137 4069 167 nfet_01v8 L=150000U W=140000U AS=21875000000P
+ AD=16800000000P PS=460000U PD=380000U
* device instance $837 r0 *1 69.46,5.41 nfet_01v8
M$837 3949 134 99 167 nfet_01v8 L=150000U W=140000U AS=16800000000P
+ AD=21875000000P PS=380000U PD=460000U
* device instance $838 r0 *1 69.495,5.81 nfet_01v8
M$838 167 4147 3949 167 nfet_01v8 L=150000U W=210000U AS=21875000000P
+ AD=51200000000P PS=460000U PD=775000U
* device instance $839 r0 *1 69.495,6.2 nfet_01v8
M$839 4147 3949 167 167 nfet_01v8 L=150000U W=210000U AS=51200000000P
+ AD=21875000000P PS=775000U PD=460000U
* device instance $840 r0 *1 69.46,6.6 nfet_01v8
M$840 100 134 4147 167 nfet_01v8 L=150000U W=140000U AS=21875000000P
+ AD=16800000000P PS=460000U PD=380000U
* device instance $841 r0 *1 69.46,6.99 nfet_01v8
M$841 4333 135 100 167 nfet_01v8 L=150000U W=140000U AS=16800000000P
+ AD=21875000000P PS=380000U PD=460000U
* device instance $842 r0 *1 69.495,7.39 nfet_01v8
M$842 167 3848 4333 167 nfet_01v8 L=150000U W=210000U AS=21875000000P
+ AD=51200000000P PS=460000U PD=775000U
* device instance $843 r0 *1 69.495,7.78 nfet_01v8
M$843 3848 4333 167 167 nfet_01v8 L=150000U W=210000U AS=51200000000P
+ AD=21875000000P PS=775000U PD=460000U
* device instance $844 r0 *1 69.46,8.18 nfet_01v8
M$844 99 135 3848 167 nfet_01v8 L=150000U W=140000U AS=21875000000P
+ AD=16800000000P PS=460000U PD=380000U
* device instance $845 r0 *1 69.46,8.57 nfet_01v8
M$845 3785 136 99 167 nfet_01v8 L=150000U W=140000U AS=16800000000P
+ AD=21875000000P PS=380000U PD=460000U
* device instance $846 r0 *1 69.495,8.97 nfet_01v8
M$846 167 3854 3785 167 nfet_01v8 L=150000U W=210000U AS=21875000000P
+ AD=51200000000P PS=460000U PD=775000U
* device instance $847 r0 *1 69.495,9.36 nfet_01v8
M$847 3854 3785 167 167 nfet_01v8 L=150000U W=210000U AS=51200000000P
+ AD=21875000000P PS=775000U PD=460000U
* device instance $848 r0 *1 69.46,9.76 nfet_01v8
M$848 100 136 3854 167 nfet_01v8 L=150000U W=140000U AS=21875000000P
+ AD=16800000000P PS=460000U PD=380000U
* device instance $849 r0 *1 69.46,10.15 nfet_01v8
M$849 3931 137 100 167 nfet_01v8 L=150000U W=140000U AS=16800000000P
+ AD=21875000000P PS=380000U PD=460000U
* device instance $850 r0 *1 69.495,10.55 nfet_01v8
M$850 167 4125 3931 167 nfet_01v8 L=150000U W=210000U AS=21875000000P
+ AD=51200000000P PS=460000U PD=775000U
* device instance $851 r0 *1 69.495,10.94 nfet_01v8
M$851 4125 3931 167 167 nfet_01v8 L=150000U W=210000U AS=51200000000P
+ AD=21875000000P PS=775000U PD=460000U
* device instance $852 r0 *1 69.46,11.34 nfet_01v8
M$852 99 137 4125 167 nfet_01v8 L=150000U W=140000U AS=21875000000P
+ AD=16800000000P PS=460000U PD=380000U
* device instance $853 r0 *1 80.36,5.41 nfet_01v8
M$853 4003 134 115 167 nfet_01v8 L=150000U W=140000U AS=16800000000P
+ AD=21875000000P PS=380000U PD=460000U
* device instance $854 r0 *1 80.395,5.81 nfet_01v8
M$854 167 4214 4003 167 nfet_01v8 L=150000U W=210000U AS=21875000000P
+ AD=51200000000P PS=460000U PD=775000U
* device instance $855 r0 *1 80.395,6.2 nfet_01v8
M$855 4214 4003 167 167 nfet_01v8 L=150000U W=210000U AS=51200000000P
+ AD=21875000000P PS=775000U PD=460000U
* device instance $856 r0 *1 80.36,6.6 nfet_01v8
M$856 116 134 4214 167 nfet_01v8 L=150000U W=140000U AS=21875000000P
+ AD=16800000000P PS=460000U PD=380000U
* device instance $857 r0 *1 80.36,6.99 nfet_01v8
M$857 4338 135 116 167 nfet_01v8 L=150000U W=140000U AS=16800000000P
+ AD=21875000000P PS=380000U PD=460000U
* device instance $858 r0 *1 80.395,7.39 nfet_01v8
M$858 167 3838 4338 167 nfet_01v8 L=150000U W=210000U AS=21875000000P
+ AD=51200000000P PS=460000U PD=775000U
* device instance $859 r0 *1 80.395,7.78 nfet_01v8
M$859 3838 4338 167 167 nfet_01v8 L=150000U W=210000U AS=51200000000P
+ AD=21875000000P PS=775000U PD=460000U
* device instance $860 r0 *1 80.36,8.18 nfet_01v8
M$860 115 135 3838 167 nfet_01v8 L=150000U W=140000U AS=21875000000P
+ AD=16800000000P PS=460000U PD=380000U
* device instance $861 r0 *1 80.36,8.57 nfet_01v8
M$861 3780 136 115 167 nfet_01v8 L=150000U W=140000U AS=16800000000P
+ AD=21875000000P PS=380000U PD=460000U
* device instance $862 r0 *1 80.395,8.97 nfet_01v8
M$862 167 3834 3780 167 nfet_01v8 L=150000U W=210000U AS=21875000000P
+ AD=51200000000P PS=460000U PD=775000U
* device instance $863 r0 *1 80.395,9.36 nfet_01v8
M$863 3834 3780 167 167 nfet_01v8 L=150000U W=210000U AS=51200000000P
+ AD=21875000000P PS=775000U PD=460000U
* device instance $864 r0 *1 80.36,9.76 nfet_01v8
M$864 116 136 3834 167 nfet_01v8 L=150000U W=140000U AS=21875000000P
+ AD=16800000000P PS=460000U PD=380000U
* device instance $865 r0 *1 80.36,10.15 nfet_01v8
M$865 4052 137 116 167 nfet_01v8 L=150000U W=140000U AS=16800000000P
+ AD=21875000000P PS=380000U PD=460000U
* device instance $866 r0 *1 80.395,10.55 nfet_01v8
M$866 167 4271 4052 167 nfet_01v8 L=150000U W=210000U AS=21875000000P
+ AD=51200000000P PS=460000U PD=775000U
* device instance $867 r0 *1 80.395,10.94 nfet_01v8
M$867 4271 4052 167 167 nfet_01v8 L=150000U W=210000U AS=51200000000P
+ AD=21875000000P PS=775000U PD=460000U
* device instance $868 r0 *1 80.36,11.34 nfet_01v8
M$868 115 137 4271 167 nfet_01v8 L=150000U W=140000U AS=21875000000P
+ AD=16800000000P PS=460000U PD=380000U
* device instance $869 r0 *1 80.36,13.31 nfet_01v8
M$869 4034 138 115 167 nfet_01v8 L=150000U W=140000U AS=16800000000P
+ AD=21875000000P PS=380000U PD=460000U
* device instance $870 r0 *1 80.395,13.71 nfet_01v8
M$870 167 4249 4034 167 nfet_01v8 L=150000U W=210000U AS=21875000000P
+ AD=51200000000P PS=460000U PD=775000U
* device instance $871 r0 *1 80.395,14.1 nfet_01v8
M$871 4249 4034 167 167 nfet_01v8 L=150000U W=210000U AS=51200000000P
+ AD=21875000000P PS=775000U PD=460000U
* device instance $872 r0 *1 80.36,14.5 nfet_01v8
M$872 116 138 4249 167 nfet_01v8 L=150000U W=140000U AS=21875000000P
+ AD=16800000000P PS=460000U PD=380000U
* device instance $873 r0 *1 80.36,14.89 nfet_01v8
M$873 4318 139 116 167 nfet_01v8 L=150000U W=140000U AS=16800000000P
+ AD=21875000000P PS=380000U PD=460000U
* device instance $874 r0 *1 80.395,15.29 nfet_01v8
M$874 167 3841 4318 167 nfet_01v8 L=150000U W=210000U AS=21875000000P
+ AD=51200000000P PS=460000U PD=775000U
* device instance $875 r0 *1 80.395,15.68 nfet_01v8
M$875 3841 4318 167 167 nfet_01v8 L=150000U W=210000U AS=51200000000P
+ AD=21875000000P PS=775000U PD=460000U
* device instance $876 r0 *1 80.36,16.08 nfet_01v8
M$876 115 139 3841 167 nfet_01v8 L=150000U W=140000U AS=21875000000P
+ AD=16800000000P PS=460000U PD=380000U
* device instance $877 r0 *1 80.36,16.47 nfet_01v8
M$877 3781 140 115 167 nfet_01v8 L=150000U W=140000U AS=16800000000P
+ AD=21875000000P PS=380000U PD=460000U
* device instance $878 r0 *1 80.395,16.87 nfet_01v8
M$878 167 3839 3781 167 nfet_01v8 L=150000U W=210000U AS=21875000000P
+ AD=51200000000P PS=460000U PD=775000U
* device instance $879 r0 *1 80.395,17.26 nfet_01v8
M$879 3839 3781 167 167 nfet_01v8 L=150000U W=210000U AS=51200000000P
+ AD=21875000000P PS=775000U PD=460000U
* device instance $880 r0 *1 80.36,17.66 nfet_01v8
M$880 116 140 3839 167 nfet_01v8 L=150000U W=140000U AS=21875000000P
+ AD=16800000000P PS=460000U PD=380000U
* device instance $881 r0 *1 80.36,18.05 nfet_01v8
M$881 3997 141 116 167 nfet_01v8 L=150000U W=140000U AS=16800000000P
+ AD=21875000000P PS=380000U PD=460000U
* device instance $882 r0 *1 80.395,18.45 nfet_01v8
M$882 167 4206 3997 167 nfet_01v8 L=150000U W=210000U AS=21875000000P
+ AD=51200000000P PS=460000U PD=775000U
* device instance $883 r0 *1 80.395,18.84 nfet_01v8
M$883 4206 3997 167 167 nfet_01v8 L=150000U W=210000U AS=51200000000P
+ AD=21875000000P PS=775000U PD=460000U
* device instance $884 r0 *1 80.36,19.24 nfet_01v8
M$884 115 141 4206 167 nfet_01v8 L=150000U W=140000U AS=21875000000P
+ AD=16800000000P PS=460000U PD=380000U
* device instance $885 r0 *1 14.96,29.11 nfet_01v8
M$885 3906 146 19 167 nfet_01v8 L=150000U W=140000U AS=16800000000P
+ AD=21875000000P PS=380000U PD=460000U
* device instance $886 r0 *1 14.995,29.51 nfet_01v8
M$886 167 4096 3906 167 nfet_01v8 L=150000U W=210000U AS=21875000000P
+ AD=51200000000P PS=460000U PD=775000U
* device instance $887 r0 *1 14.995,29.9 nfet_01v8
M$887 4096 3906 167 167 nfet_01v8 L=150000U W=210000U AS=51200000000P
+ AD=21875000000P PS=775000U PD=460000U
* device instance $888 r0 *1 14.96,30.3 nfet_01v8
M$888 20 146 4096 167 nfet_01v8 L=150000U W=140000U AS=21875000000P
+ AD=16800000000P PS=460000U PD=380000U
* device instance $889 r0 *1 14.96,30.69 nfet_01v8
M$889 4512 147 20 167 nfet_01v8 L=150000U W=140000U AS=16800000000P
+ AD=21875000000P PS=380000U PD=460000U
* device instance $890 r0 *1 14.995,31.09 nfet_01v8
M$890 167 3822 4512 167 nfet_01v8 L=150000U W=210000U AS=21875000000P
+ AD=51200000000P PS=460000U PD=775000U
* device instance $891 r0 *1 14.995,31.48 nfet_01v8
M$891 3822 4512 167 167 nfet_01v8 L=150000U W=210000U AS=51200000000P
+ AD=21875000000P PS=775000U PD=460000U
* device instance $892 r0 *1 14.96,31.88 nfet_01v8
M$892 19 147 3822 167 nfet_01v8 L=150000U W=140000U AS=21875000000P
+ AD=16800000000P PS=460000U PD=380000U
* device instance $893 r0 *1 14.96,32.27 nfet_01v8
M$893 3776 148 19 167 nfet_01v8 L=150000U W=140000U AS=16800000000P
+ AD=21875000000P PS=380000U PD=460000U
* device instance $894 r0 *1 14.995,32.67 nfet_01v8
M$894 167 3827 3776 167 nfet_01v8 L=150000U W=210000U AS=21875000000P
+ AD=51200000000P PS=460000U PD=775000U
* device instance $895 r0 *1 14.995,33.06 nfet_01v8
M$895 3827 3776 167 167 nfet_01v8 L=150000U W=210000U AS=51200000000P
+ AD=21875000000P PS=775000U PD=460000U
* device instance $896 r0 *1 14.96,33.46 nfet_01v8
M$896 20 148 3827 167 nfet_01v8 L=150000U W=140000U AS=21875000000P
+ AD=16800000000P PS=460000U PD=380000U
* device instance $897 r0 *1 14.96,33.85 nfet_01v8
M$897 4046 149 20 167 nfet_01v8 L=150000U W=140000U AS=16800000000P
+ AD=21875000000P PS=380000U PD=460000U
* device instance $898 r0 *1 14.995,34.25 nfet_01v8
M$898 167 4263 4046 167 nfet_01v8 L=150000U W=210000U AS=21875000000P
+ AD=51200000000P PS=460000U PD=775000U
* device instance $899 r0 *1 14.995,34.64 nfet_01v8
M$899 4263 4046 167 167 nfet_01v8 L=150000U W=210000U AS=51200000000P
+ AD=21875000000P PS=775000U PD=460000U
* device instance $900 r0 *1 14.96,35.04 nfet_01v8
M$900 19 149 4263 167 nfet_01v8 L=150000U W=140000U AS=21875000000P
+ AD=16800000000P PS=460000U PD=380000U
* device instance $901 r0 *1 25.86,29.11 nfet_01v8
M$901 3873 146 35 167 nfet_01v8 L=150000U W=140000U AS=16800000000P
+ AD=21875000000P PS=380000U PD=460000U
* device instance $902 r0 *1 25.895,29.51 nfet_01v8
M$902 167 4061 3873 167 nfet_01v8 L=150000U W=210000U AS=21875000000P
+ AD=51200000000P PS=460000U PD=775000U
* device instance $903 r0 *1 25.895,29.9 nfet_01v8
M$903 4061 3873 167 167 nfet_01v8 L=150000U W=210000U AS=51200000000P
+ AD=21875000000P PS=775000U PD=460000U
* device instance $904 r0 *1 25.86,30.3 nfet_01v8
M$904 36 146 4061 167 nfet_01v8 L=150000U W=140000U AS=21875000000P
+ AD=16800000000P PS=460000U PD=380000U
* device instance $905 r0 *1 25.86,30.69 nfet_01v8
M$905 4418 147 36 167 nfet_01v8 L=150000U W=140000U AS=16800000000P
+ AD=21875000000P PS=380000U PD=460000U
* device instance $906 r0 *1 25.895,31.09 nfet_01v8
M$906 167 3870 4418 167 nfet_01v8 L=150000U W=210000U AS=21875000000P
+ AD=51200000000P PS=460000U PD=775000U
* device instance $907 r0 *1 25.895,31.48 nfet_01v8
M$907 3870 4418 167 167 nfet_01v8 L=150000U W=210000U AS=51200000000P
+ AD=21875000000P PS=775000U PD=460000U
* device instance $908 r0 *1 25.86,31.88 nfet_01v8
M$908 35 147 3870 167 nfet_01v8 L=150000U W=140000U AS=21875000000P
+ AD=16800000000P PS=460000U PD=380000U
* device instance $909 r0 *1 25.86,32.27 nfet_01v8
M$909 3789 148 35 167 nfet_01v8 L=150000U W=140000U AS=16800000000P
+ AD=21875000000P PS=380000U PD=460000U
* device instance $910 r0 *1 25.895,32.67 nfet_01v8
M$910 167 3863 3789 167 nfet_01v8 L=150000U W=210000U AS=21875000000P
+ AD=51200000000P PS=460000U PD=775000U
* device instance $911 r0 *1 25.895,33.06 nfet_01v8
M$911 3863 3789 167 167 nfet_01v8 L=150000U W=210000U AS=51200000000P
+ AD=21875000000P PS=775000U PD=460000U
* device instance $912 r0 *1 25.86,33.46 nfet_01v8
M$912 36 148 3863 167 nfet_01v8 L=150000U W=140000U AS=21875000000P
+ AD=16800000000P PS=460000U PD=380000U
* device instance $913 r0 *1 25.86,33.85 nfet_01v8
M$913 3879 149 36 167 nfet_01v8 L=150000U W=140000U AS=16800000000P
+ AD=21875000000P PS=380000U PD=460000U
* device instance $914 r0 *1 25.895,34.25 nfet_01v8
M$914 167 4067 3879 167 nfet_01v8 L=150000U W=210000U AS=21875000000P
+ AD=51200000000P PS=460000U PD=775000U
* device instance $915 r0 *1 25.895,34.64 nfet_01v8
M$915 4067 3879 167 167 nfet_01v8 L=150000U W=210000U AS=51200000000P
+ AD=21875000000P PS=775000U PD=460000U
* device instance $916 r0 *1 25.86,35.04 nfet_01v8
M$916 35 149 4067 167 nfet_01v8 L=150000U W=140000U AS=21875000000P
+ AD=16800000000P PS=460000U PD=380000U
* device instance $917 r0 *1 36.76,29.11 nfet_01v8
M$917 3904 146 51 167 nfet_01v8 L=150000U W=140000U AS=16800000000P
+ AD=21875000000P PS=380000U PD=460000U
* device instance $918 r0 *1 36.795,29.51 nfet_01v8
M$918 167 4094 3904 167 nfet_01v8 L=150000U W=210000U AS=21875000000P
+ AD=51200000000P PS=460000U PD=775000U
* device instance $919 r0 *1 36.795,29.9 nfet_01v8
M$919 4094 3904 167 167 nfet_01v8 L=150000U W=210000U AS=51200000000P
+ AD=21875000000P PS=775000U PD=460000U
* device instance $920 r0 *1 36.76,30.3 nfet_01v8
M$920 52 146 4094 167 nfet_01v8 L=150000U W=140000U AS=21875000000P
+ AD=16800000000P PS=460000U PD=380000U
* device instance $921 r0 *1 36.76,30.69 nfet_01v8
M$921 4412 147 52 167 nfet_01v8 L=150000U W=140000U AS=16800000000P
+ AD=21875000000P PS=380000U PD=460000U
* device instance $922 r0 *1 36.795,31.09 nfet_01v8
M$922 167 3852 4412 167 nfet_01v8 L=150000U W=210000U AS=21875000000P
+ AD=51200000000P PS=460000U PD=775000U
* device instance $923 r0 *1 36.795,31.48 nfet_01v8
M$923 3852 4412 167 167 nfet_01v8 L=150000U W=210000U AS=51200000000P
+ AD=21875000000P PS=775000U PD=460000U
* device instance $924 r0 *1 36.76,31.88 nfet_01v8
M$924 51 147 3852 167 nfet_01v8 L=150000U W=140000U AS=21875000000P
+ AD=16800000000P PS=460000U PD=380000U
* device instance $925 r0 *1 36.76,32.27 nfet_01v8
M$925 3782 148 51 167 nfet_01v8 L=150000U W=140000U AS=16800000000P
+ AD=21875000000P PS=380000U PD=460000U
* device instance $926 r0 *1 36.795,32.67 nfet_01v8
M$926 167 3842 3782 167 nfet_01v8 L=150000U W=210000U AS=21875000000P
+ AD=51200000000P PS=460000U PD=775000U
* device instance $927 r0 *1 36.795,33.06 nfet_01v8
M$927 3842 3782 167 167 nfet_01v8 L=150000U W=210000U AS=51200000000P
+ AD=21875000000P PS=775000U PD=460000U
* device instance $928 r0 *1 36.76,33.46 nfet_01v8
M$928 52 148 3842 167 nfet_01v8 L=150000U W=140000U AS=21875000000P
+ AD=16800000000P PS=460000U PD=380000U
* device instance $929 r0 *1 36.76,33.85 nfet_01v8
M$929 3895 149 52 167 nfet_01v8 L=150000U W=140000U AS=16800000000P
+ AD=21875000000P PS=380000U PD=460000U
* device instance $930 r0 *1 36.795,34.25 nfet_01v8
M$930 167 4083 3895 167 nfet_01v8 L=150000U W=210000U AS=21875000000P
+ AD=51200000000P PS=460000U PD=775000U
* device instance $931 r0 *1 36.795,34.64 nfet_01v8
M$931 4083 3895 167 167 nfet_01v8 L=150000U W=210000U AS=51200000000P
+ AD=21875000000P PS=775000U PD=460000U
* device instance $932 r0 *1 36.76,35.04 nfet_01v8
M$932 51 149 4083 167 nfet_01v8 L=150000U W=140000U AS=21875000000P
+ AD=16800000000P PS=460000U PD=380000U
* device instance $933 r0 *1 47.66,29.11 nfet_01v8
M$933 3989 146 67 167 nfet_01v8 L=150000U W=140000U AS=16800000000P
+ AD=21875000000P PS=380000U PD=460000U
* device instance $934 r0 *1 47.695,29.51 nfet_01v8
M$934 167 4196 3989 167 nfet_01v8 L=150000U W=210000U AS=21875000000P
+ AD=51200000000P PS=460000U PD=775000U
* device instance $935 r0 *1 47.695,29.9 nfet_01v8
M$935 4196 3989 167 167 nfet_01v8 L=150000U W=210000U AS=51200000000P
+ AD=21875000000P PS=775000U PD=460000U
* device instance $936 r0 *1 47.66,30.3 nfet_01v8
M$936 68 146 4196 167 nfet_01v8 L=150000U W=140000U AS=21875000000P
+ AD=16800000000P PS=460000U PD=380000U
* device instance $937 r0 *1 47.66,30.69 nfet_01v8
M$937 4359 147 68 167 nfet_01v8 L=150000U W=140000U AS=16800000000P
+ AD=21875000000P PS=380000U PD=460000U
* device instance $938 r0 *1 47.695,31.09 nfet_01v8
M$938 167 4195 4359 167 nfet_01v8 L=150000U W=210000U AS=21875000000P
+ AD=51200000000P PS=460000U PD=775000U
* device instance $939 r0 *1 47.695,31.48 nfet_01v8
M$939 4195 4359 167 167 nfet_01v8 L=150000U W=210000U AS=51200000000P
+ AD=21875000000P PS=775000U PD=460000U
* device instance $940 r0 *1 47.66,31.88 nfet_01v8
M$940 67 147 4195 167 nfet_01v8 L=150000U W=140000U AS=21875000000P
+ AD=16800000000P PS=460000U PD=380000U
* device instance $941 r0 *1 47.66,32.27 nfet_01v8
M$941 3758 148 67 167 nfet_01v8 L=150000U W=140000U AS=16800000000P
+ AD=21875000000P PS=380000U PD=460000U
* device instance $942 r0 *1 47.695,32.67 nfet_01v8
M$942 167 3799 3758 167 nfet_01v8 L=150000U W=210000U AS=21875000000P
+ AD=51200000000P PS=460000U PD=775000U
* device instance $943 r0 *1 47.695,33.06 nfet_01v8
M$943 3799 3758 167 167 nfet_01v8 L=150000U W=210000U AS=51200000000P
+ AD=21875000000P PS=775000U PD=460000U
* device instance $944 r0 *1 47.66,33.46 nfet_01v8
M$944 68 148 3799 167 nfet_01v8 L=150000U W=140000U AS=21875000000P
+ AD=16800000000P PS=460000U PD=380000U
* device instance $945 r0 *1 47.66,33.85 nfet_01v8
M$945 3991 149 68 167 nfet_01v8 L=150000U W=140000U AS=16800000000P
+ AD=21875000000P PS=380000U PD=460000U
* device instance $946 r0 *1 47.695,34.25 nfet_01v8
M$946 167 4198 3991 167 nfet_01v8 L=150000U W=210000U AS=21875000000P
+ AD=51200000000P PS=460000U PD=775000U
* device instance $947 r0 *1 47.695,34.64 nfet_01v8
M$947 4198 3991 167 167 nfet_01v8 L=150000U W=210000U AS=51200000000P
+ AD=21875000000P PS=775000U PD=460000U
* device instance $948 r0 *1 47.66,35.04 nfet_01v8
M$948 67 149 4198 167 nfet_01v8 L=150000U W=140000U AS=21875000000P
+ AD=16800000000P PS=460000U PD=380000U
* device instance $949 r0 *1 58.56,29.11 nfet_01v8
M$949 3975 146 83 167 nfet_01v8 L=150000U W=140000U AS=16800000000P
+ AD=21875000000P PS=380000U PD=460000U
* device instance $950 r0 *1 58.595,29.51 nfet_01v8
M$950 167 4180 3975 167 nfet_01v8 L=150000U W=210000U AS=21875000000P
+ AD=51200000000P PS=460000U PD=775000U
* device instance $951 r0 *1 58.595,29.9 nfet_01v8
M$951 4180 3975 167 167 nfet_01v8 L=150000U W=210000U AS=51200000000P
+ AD=21875000000P PS=775000U PD=460000U
* device instance $952 r0 *1 58.56,30.3 nfet_01v8
M$952 84 146 4180 167 nfet_01v8 L=150000U W=140000U AS=21875000000P
+ AD=16800000000P PS=460000U PD=380000U
* device instance $953 r0 *1 58.56,30.69 nfet_01v8
M$953 4351 147 84 167 nfet_01v8 L=150000U W=140000U AS=16800000000P
+ AD=21875000000P PS=380000U PD=460000U
* device instance $954 r0 *1 58.595,31.09 nfet_01v8
M$954 167 4179 4351 167 nfet_01v8 L=150000U W=210000U AS=21875000000P
+ AD=51200000000P PS=460000U PD=775000U
* device instance $955 r0 *1 58.595,31.48 nfet_01v8
M$955 4179 4351 167 167 nfet_01v8 L=150000U W=210000U AS=51200000000P
+ AD=21875000000P PS=775000U PD=460000U
* device instance $956 r0 *1 58.56,31.88 nfet_01v8
M$956 83 147 4179 167 nfet_01v8 L=150000U W=140000U AS=21875000000P
+ AD=16800000000P PS=460000U PD=380000U
* device instance $957 r0 *1 58.56,32.27 nfet_01v8
M$957 3979 148 83 167 nfet_01v8 L=150000U W=140000U AS=16800000000P
+ AD=21875000000P PS=380000U PD=460000U
* device instance $958 r0 *1 58.595,32.67 nfet_01v8
M$958 167 4185 3979 167 nfet_01v8 L=150000U W=210000U AS=21875000000P
+ AD=51200000000P PS=460000U PD=775000U
* device instance $959 r0 *1 58.595,33.06 nfet_01v8
M$959 4185 3979 167 167 nfet_01v8 L=150000U W=210000U AS=51200000000P
+ AD=21875000000P PS=775000U PD=460000U
* device instance $960 r0 *1 58.56,33.46 nfet_01v8
M$960 84 148 4185 167 nfet_01v8 L=150000U W=140000U AS=21875000000P
+ AD=16800000000P PS=460000U PD=380000U
* device instance $961 r0 *1 58.56,33.85 nfet_01v8
M$961 3977 149 84 167 nfet_01v8 L=150000U W=140000U AS=16800000000P
+ AD=21875000000P PS=380000U PD=460000U
* device instance $962 r0 *1 58.595,34.25 nfet_01v8
M$962 167 4183 3977 167 nfet_01v8 L=150000U W=210000U AS=21875000000P
+ AD=51200000000P PS=460000U PD=775000U
* device instance $963 r0 *1 58.595,34.64 nfet_01v8
M$963 4183 3977 167 167 nfet_01v8 L=150000U W=210000U AS=51200000000P
+ AD=21875000000P PS=775000U PD=460000U
* device instance $964 r0 *1 58.56,35.04 nfet_01v8
M$964 83 149 4183 167 nfet_01v8 L=150000U W=140000U AS=21875000000P
+ AD=16800000000P PS=460000U PD=380000U
* device instance $965 r0 *1 69.46,29.11 nfet_01v8
M$965 3941 146 99 167 nfet_01v8 L=150000U W=140000U AS=16800000000P
+ AD=21875000000P PS=380000U PD=460000U
* device instance $966 r0 *1 69.495,29.51 nfet_01v8
M$966 167 4138 3941 167 nfet_01v8 L=150000U W=210000U AS=21875000000P
+ AD=51200000000P PS=460000U PD=775000U
* device instance $967 r0 *1 69.495,29.9 nfet_01v8
M$967 4138 3941 167 167 nfet_01v8 L=150000U W=210000U AS=51200000000P
+ AD=21875000000P PS=775000U PD=460000U
* device instance $968 r0 *1 69.46,30.3 nfet_01v8
M$968 100 146 4138 167 nfet_01v8 L=150000U W=140000U AS=21875000000P
+ AD=16800000000P PS=460000U PD=380000U
* device instance $969 r0 *1 69.46,30.69 nfet_01v8
M$969 4301 147 100 167 nfet_01v8 L=150000U W=140000U AS=16800000000P
+ AD=21875000000P PS=380000U PD=460000U
* device instance $970 r0 *1 69.495,31.09 nfet_01v8
M$970 167 4139 4301 167 nfet_01v8 L=150000U W=210000U AS=21875000000P
+ AD=51200000000P PS=460000U PD=775000U
* device instance $971 r0 *1 69.495,31.48 nfet_01v8
M$971 4139 4301 167 167 nfet_01v8 L=150000U W=210000U AS=51200000000P
+ AD=21875000000P PS=775000U PD=460000U
* device instance $972 r0 *1 69.46,31.88 nfet_01v8
M$972 99 147 4139 167 nfet_01v8 L=150000U W=140000U AS=21875000000P
+ AD=16800000000P PS=460000U PD=380000U
* device instance $973 r0 *1 69.46,32.27 nfet_01v8
M$973 3783 148 99 167 nfet_01v8 L=150000U W=140000U AS=16800000000P
+ AD=21875000000P PS=380000U PD=460000U
* device instance $974 r0 *1 69.495,32.67 nfet_01v8
M$974 167 3843 3783 167 nfet_01v8 L=150000U W=210000U AS=21875000000P
+ AD=51200000000P PS=460000U PD=775000U
* device instance $975 r0 *1 69.495,33.06 nfet_01v8
M$975 3843 3783 167 167 nfet_01v8 L=150000U W=210000U AS=51200000000P
+ AD=21875000000P PS=775000U PD=460000U
* device instance $976 r0 *1 69.46,33.46 nfet_01v8
M$976 100 148 3843 167 nfet_01v8 L=150000U W=140000U AS=21875000000P
+ AD=16800000000P PS=460000U PD=380000U
* device instance $977 r0 *1 69.46,33.85 nfet_01v8
M$977 3942 149 100 167 nfet_01v8 L=150000U W=140000U AS=16800000000P
+ AD=21875000000P PS=380000U PD=460000U
* device instance $978 r0 *1 69.495,34.25 nfet_01v8
M$978 167 4140 3942 167 nfet_01v8 L=150000U W=210000U AS=21875000000P
+ AD=51200000000P PS=460000U PD=775000U
* device instance $979 r0 *1 69.495,34.64 nfet_01v8
M$979 4140 3942 167 167 nfet_01v8 L=150000U W=210000U AS=51200000000P
+ AD=21875000000P PS=775000U PD=460000U
* device instance $980 r0 *1 69.46,35.04 nfet_01v8
M$980 99 149 4140 167 nfet_01v8 L=150000U W=140000U AS=21875000000P
+ AD=16800000000P PS=460000U PD=380000U
* device instance $981 r0 *1 80.36,29.11 nfet_01v8
M$981 3932 146 115 167 nfet_01v8 L=150000U W=140000U AS=16800000000P
+ AD=21875000000P PS=380000U PD=460000U
* device instance $982 r0 *1 80.395,29.51 nfet_01v8
M$982 167 4126 3932 167 nfet_01v8 L=150000U W=210000U AS=21875000000P
+ AD=51200000000P PS=460000U PD=775000U
* device instance $983 r0 *1 80.395,29.9 nfet_01v8
M$983 4126 3932 167 167 nfet_01v8 L=150000U W=210000U AS=51200000000P
+ AD=21875000000P PS=775000U PD=460000U
* device instance $984 r0 *1 80.36,30.3 nfet_01v8
M$984 116 146 4126 167 nfet_01v8 L=150000U W=140000U AS=21875000000P
+ AD=16800000000P PS=460000U PD=380000U
* device instance $985 r0 *1 80.36,30.69 nfet_01v8
M$985 4306 147 116 167 nfet_01v8 L=150000U W=140000U AS=16800000000P
+ AD=21875000000P PS=380000U PD=460000U
* device instance $986 r0 *1 80.395,31.09 nfet_01v8
M$986 167 4127 4306 167 nfet_01v8 L=150000U W=210000U AS=21875000000P
+ AD=51200000000P PS=460000U PD=775000U
* device instance $987 r0 *1 80.395,31.48 nfet_01v8
M$987 4127 4306 167 167 nfet_01v8 L=150000U W=210000U AS=51200000000P
+ AD=21875000000P PS=775000U PD=460000U
* device instance $988 r0 *1 80.36,31.88 nfet_01v8
M$988 115 147 4127 167 nfet_01v8 L=150000U W=140000U AS=21875000000P
+ AD=16800000000P PS=460000U PD=380000U
* device instance $989 r0 *1 80.36,32.27 nfet_01v8
M$989 3786 148 115 167 nfet_01v8 L=150000U W=140000U AS=16800000000P
+ AD=21875000000P PS=380000U PD=460000U
* device instance $990 r0 *1 80.395,32.67 nfet_01v8
M$990 167 3855 3786 167 nfet_01v8 L=150000U W=210000U AS=21875000000P
+ AD=51200000000P PS=460000U PD=775000U
* device instance $991 r0 *1 80.395,33.06 nfet_01v8
M$991 3855 3786 167 167 nfet_01v8 L=150000U W=210000U AS=51200000000P
+ AD=21875000000P PS=775000U PD=460000U
* device instance $992 r0 *1 80.36,33.46 nfet_01v8
M$992 116 148 3855 167 nfet_01v8 L=150000U W=140000U AS=21875000000P
+ AD=16800000000P PS=460000U PD=380000U
* device instance $993 r0 *1 80.36,33.85 nfet_01v8
M$993 3933 149 116 167 nfet_01v8 L=150000U W=140000U AS=16800000000P
+ AD=21875000000P PS=380000U PD=460000U
* device instance $994 r0 *1 80.395,34.25 nfet_01v8
M$994 167 4128 3933 167 nfet_01v8 L=150000U W=210000U AS=21875000000P
+ AD=51200000000P PS=460000U PD=775000U
* device instance $995 r0 *1 80.395,34.64 nfet_01v8
M$995 4128 3933 167 167 nfet_01v8 L=150000U W=210000U AS=51200000000P
+ AD=21875000000P PS=775000U PD=460000U
* device instance $996 r0 *1 80.36,35.04 nfet_01v8
M$996 115 149 4128 167 nfet_01v8 L=150000U W=140000U AS=21875000000P
+ AD=16800000000P PS=460000U PD=380000U
* device instance $997 r0 *1 14.96,60.71 nfet_01v8
M$997 3970 162 19 167 nfet_01v8 L=150000U W=140000U AS=16800000000P
+ AD=21875000000P PS=380000U PD=460000U
* device instance $998 r0 *1 14.995,61.11 nfet_01v8
M$998 167 4172 3970 167 nfet_01v8 L=150000U W=210000U AS=21875000000P
+ AD=51200000000P PS=460000U PD=775000U
* device instance $999 r0 *1 14.995,61.5 nfet_01v8
M$999 4172 3970 167 167 nfet_01v8 L=150000U W=210000U AS=51200000000P
+ AD=21875000000P PS=775000U PD=460000U
* device instance $1000 r0 *1 14.96,61.9 nfet_01v8
M$1000 20 162 4172 167 nfet_01v8 L=150000U W=140000U AS=21875000000P
+ AD=16800000000P PS=460000U PD=380000U
* device instance $1001 r0 *1 14.96,62.29 nfet_01v8
M$1001 4448 163 20 167 nfet_01v8 L=150000U W=140000U AS=16800000000P
+ AD=21875000000P PS=380000U PD=460000U
* device instance $1002 r0 *1 14.995,62.69 nfet_01v8
M$1002 167 3828 4448 167 nfet_01v8 L=150000U W=210000U AS=21875000000P
+ AD=51200000000P PS=460000U PD=775000U
* device instance $1003 r0 *1 14.995,63.08 nfet_01v8
M$1003 3828 4448 167 167 nfet_01v8 L=150000U W=210000U AS=51200000000P
+ AD=21875000000P PS=775000U PD=460000U
* device instance $1004 r0 *1 14.96,63.48 nfet_01v8
M$1004 19 163 3828 167 nfet_01v8 L=150000U W=140000U AS=21875000000P
+ AD=16800000000P PS=460000U PD=380000U
* device instance $1005 r0 *1 14.96,63.87 nfet_01v8
M$1005 3773 164 19 167 nfet_01v8 L=150000U W=140000U AS=16800000000P
+ AD=21875000000P PS=380000U PD=460000U
* device instance $1006 r0 *1 14.995,64.27 nfet_01v8
M$1006 167 3821 3773 167 nfet_01v8 L=150000U W=210000U AS=21875000000P
+ AD=51200000000P PS=460000U PD=775000U
* device instance $1007 r0 *1 14.995,64.66 nfet_01v8
M$1007 3821 3773 167 167 nfet_01v8 L=150000U W=210000U AS=51200000000P
+ AD=21875000000P PS=775000U PD=460000U
* device instance $1008 r0 *1 14.96,65.06 nfet_01v8
M$1008 20 164 3821 167 nfet_01v8 L=150000U W=140000U AS=21875000000P
+ AD=16800000000P PS=460000U PD=380000U
* device instance $1009 r0 *1 14.96,65.45 nfet_01v8
M$1009 3890 165 20 167 nfet_01v8 L=150000U W=140000U AS=16800000000P
+ AD=21875000000P PS=380000U PD=460000U
* device instance $1010 r0 *1 14.995,65.85 nfet_01v8
M$1010 167 4078 3890 167 nfet_01v8 L=150000U W=210000U AS=21875000000P
+ AD=51200000000P PS=460000U PD=775000U
* device instance $1011 r0 *1 14.995,66.24 nfet_01v8
M$1011 4078 3890 167 167 nfet_01v8 L=150000U W=210000U AS=51200000000P
+ AD=21875000000P PS=775000U PD=460000U
* device instance $1012 r0 *1 14.96,66.64 nfet_01v8
M$1012 19 165 4078 167 nfet_01v8 L=150000U W=140000U AS=21875000000P
+ AD=16800000000P PS=460000U PD=380000U
* device instance $1013 r0 *1 4.06,21.21 nfet_01v8
M$1013 3951 142 3 167 nfet_01v8 L=150000U W=140000U AS=16800000000P
+ AD=21875000000P PS=380000U PD=460000U
* device instance $1014 r0 *1 4.095,21.61 nfet_01v8
M$1014 167 4149 3951 167 nfet_01v8 L=150000U W=210000U AS=21875000000P
+ AD=51200000000P PS=460000U PD=775000U
* device instance $1015 r0 *1 4.095,22 nfet_01v8
M$1015 4149 3951 167 167 nfet_01v8 L=150000U W=210000U AS=51200000000P
+ AD=21875000000P PS=775000U PD=460000U
* device instance $1016 r0 *1 4.06,22.4 nfet_01v8
M$1016 4 142 4149 167 nfet_01v8 L=150000U W=140000U AS=21875000000P
+ AD=16800000000P PS=460000U PD=380000U
* device instance $1017 r0 *1 4.06,22.79 nfet_01v8
M$1017 4533 143 4 167 nfet_01v8 L=150000U W=140000U AS=16800000000P
+ AD=21875000000P PS=380000U PD=460000U
* device instance $1018 r0 *1 4.095,23.19 nfet_01v8
M$1018 167 3816 4533 167 nfet_01v8 L=150000U W=210000U AS=21875000000P
+ AD=51200000000P PS=460000U PD=775000U
* device instance $1019 r0 *1 4.095,23.58 nfet_01v8
M$1019 3816 4533 167 167 nfet_01v8 L=150000U W=210000U AS=51200000000P
+ AD=21875000000P PS=775000U PD=460000U
* device instance $1020 r0 *1 4.06,23.98 nfet_01v8
M$1020 3 143 3816 167 nfet_01v8 L=150000U W=140000U AS=21875000000P
+ AD=16800000000P PS=460000U PD=380000U
* device instance $1021 r0 *1 4.06,24.37 nfet_01v8
M$1021 3950 144 3 167 nfet_01v8 L=150000U W=140000U AS=16800000000P
+ AD=21875000000P PS=380000U PD=460000U
* device instance $1022 r0 *1 4.095,24.77 nfet_01v8
M$1022 167 4148 3950 167 nfet_01v8 L=150000U W=210000U AS=21875000000P
+ AD=51200000000P PS=460000U PD=775000U
* device instance $1023 r0 *1 4.095,25.16 nfet_01v8
M$1023 4148 3950 167 167 nfet_01v8 L=150000U W=210000U AS=51200000000P
+ AD=21875000000P PS=775000U PD=460000U
* device instance $1024 r0 *1 4.06,25.56 nfet_01v8
M$1024 4 144 4148 167 nfet_01v8 L=150000U W=140000U AS=21875000000P
+ AD=16800000000P PS=460000U PD=380000U
* device instance $1025 r0 *1 4.06,25.95 nfet_01v8
M$1025 3973 145 4 167 nfet_01v8 L=150000U W=140000U AS=16800000000P
+ AD=21875000000P PS=380000U PD=460000U
* device instance $1026 r0 *1 4.095,26.35 nfet_01v8
M$1026 167 4175 3973 167 nfet_01v8 L=150000U W=210000U AS=21875000000P
+ AD=51200000000P PS=460000U PD=775000U
* device instance $1027 r0 *1 4.095,26.74 nfet_01v8
M$1027 4175 3973 167 167 nfet_01v8 L=150000U W=210000U AS=51200000000P
+ AD=21875000000P PS=775000U PD=460000U
* device instance $1028 r0 *1 4.06,27.14 nfet_01v8
M$1028 3 145 4175 167 nfet_01v8 L=150000U W=140000U AS=21875000000P
+ AD=16800000000P PS=460000U PD=380000U
* device instance $1029 r0 *1 14.96,21.21 nfet_01v8
M$1029 3962 142 19 167 nfet_01v8 L=150000U W=140000U AS=16800000000P
+ AD=21875000000P PS=380000U PD=460000U
* device instance $1030 r0 *1 14.995,21.61 nfet_01v8
M$1030 167 4162 3962 167 nfet_01v8 L=150000U W=210000U AS=21875000000P
+ AD=51200000000P PS=460000U PD=775000U
* device instance $1031 r0 *1 14.995,22 nfet_01v8
M$1031 4162 3962 167 167 nfet_01v8 L=150000U W=210000U AS=51200000000P
+ AD=21875000000P PS=775000U PD=460000U
* device instance $1032 r0 *1 14.96,22.4 nfet_01v8
M$1032 20 142 4162 167 nfet_01v8 L=150000U W=140000U AS=21875000000P
+ AD=16800000000P PS=460000U PD=380000U
* device instance $1033 r0 *1 14.96,22.79 nfet_01v8
M$1033 4480 143 20 167 nfet_01v8 L=150000U W=140000U AS=16800000000P
+ AD=21875000000P PS=380000U PD=460000U
* device instance $1034 r0 *1 14.995,23.19 nfet_01v8
M$1034 167 4150 4480 167 nfet_01v8 L=150000U W=210000U AS=21875000000P
+ AD=51200000000P PS=460000U PD=775000U
* device instance $1035 r0 *1 14.995,23.58 nfet_01v8
M$1035 4150 4480 167 167 nfet_01v8 L=150000U W=210000U AS=51200000000P
+ AD=21875000000P PS=775000U PD=460000U
* device instance $1036 r0 *1 14.96,23.98 nfet_01v8
M$1036 19 143 4150 167 nfet_01v8 L=150000U W=140000U AS=21875000000P
+ AD=16800000000P PS=460000U PD=380000U
* device instance $1037 r0 *1 14.96,24.37 nfet_01v8
M$1037 3775 144 19 167 nfet_01v8 L=150000U W=140000U AS=16800000000P
+ AD=21875000000P PS=380000U PD=460000U
* device instance $1038 r0 *1 14.995,24.77 nfet_01v8
M$1038 167 3825 3775 167 nfet_01v8 L=150000U W=210000U AS=21875000000P
+ AD=51200000000P PS=460000U PD=775000U
* device instance $1039 r0 *1 14.995,25.16 nfet_01v8
M$1039 3825 3775 167 167 nfet_01v8 L=150000U W=210000U AS=51200000000P
+ AD=21875000000P PS=775000U PD=460000U
* device instance $1040 r0 *1 14.96,25.56 nfet_01v8
M$1040 20 144 3825 167 nfet_01v8 L=150000U W=140000U AS=21875000000P
+ AD=16800000000P PS=460000U PD=380000U
* device instance $1041 r0 *1 14.96,25.95 nfet_01v8
M$1041 3953 145 20 167 nfet_01v8 L=150000U W=140000U AS=16800000000P
+ AD=21875000000P PS=380000U PD=460000U
* device instance $1042 r0 *1 14.995,26.35 nfet_01v8
M$1042 167 4152 3953 167 nfet_01v8 L=150000U W=210000U AS=21875000000P
+ AD=51200000000P PS=460000U PD=775000U
* device instance $1043 r0 *1 14.995,26.74 nfet_01v8
M$1043 4152 3953 167 167 nfet_01v8 L=150000U W=210000U AS=51200000000P
+ AD=21875000000P PS=775000U PD=460000U
* device instance $1044 r0 *1 14.96,27.14 nfet_01v8
M$1044 19 145 4152 167 nfet_01v8 L=150000U W=140000U AS=21875000000P
+ AD=16800000000P PS=460000U PD=380000U
* device instance $1045 r0 *1 25.86,21.21 nfet_01v8
M$1045 3889 142 35 167 nfet_01v8 L=150000U W=140000U AS=16800000000P
+ AD=21875000000P PS=380000U PD=460000U
* device instance $1046 r0 *1 25.895,21.61 nfet_01v8
M$1046 167 4077 3889 167 nfet_01v8 L=150000U W=210000U AS=21875000000P
+ AD=51200000000P PS=460000U PD=775000U
* device instance $1047 r0 *1 25.895,22 nfet_01v8
M$1047 4077 3889 167 167 nfet_01v8 L=150000U W=210000U AS=51200000000P
+ AD=21875000000P PS=775000U PD=460000U
* device instance $1048 r0 *1 25.86,22.4 nfet_01v8
M$1048 36 142 4077 167 nfet_01v8 L=150000U W=140000U AS=21875000000P
+ AD=16800000000P PS=460000U PD=380000U
* device instance $1049 r0 *1 25.86,22.79 nfet_01v8
M$1049 4520 143 36 167 nfet_01v8 L=150000U W=140000U AS=16800000000P
+ AD=21875000000P PS=380000U PD=460000U
* device instance $1050 r0 *1 25.895,23.19 nfet_01v8
M$1050 167 3805 4520 167 nfet_01v8 L=150000U W=210000U AS=21875000000P
+ AD=51200000000P PS=460000U PD=775000U
* device instance $1051 r0 *1 25.895,23.58 nfet_01v8
M$1051 3805 4520 167 167 nfet_01v8 L=150000U W=210000U AS=51200000000P
+ AD=21875000000P PS=775000U PD=460000U
* device instance $1052 r0 *1 25.86,23.98 nfet_01v8
M$1052 35 143 3805 167 nfet_01v8 L=150000U W=140000U AS=21875000000P
+ AD=16800000000P PS=460000U PD=380000U
* device instance $1053 r0 *1 25.86,24.37 nfet_01v8
M$1053 3899 144 35 167 nfet_01v8 L=150000U W=140000U AS=16800000000P
+ AD=21875000000P PS=380000U PD=460000U
* device instance $1054 r0 *1 25.895,24.77 nfet_01v8
M$1054 167 4088 3899 167 nfet_01v8 L=150000U W=210000U AS=21875000000P
+ AD=51200000000P PS=460000U PD=775000U
* device instance $1055 r0 *1 25.895,25.16 nfet_01v8
M$1055 4088 3899 167 167 nfet_01v8 L=150000U W=210000U AS=51200000000P
+ AD=21875000000P PS=775000U PD=460000U
* device instance $1056 r0 *1 25.86,25.56 nfet_01v8
M$1056 36 144 4088 167 nfet_01v8 L=150000U W=140000U AS=21875000000P
+ AD=16800000000P PS=460000U PD=380000U
* device instance $1057 r0 *1 25.86,25.95 nfet_01v8
M$1057 3897 145 36 167 nfet_01v8 L=150000U W=140000U AS=16800000000P
+ AD=21875000000P PS=380000U PD=460000U
* device instance $1058 r0 *1 25.895,26.35 nfet_01v8
M$1058 167 4085 3897 167 nfet_01v8 L=150000U W=210000U AS=21875000000P
+ AD=51200000000P PS=460000U PD=775000U
* device instance $1059 r0 *1 25.895,26.74 nfet_01v8
M$1059 4085 3897 167 167 nfet_01v8 L=150000U W=210000U AS=51200000000P
+ AD=21875000000P PS=775000U PD=460000U
* device instance $1060 r0 *1 25.86,27.14 nfet_01v8
M$1060 35 145 4085 167 nfet_01v8 L=150000U W=140000U AS=21875000000P
+ AD=16800000000P PS=460000U PD=380000U
* device instance $1061 r0 *1 36.76,21.21 nfet_01v8
M$1061 3883 142 51 167 nfet_01v8 L=150000U W=140000U AS=16800000000P
+ AD=21875000000P PS=380000U PD=460000U
* device instance $1062 r0 *1 36.795,21.61 nfet_01v8
M$1062 167 4071 3883 167 nfet_01v8 L=150000U W=210000U AS=21875000000P
+ AD=51200000000P PS=460000U PD=775000U
* device instance $1063 r0 *1 36.795,22 nfet_01v8
M$1063 4071 3883 167 167 nfet_01v8 L=150000U W=210000U AS=51200000000P
+ AD=21875000000P PS=775000U PD=460000U
* device instance $1064 r0 *1 36.76,22.4 nfet_01v8
M$1064 52 142 4071 167 nfet_01v8 L=150000U W=140000U AS=21875000000P
+ AD=16800000000P PS=460000U PD=380000U
* device instance $1065 r0 *1 36.76,22.79 nfet_01v8
M$1065 4528 143 52 167 nfet_01v8 L=150000U W=140000U AS=16800000000P
+ AD=21875000000P PS=380000U PD=460000U
* device instance $1066 r0 *1 36.795,23.19 nfet_01v8
M$1066 167 3798 4528 167 nfet_01v8 L=150000U W=210000U AS=21875000000P
+ AD=51200000000P PS=460000U PD=775000U
* device instance $1067 r0 *1 36.795,23.58 nfet_01v8
M$1067 3798 4528 167 167 nfet_01v8 L=150000U W=210000U AS=51200000000P
+ AD=21875000000P PS=775000U PD=460000U
* device instance $1068 r0 *1 36.76,23.98 nfet_01v8
M$1068 51 143 3798 167 nfet_01v8 L=150000U W=140000U AS=21875000000P
+ AD=16800000000P PS=460000U PD=380000U
* device instance $1069 r0 *1 36.76,24.37 nfet_01v8
M$1069 3757 144 51 167 nfet_01v8 L=150000U W=140000U AS=16800000000P
+ AD=21875000000P PS=380000U PD=460000U
* device instance $1070 r0 *1 36.795,24.77 nfet_01v8
M$1070 167 3797 3757 167 nfet_01v8 L=150000U W=210000U AS=21875000000P
+ AD=51200000000P PS=460000U PD=775000U
* device instance $1071 r0 *1 36.795,25.16 nfet_01v8
M$1071 3797 3757 167 167 nfet_01v8 L=150000U W=210000U AS=51200000000P
+ AD=21875000000P PS=775000U PD=460000U
* device instance $1072 r0 *1 36.76,25.56 nfet_01v8
M$1072 52 144 3797 167 nfet_01v8 L=150000U W=140000U AS=21875000000P
+ AD=16800000000P PS=460000U PD=380000U
* device instance $1073 r0 *1 36.76,25.95 nfet_01v8
M$1073 3888 145 52 167 nfet_01v8 L=150000U W=140000U AS=16800000000P
+ AD=21875000000P PS=380000U PD=460000U
* device instance $1074 r0 *1 36.795,26.35 nfet_01v8
M$1074 167 4076 3888 167 nfet_01v8 L=150000U W=210000U AS=21875000000P
+ AD=51200000000P PS=460000U PD=775000U
* device instance $1075 r0 *1 36.795,26.74 nfet_01v8
M$1075 4076 3888 167 167 nfet_01v8 L=150000U W=210000U AS=51200000000P
+ AD=21875000000P PS=775000U PD=460000U
* device instance $1076 r0 *1 36.76,27.14 nfet_01v8
M$1076 51 145 4076 167 nfet_01v8 L=150000U W=140000U AS=21875000000P
+ AD=16800000000P PS=460000U PD=380000U
* device instance $1077 r0 *1 47.66,21.21 nfet_01v8
M$1077 3952 142 67 167 nfet_01v8 L=150000U W=140000U AS=16800000000P
+ AD=21875000000P PS=380000U PD=460000U
* device instance $1078 r0 *1 47.695,21.61 nfet_01v8
M$1078 167 4151 3952 167 nfet_01v8 L=150000U W=210000U AS=21875000000P
+ AD=51200000000P PS=460000U PD=775000U
* device instance $1079 r0 *1 47.695,22 nfet_01v8
M$1079 4151 3952 167 167 nfet_01v8 L=150000U W=210000U AS=51200000000P
+ AD=21875000000P PS=775000U PD=460000U
* device instance $1080 r0 *1 47.66,22.4 nfet_01v8
M$1080 68 142 4151 167 nfet_01v8 L=150000U W=140000U AS=21875000000P
+ AD=16800000000P PS=460000U PD=380000U
* device instance $1081 r0 *1 47.66,22.79 nfet_01v8
M$1081 4381 143 68 167 nfet_01v8 L=150000U W=140000U AS=16800000000P
+ AD=21875000000P PS=380000U PD=460000U
* device instance $1082 r0 *1 47.695,23.19 nfet_01v8
M$1082 167 4160 4381 167 nfet_01v8 L=150000U W=210000U AS=21875000000P
+ AD=51200000000P PS=460000U PD=775000U
* device instance $1083 r0 *1 47.695,23.58 nfet_01v8
M$1083 4160 4381 167 167 nfet_01v8 L=150000U W=210000U AS=51200000000P
+ AD=21875000000P PS=775000U PD=460000U
* device instance $1084 r0 *1 47.66,23.98 nfet_01v8
M$1084 67 143 4160 167 nfet_01v8 L=150000U W=140000U AS=21875000000P
+ AD=16800000000P PS=460000U PD=380000U
* device instance $1085 r0 *1 47.66,24.37 nfet_01v8
M$1085 3955 144 67 167 nfet_01v8 L=150000U W=140000U AS=16800000000P
+ AD=21875000000P PS=380000U PD=460000U
* device instance $1086 r0 *1 47.695,24.77 nfet_01v8
M$1086 167 4154 3955 167 nfet_01v8 L=150000U W=210000U AS=21875000000P
+ AD=51200000000P PS=460000U PD=775000U
* device instance $1087 r0 *1 47.695,25.16 nfet_01v8
M$1087 4154 3955 167 167 nfet_01v8 L=150000U W=210000U AS=51200000000P
+ AD=21875000000P PS=775000U PD=460000U
* device instance $1088 r0 *1 47.66,25.56 nfet_01v8
M$1088 68 144 4154 167 nfet_01v8 L=150000U W=140000U AS=21875000000P
+ AD=16800000000P PS=460000U PD=380000U
* device instance $1089 r0 *1 47.66,25.95 nfet_01v8
M$1089 3957 145 68 167 nfet_01v8 L=150000U W=140000U AS=16800000000P
+ AD=21875000000P PS=380000U PD=460000U
* device instance $1090 r0 *1 47.695,26.35 nfet_01v8
M$1090 167 4156 3957 167 nfet_01v8 L=150000U W=210000U AS=21875000000P
+ AD=51200000000P PS=460000U PD=775000U
* device instance $1091 r0 *1 47.695,26.74 nfet_01v8
M$1091 4156 3957 167 167 nfet_01v8 L=150000U W=210000U AS=51200000000P
+ AD=21875000000P PS=775000U PD=460000U
* device instance $1092 r0 *1 47.66,27.14 nfet_01v8
M$1092 67 145 4156 167 nfet_01v8 L=150000U W=140000U AS=21875000000P
+ AD=16800000000P PS=460000U PD=380000U
* device instance $1093 r0 *1 58.56,21.21 nfet_01v8
M$1093 3963 142 83 167 nfet_01v8 L=150000U W=140000U AS=16800000000P
+ AD=21875000000P PS=380000U PD=460000U
* device instance $1094 r0 *1 58.595,21.61 nfet_01v8
M$1094 167 4163 3963 167 nfet_01v8 L=150000U W=210000U AS=21875000000P
+ AD=51200000000P PS=460000U PD=775000U
* device instance $1095 r0 *1 58.595,22 nfet_01v8
M$1095 4163 3963 167 167 nfet_01v8 L=150000U W=210000U AS=51200000000P
+ AD=21875000000P PS=775000U PD=460000U
* device instance $1096 r0 *1 58.56,22.4 nfet_01v8
M$1096 84 142 4163 167 nfet_01v8 L=150000U W=140000U AS=21875000000P
+ AD=16800000000P PS=460000U PD=380000U
* device instance $1097 r0 *1 58.56,22.79 nfet_01v8
M$1097 4386 143 84 167 nfet_01v8 L=150000U W=140000U AS=16800000000P
+ AD=21875000000P PS=380000U PD=460000U
* device instance $1098 r0 *1 58.595,23.19 nfet_01v8
M$1098 167 3812 4386 167 nfet_01v8 L=150000U W=210000U AS=21875000000P
+ AD=51200000000P PS=460000U PD=775000U
* device instance $1099 r0 *1 58.595,23.58 nfet_01v8
M$1099 3812 4386 167 167 nfet_01v8 L=150000U W=210000U AS=51200000000P
+ AD=21875000000P PS=775000U PD=460000U
* device instance $1100 r0 *1 58.56,23.98 nfet_01v8
M$1100 83 143 3812 167 nfet_01v8 L=150000U W=140000U AS=21875000000P
+ AD=16800000000P PS=460000U PD=380000U
* device instance $1101 r0 *1 58.56,24.37 nfet_01v8
M$1101 3772 144 83 167 nfet_01v8 L=150000U W=140000U AS=16800000000P
+ AD=21875000000P PS=380000U PD=460000U
* device instance $1102 r0 *1 58.595,24.77 nfet_01v8
M$1102 167 3820 3772 167 nfet_01v8 L=150000U W=210000U AS=21875000000P
+ AD=51200000000P PS=460000U PD=775000U
* device instance $1103 r0 *1 58.595,25.16 nfet_01v8
M$1103 3820 3772 167 167 nfet_01v8 L=150000U W=210000U AS=51200000000P
+ AD=21875000000P PS=775000U PD=460000U
* device instance $1104 r0 *1 58.56,25.56 nfet_01v8
M$1104 84 144 3820 167 nfet_01v8 L=150000U W=140000U AS=21875000000P
+ AD=16800000000P PS=460000U PD=380000U
* device instance $1105 r0 *1 58.56,25.95 nfet_01v8
M$1105 3966 145 84 167 nfet_01v8 L=150000U W=140000U AS=16800000000P
+ AD=21875000000P PS=380000U PD=460000U
* device instance $1106 r0 *1 58.595,26.35 nfet_01v8
M$1106 167 4168 3966 167 nfet_01v8 L=150000U W=210000U AS=21875000000P
+ AD=51200000000P PS=460000U PD=775000U
* device instance $1107 r0 *1 58.595,26.74 nfet_01v8
M$1107 4168 3966 167 167 nfet_01v8 L=150000U W=210000U AS=51200000000P
+ AD=21875000000P PS=775000U PD=460000U
* device instance $1108 r0 *1 58.56,27.14 nfet_01v8
M$1108 83 145 4168 167 nfet_01v8 L=150000U W=140000U AS=21875000000P
+ AD=16800000000P PS=460000U PD=380000U
* device instance $1109 r0 *1 69.46,21.21 nfet_01v8
M$1109 3946 142 99 167 nfet_01v8 L=150000U W=140000U AS=16800000000P
+ AD=21875000000P PS=380000U PD=460000U
* device instance $1110 r0 *1 69.495,21.61 nfet_01v8
M$1110 167 4144 3946 167 nfet_01v8 L=150000U W=210000U AS=21875000000P
+ AD=51200000000P PS=460000U PD=775000U
* device instance $1111 r0 *1 69.495,22 nfet_01v8
M$1111 4144 3946 167 167 nfet_01v8 L=150000U W=210000U AS=51200000000P
+ AD=21875000000P PS=775000U PD=460000U
* device instance $1112 r0 *1 69.46,22.4 nfet_01v8
M$1112 100 142 4144 167 nfet_01v8 L=150000U W=140000U AS=21875000000P
+ AD=16800000000P PS=460000U PD=380000U
* device instance $1113 r0 *1 69.46,22.79 nfet_01v8
M$1113 4281 143 100 167 nfet_01v8 L=150000U W=140000U AS=16800000000P
+ AD=21875000000P PS=380000U PD=460000U
* device instance $1114 r0 *1 69.495,23.19 nfet_01v8
M$1114 167 3836 4281 167 nfet_01v8 L=150000U W=210000U AS=21875000000P
+ AD=51200000000P PS=460000U PD=775000U
* device instance $1115 r0 *1 69.495,23.58 nfet_01v8
M$1115 3836 4281 167 167 nfet_01v8 L=150000U W=210000U AS=51200000000P
+ AD=21875000000P PS=775000U PD=460000U
* device instance $1116 r0 *1 69.46,23.98 nfet_01v8
M$1116 99 143 3836 167 nfet_01v8 L=150000U W=140000U AS=21875000000P
+ AD=16800000000P PS=460000U PD=380000U
* device instance $1117 r0 *1 69.46,24.37 nfet_01v8
M$1117 3947 144 99 167 nfet_01v8 L=150000U W=140000U AS=16800000000P
+ AD=21875000000P PS=380000U PD=460000U
* device instance $1118 r0 *1 69.495,24.77 nfet_01v8
M$1118 167 4145 3947 167 nfet_01v8 L=150000U W=210000U AS=21875000000P
+ AD=51200000000P PS=460000U PD=775000U
* device instance $1119 r0 *1 69.495,25.16 nfet_01v8
M$1119 4145 3947 167 167 nfet_01v8 L=150000U W=210000U AS=51200000000P
+ AD=21875000000P PS=775000U PD=460000U
* device instance $1120 r0 *1 69.46,25.56 nfet_01v8
M$1120 100 144 4145 167 nfet_01v8 L=150000U W=140000U AS=21875000000P
+ AD=16800000000P PS=460000U PD=380000U
* device instance $1121 r0 *1 69.46,25.95 nfet_01v8
M$1121 3948 145 100 167 nfet_01v8 L=150000U W=140000U AS=16800000000P
+ AD=21875000000P PS=380000U PD=460000U
* device instance $1122 r0 *1 69.495,26.35 nfet_01v8
M$1122 167 4146 3948 167 nfet_01v8 L=150000U W=210000U AS=21875000000P
+ AD=51200000000P PS=460000U PD=775000U
* device instance $1123 r0 *1 69.495,26.74 nfet_01v8
M$1123 4146 3948 167 167 nfet_01v8 L=150000U W=210000U AS=51200000000P
+ AD=21875000000P PS=775000U PD=460000U
* device instance $1124 r0 *1 69.46,27.14 nfet_01v8
M$1124 99 145 4146 167 nfet_01v8 L=150000U W=140000U AS=21875000000P
+ AD=16800000000P PS=460000U PD=380000U
* device instance $1125 r0 *1 4.06,13.31 nfet_01v8
M$1125 3994 138 3 167 nfet_01v8 L=150000U W=140000U AS=16800000000P
+ AD=21875000000P PS=380000U PD=460000U
* device instance $1126 r0 *1 4.095,13.71 nfet_01v8
M$1126 167 4202 3994 167 nfet_01v8 L=150000U W=210000U AS=21875000000P
+ AD=51200000000P PS=460000U PD=775000U
* device instance $1127 r0 *1 4.095,14.1 nfet_01v8
M$1127 4202 3994 167 167 nfet_01v8 L=150000U W=210000U AS=51200000000P
+ AD=21875000000P PS=775000U PD=460000U
* device instance $1128 r0 *1 4.06,14.5 nfet_01v8
M$1128 4 138 4202 167 nfet_01v8 L=150000U W=140000U AS=21875000000P
+ AD=16800000000P PS=460000U PD=380000U
* device instance $1129 r0 *1 4.06,14.89 nfet_01v8
M$1129 4478 139 4 167 nfet_01v8 L=150000U W=140000U AS=16800000000P
+ AD=21875000000P PS=380000U PD=460000U
* device instance $1130 r0 *1 4.095,15.29 nfet_01v8
M$1130 167 4200 4478 167 nfet_01v8 L=150000U W=210000U AS=21875000000P
+ AD=51200000000P PS=460000U PD=775000U
* device instance $1131 r0 *1 4.095,15.68 nfet_01v8
M$1131 4200 4478 167 167 nfet_01v8 L=150000U W=210000U AS=51200000000P
+ AD=21875000000P PS=775000U PD=460000U
* device instance $1132 r0 *1 4.06,16.08 nfet_01v8
M$1132 3 139 4200 167 nfet_01v8 L=150000U W=140000U AS=21875000000P
+ AD=16800000000P PS=460000U PD=380000U
* device instance $1133 r0 *1 4.06,16.47 nfet_01v8
M$1133 3759 140 3 167 nfet_01v8 L=150000U W=140000U AS=16800000000P
+ AD=21875000000P PS=380000U PD=460000U
* device instance $1134 r0 *1 4.095,16.87 nfet_01v8
M$1134 167 3800 3759 167 nfet_01v8 L=150000U W=210000U AS=21875000000P
+ AD=51200000000P PS=460000U PD=775000U
* device instance $1135 r0 *1 4.095,17.26 nfet_01v8
M$1135 3800 3759 167 167 nfet_01v8 L=150000U W=210000U AS=51200000000P
+ AD=21875000000P PS=775000U PD=460000U
* device instance $1136 r0 *1 4.06,17.66 nfet_01v8
M$1136 4 140 3800 167 nfet_01v8 L=150000U W=140000U AS=21875000000P
+ AD=16800000000P PS=460000U PD=380000U
* device instance $1137 r0 *1 4.06,18.05 nfet_01v8
M$1137 3992 141 4 167 nfet_01v8 L=150000U W=140000U AS=16800000000P
+ AD=21875000000P PS=380000U PD=460000U
* device instance $1138 r0 *1 4.095,18.45 nfet_01v8
M$1138 167 4199 3992 167 nfet_01v8 L=150000U W=210000U AS=21875000000P
+ AD=51200000000P PS=460000U PD=775000U
* device instance $1139 r0 *1 4.095,18.84 nfet_01v8
M$1139 4199 3992 167 167 nfet_01v8 L=150000U W=210000U AS=51200000000P
+ AD=21875000000P PS=775000U PD=460000U
* device instance $1140 r0 *1 4.06,19.24 nfet_01v8
M$1140 3 141 4199 167 nfet_01v8 L=150000U W=140000U AS=21875000000P
+ AD=16800000000P PS=460000U PD=380000U
* device instance $1141 r0 *1 80.36,21.21 nfet_01v8
M$1141 3934 142 115 167 nfet_01v8 L=150000U W=140000U AS=16800000000P
+ AD=21875000000P PS=380000U PD=460000U
* device instance $1142 r0 *1 80.395,21.61 nfet_01v8
M$1142 167 4129 3934 167 nfet_01v8 L=150000U W=210000U AS=21875000000P
+ AD=51200000000P PS=460000U PD=775000U
* device instance $1143 r0 *1 80.395,22 nfet_01v8
M$1143 4129 3934 167 167 nfet_01v8 L=150000U W=210000U AS=51200000000P
+ AD=21875000000P PS=775000U PD=460000U
* device instance $1144 r0 *1 80.36,22.4 nfet_01v8
M$1144 116 142 4129 167 nfet_01v8 L=150000U W=140000U AS=21875000000P
+ AD=16800000000P PS=460000U PD=380000U
* device instance $1145 r0 *1 80.36,22.79 nfet_01v8
M$1145 4360 143 116 167 nfet_01v8 L=150000U W=140000U AS=16800000000P
+ AD=21875000000P PS=380000U PD=460000U
* device instance $1146 r0 *1 80.395,23.19 nfet_01v8
M$1146 167 3845 4360 167 nfet_01v8 L=150000U W=210000U AS=21875000000P
+ AD=51200000000P PS=460000U PD=775000U
* device instance $1147 r0 *1 80.395,23.58 nfet_01v8
M$1147 3845 4360 167 167 nfet_01v8 L=150000U W=210000U AS=51200000000P
+ AD=21875000000P PS=775000U PD=460000U
* device instance $1148 r0 *1 80.36,23.98 nfet_01v8
M$1148 115 143 3845 167 nfet_01v8 L=150000U W=140000U AS=21875000000P
+ AD=16800000000P PS=460000U PD=380000U
* device instance $1149 r0 *1 80.36,24.37 nfet_01v8
M$1149 3935 144 115 167 nfet_01v8 L=150000U W=140000U AS=16800000000P
+ AD=21875000000P PS=380000U PD=460000U
* device instance $1150 r0 *1 80.395,24.77 nfet_01v8
M$1150 167 4130 3935 167 nfet_01v8 L=150000U W=210000U AS=21875000000P
+ AD=51200000000P PS=460000U PD=775000U
* device instance $1151 r0 *1 80.395,25.16 nfet_01v8
M$1151 4130 3935 167 167 nfet_01v8 L=150000U W=210000U AS=51200000000P
+ AD=21875000000P PS=775000U PD=460000U
* device instance $1152 r0 *1 80.36,25.56 nfet_01v8
M$1152 116 144 4130 167 nfet_01v8 L=150000U W=140000U AS=21875000000P
+ AD=16800000000P PS=460000U PD=380000U
* device instance $1153 r0 *1 80.36,25.95 nfet_01v8
M$1153 3939 145 116 167 nfet_01v8 L=150000U W=140000U AS=16800000000P
+ AD=21875000000P PS=380000U PD=460000U
* device instance $1154 r0 *1 80.395,26.35 nfet_01v8
M$1154 167 4136 3939 167 nfet_01v8 L=150000U W=210000U AS=21875000000P
+ AD=51200000000P PS=460000U PD=775000U
* device instance $1155 r0 *1 80.395,26.74 nfet_01v8
M$1155 4136 3939 167 167 nfet_01v8 L=150000U W=210000U AS=51200000000P
+ AD=21875000000P PS=775000U PD=460000U
* device instance $1156 r0 *1 80.36,27.14 nfet_01v8
M$1156 115 145 4136 167 nfet_01v8 L=150000U W=140000U AS=21875000000P
+ AD=16800000000P PS=460000U PD=380000U
* device instance $1157 r0 *1 27.74,60.71 nfet_01v8
M$1157 2281 162 38 167 nfet_01v8 L=150000U W=140000U AS=16800000000P
+ AD=21875000000P PS=380000U PD=460000U
* device instance $1158 r0 *1 28.26,60.71 nfet_01v8
M$1158 918 162 39 167 nfet_01v8 L=150000U W=140000U AS=16800000000P
+ AD=21875000000P PS=380000U PD=460000U
* device instance $1159 r0 *1 27.705,61.11 nfet_01v8
M$1159 167 2587 2281 167 nfet_01v8 L=150000U W=210000U AS=21875000000P
+ AD=40400000000P PS=460000U PD=560000U
* device instance $1160 r0 *1 28.295,61.11 nfet_01v8
M$1160 167 1435 918 167 nfet_01v8 L=150000U W=210000U AS=21875000000P
+ AD=40400000000P PS=460000U PD=560000U
* device instance $1161 r0 *1 27.705,61.5 nfet_01v8
M$1161 2587 2281 167 167 nfet_01v8 L=150000U W=210000U AS=40400000000P
+ AD=21875000000P PS=560000U PD=460000U
* device instance $1162 r0 *1 28.295,61.5 nfet_01v8
M$1162 1435 918 167 167 nfet_01v8 L=150000U W=210000U AS=40400000000P
+ AD=21875000000P PS=560000U PD=460000U
* device instance $1163 r0 *1 27.74,61.9 nfet_01v8
M$1163 37 162 2587 167 nfet_01v8 L=150000U W=140000U AS=21875000000P
+ AD=16800000000P PS=460000U PD=380000U
* device instance $1164 r0 *1 28.26,61.9 nfet_01v8
M$1164 40 162 1435 167 nfet_01v8 L=150000U W=140000U AS=21875000000P
+ AD=16800000000P PS=460000U PD=380000U
* device instance $1165 r0 *1 27.74,62.29 nfet_01v8
M$1165 3543 163 37 167 nfet_01v8 L=150000U W=140000U AS=16800000000P
+ AD=21875000000P PS=380000U PD=460000U
* device instance $1166 r0 *1 28.26,62.29 nfet_01v8
M$1166 4464 163 40 167 nfet_01v8 L=150000U W=140000U AS=16800000000P
+ AD=21875000000P PS=380000U PD=460000U
* device instance $1167 r0 *1 27.705,62.69 nfet_01v8
M$1167 167 2129 3543 167 nfet_01v8 L=150000U W=210000U AS=21875000000P
+ AD=40400000000P PS=460000U PD=560000U
* device instance $1168 r0 *1 28.295,62.69 nfet_01v8
M$1168 167 694 4464 167 nfet_01v8 L=150000U W=210000U AS=21875000000P
+ AD=40400000000P PS=460000U PD=560000U
* device instance $1169 r0 *1 27.705,63.08 nfet_01v8
M$1169 2129 3543 167 167 nfet_01v8 L=150000U W=210000U AS=40400000000P
+ AD=21875000000P PS=560000U PD=460000U
* device instance $1170 r0 *1 28.295,63.08 nfet_01v8
M$1170 694 4464 167 167 nfet_01v8 L=150000U W=210000U AS=40400000000P
+ AD=21875000000P PS=560000U PD=460000U
* device instance $1171 r0 *1 27.74,63.48 nfet_01v8
M$1171 38 163 2129 167 nfet_01v8 L=150000U W=140000U AS=21875000000P
+ AD=16800000000P PS=460000U PD=380000U
* device instance $1172 r0 *1 28.26,63.48 nfet_01v8
M$1172 39 163 694 167 nfet_01v8 L=150000U W=140000U AS=21875000000P
+ AD=16800000000P PS=460000U PD=380000U
* device instance $1173 r0 *1 27.74,63.87 nfet_01v8
M$1173 3544 164 38 167 nfet_01v8 L=150000U W=140000U AS=16800000000P
+ AD=21875000000P PS=380000U PD=460000U
* device instance $1174 r0 *1 28.26,63.87 nfet_01v8
M$1174 939 164 39 167 nfet_01v8 L=150000U W=140000U AS=16800000000P
+ AD=21875000000P PS=380000U PD=460000U
* device instance $1175 r0 *1 27.705,64.27 nfet_01v8
M$1175 167 2657 3544 167 nfet_01v8 L=150000U W=210000U AS=21875000000P
+ AD=40400000000P PS=460000U PD=560000U
* device instance $1176 r0 *1 28.295,64.27 nfet_01v8
M$1176 167 1462 939 167 nfet_01v8 L=150000U W=210000U AS=21875000000P
+ AD=40400000000P PS=460000U PD=560000U
* device instance $1177 r0 *1 27.705,64.66 nfet_01v8
M$1177 2657 3544 167 167 nfet_01v8 L=150000U W=210000U AS=40400000000P
+ AD=21875000000P PS=560000U PD=460000U
* device instance $1178 r0 *1 28.295,64.66 nfet_01v8
M$1178 1462 939 167 167 nfet_01v8 L=150000U W=210000U AS=40400000000P
+ AD=21875000000P PS=560000U PD=460000U
* device instance $1179 r0 *1 27.74,65.06 nfet_01v8
M$1179 37 164 2657 167 nfet_01v8 L=150000U W=140000U AS=21875000000P
+ AD=16800000000P PS=460000U PD=380000U
* device instance $1180 r0 *1 28.26,65.06 nfet_01v8
M$1180 40 164 1462 167 nfet_01v8 L=150000U W=140000U AS=21875000000P
+ AD=16800000000P PS=460000U PD=380000U
* device instance $1181 r0 *1 27.74,65.45 nfet_01v8
M$1181 2273 165 37 167 nfet_01v8 L=150000U W=140000U AS=16800000000P
+ AD=21875000000P PS=380000U PD=460000U
* device instance $1182 r0 *1 28.26,65.45 nfet_01v8
M$1182 1295 165 40 167 nfet_01v8 L=150000U W=140000U AS=16800000000P
+ AD=21875000000P PS=380000U PD=460000U
* device instance $1183 r0 *1 27.705,65.85 nfet_01v8
M$1183 167 2559 2273 167 nfet_01v8 L=150000U W=210000U AS=21875000000P
+ AD=40400000000P PS=460000U PD=560000U
* device instance $1184 r0 *1 28.295,65.85 nfet_01v8
M$1184 167 1872 1295 167 nfet_01v8 L=150000U W=210000U AS=21875000000P
+ AD=40400000000P PS=460000U PD=560000U
* device instance $1185 r0 *1 27.705,66.24 nfet_01v8
M$1185 2559 2273 167 167 nfet_01v8 L=150000U W=210000U AS=40400000000P
+ AD=21875000000P PS=560000U PD=460000U
* device instance $1186 r0 *1 28.295,66.24 nfet_01v8
M$1186 1872 1295 167 167 nfet_01v8 L=150000U W=210000U AS=40400000000P
+ AD=21875000000P PS=560000U PD=460000U
* device instance $1187 r0 *1 27.74,66.64 nfet_01v8
M$1187 38 165 2559 167 nfet_01v8 L=150000U W=140000U AS=21875000000P
+ AD=16800000000P PS=460000U PD=380000U
* device instance $1188 r0 *1 28.26,66.64 nfet_01v8
M$1188 39 165 1872 167 nfet_01v8 L=150000U W=140000U AS=21875000000P
+ AD=16800000000P PS=460000U PD=380000U
* device instance $1189 r0 *1 82.24,37.01 nfet_01v8
M$1189 3512 150 118 167 nfet_01v8 L=150000U W=140000U AS=16800000000P
+ AD=21875000000P PS=380000U PD=460000U
* device instance $1190 r0 *1 82.76,37.01 nfet_01v8
M$1190 1221 150 119 167 nfet_01v8 L=150000U W=140000U AS=16800000000P
+ AD=21875000000P PS=380000U PD=460000U
* device instance $1191 r0 *1 82.205,37.41 nfet_01v8
M$1191 167 2663 3512 167 nfet_01v8 L=150000U W=210000U AS=21875000000P
+ AD=40400000000P PS=460000U PD=560000U
* device instance $1192 r0 *1 82.795,37.41 nfet_01v8
M$1192 167 1792 1221 167 nfet_01v8 L=150000U W=210000U AS=21875000000P
+ AD=40400000000P PS=460000U PD=560000U
* device instance $1193 r0 *1 82.205,37.8 nfet_01v8
M$1193 2663 3512 167 167 nfet_01v8 L=150000U W=210000U AS=40400000000P
+ AD=21875000000P PS=560000U PD=460000U
* device instance $1194 r0 *1 82.795,37.8 nfet_01v8
M$1194 1792 1221 167 167 nfet_01v8 L=150000U W=210000U AS=40400000000P
+ AD=21875000000P PS=560000U PD=460000U
* device instance $1195 r0 *1 82.24,38.2 nfet_01v8
M$1195 117 150 2663 167 nfet_01v8 L=150000U W=140000U AS=21875000000P
+ AD=16800000000P PS=460000U PD=380000U
* device instance $1196 r0 *1 82.76,38.2 nfet_01v8
M$1196 120 150 1792 167 nfet_01v8 L=150000U W=140000U AS=21875000000P
+ AD=16800000000P PS=460000U PD=380000U
* device instance $1197 r0 *1 82.24,38.59 nfet_01v8
M$1197 3513 151 117 167 nfet_01v8 L=150000U W=140000U AS=16800000000P
+ AD=21875000000P PS=380000U PD=460000U
* device instance $1198 r0 *1 82.76,38.59 nfet_01v8
M$1198 4522 151 120 167 nfet_01v8 L=150000U W=140000U AS=16800000000P
+ AD=21875000000P PS=380000U PD=460000U
* device instance $1199 r0 *1 82.205,38.99 nfet_01v8
M$1199 167 1983 3513 167 nfet_01v8 L=150000U W=210000U AS=21875000000P
+ AD=40400000000P PS=460000U PD=560000U
* device instance $1200 r0 *1 82.795,38.99 nfet_01v8
M$1200 167 688 4522 167 nfet_01v8 L=150000U W=210000U AS=21875000000P
+ AD=40400000000P PS=460000U PD=560000U
* device instance $1201 r0 *1 82.205,39.38 nfet_01v8
M$1201 1983 3513 167 167 nfet_01v8 L=150000U W=210000U AS=40400000000P
+ AD=21875000000P PS=560000U PD=460000U
* device instance $1202 r0 *1 82.795,39.38 nfet_01v8
M$1202 688 4522 167 167 nfet_01v8 L=150000U W=210000U AS=40400000000P
+ AD=21875000000P PS=560000U PD=460000U
* device instance $1203 r0 *1 82.24,39.78 nfet_01v8
M$1203 118 151 1983 167 nfet_01v8 L=150000U W=140000U AS=21875000000P
+ AD=16800000000P PS=460000U PD=380000U
* device instance $1204 r0 *1 82.76,39.78 nfet_01v8
M$1204 119 151 688 167 nfet_01v8 L=150000U W=140000U AS=21875000000P
+ AD=16800000000P PS=460000U PD=380000U
* device instance $1205 r0 *1 82.24,40.17 nfet_01v8
M$1205 2107 152 118 167 nfet_01v8 L=150000U W=140000U AS=16800000000P
+ AD=21875000000P PS=380000U PD=460000U
* device instance $1206 r0 *1 82.76,40.17 nfet_01v8
M$1206 1219 152 119 167 nfet_01v8 L=150000U W=140000U AS=16800000000P
+ AD=21875000000P PS=380000U PD=460000U
* device instance $1207 r0 *1 82.205,40.57 nfet_01v8
M$1207 167 2217 2107 167 nfet_01v8 L=150000U W=210000U AS=21875000000P
+ AD=40400000000P PS=460000U PD=560000U
* device instance $1208 r0 *1 82.795,40.57 nfet_01v8
M$1208 167 1790 1219 167 nfet_01v8 L=150000U W=210000U AS=21875000000P
+ AD=40400000000P PS=460000U PD=560000U
* device instance $1209 r0 *1 82.205,40.96 nfet_01v8
M$1209 2217 2107 167 167 nfet_01v8 L=150000U W=210000U AS=40400000000P
+ AD=21875000000P PS=560000U PD=460000U
* device instance $1210 r0 *1 82.795,40.96 nfet_01v8
M$1210 1790 1219 167 167 nfet_01v8 L=150000U W=210000U AS=40400000000P
+ AD=21875000000P PS=560000U PD=460000U
* device instance $1211 r0 *1 82.24,41.36 nfet_01v8
M$1211 117 152 2217 167 nfet_01v8 L=150000U W=140000U AS=21875000000P
+ AD=16800000000P PS=460000U PD=380000U
* device instance $1212 r0 *1 82.76,41.36 nfet_01v8
M$1212 120 152 1790 167 nfet_01v8 L=150000U W=140000U AS=21875000000P
+ AD=16800000000P PS=460000U PD=380000U
* device instance $1213 r0 *1 82.24,41.75 nfet_01v8
M$1213 2323 153 117 167 nfet_01v8 L=150000U W=140000U AS=16800000000P
+ AD=21875000000P PS=380000U PD=460000U
* device instance $1214 r0 *1 82.76,41.75 nfet_01v8
M$1214 1229 153 120 167 nfet_01v8 L=150000U W=140000U AS=16800000000P
+ AD=21875000000P PS=380000U PD=460000U
* device instance $1215 r0 *1 82.205,42.15 nfet_01v8
M$1215 167 2664 2323 167 nfet_01v8 L=150000U W=210000U AS=21875000000P
+ AD=40400000000P PS=460000U PD=560000U
* device instance $1216 r0 *1 82.795,42.15 nfet_01v8
M$1216 167 1800 1229 167 nfet_01v8 L=150000U W=210000U AS=21875000000P
+ AD=40400000000P PS=460000U PD=560000U
* device instance $1217 r0 *1 82.205,42.54 nfet_01v8
M$1217 2664 2323 167 167 nfet_01v8 L=150000U W=210000U AS=40400000000P
+ AD=21875000000P PS=560000U PD=460000U
* device instance $1218 r0 *1 82.795,42.54 nfet_01v8
M$1218 1800 1229 167 167 nfet_01v8 L=150000U W=210000U AS=40400000000P
+ AD=21875000000P PS=560000U PD=460000U
* device instance $1219 r0 *1 82.24,42.94 nfet_01v8
M$1219 118 153 2664 167 nfet_01v8 L=150000U W=140000U AS=21875000000P
+ AD=16800000000P PS=460000U PD=380000U
* device instance $1220 r0 *1 82.76,42.94 nfet_01v8
M$1220 119 153 1800 167 nfet_01v8 L=150000U W=140000U AS=21875000000P
+ AD=16800000000P PS=460000U PD=380000U
* device instance $1221 r0 *1 71.34,37.01 nfet_01v8
M$1221 3506 150 102 167 nfet_01v8 L=150000U W=140000U AS=16800000000P
+ AD=21875000000P PS=380000U PD=460000U
* device instance $1222 r0 *1 71.86,37.01 nfet_01v8
M$1222 1349 150 103 167 nfet_01v8 L=150000U W=140000U AS=16800000000P
+ AD=21875000000P PS=380000U PD=460000U
* device instance $1223 r0 *1 71.305,37.41 nfet_01v8
M$1223 167 2604 3506 167 nfet_01v8 L=150000U W=210000U AS=21875000000P
+ AD=40400000000P PS=460000U PD=560000U
* device instance $1224 r0 *1 71.895,37.41 nfet_01v8
M$1224 167 1937 1349 167 nfet_01v8 L=150000U W=210000U AS=21875000000P
+ AD=40400000000P PS=460000U PD=560000U
* device instance $1225 r0 *1 71.305,37.8 nfet_01v8
M$1225 2604 3506 167 167 nfet_01v8 L=150000U W=210000U AS=40400000000P
+ AD=21875000000P PS=560000U PD=460000U
* device instance $1226 r0 *1 71.895,37.8 nfet_01v8
M$1226 1937 1349 167 167 nfet_01v8 L=150000U W=210000U AS=40400000000P
+ AD=21875000000P PS=560000U PD=460000U
* device instance $1227 r0 *1 71.34,38.2 nfet_01v8
M$1227 101 150 2604 167 nfet_01v8 L=150000U W=140000U AS=21875000000P
+ AD=16800000000P PS=460000U PD=380000U
* device instance $1228 r0 *1 71.86,38.2 nfet_01v8
M$1228 104 150 1937 167 nfet_01v8 L=150000U W=140000U AS=21875000000P
+ AD=16800000000P PS=460000U PD=380000U
* device instance $1229 r0 *1 71.34,38.59 nfet_01v8
M$1229 3505 151 101 167 nfet_01v8 L=150000U W=140000U AS=16800000000P
+ AD=21875000000P PS=380000U PD=460000U
* device instance $1230 r0 *1 71.86,38.59 nfet_01v8
M$1230 4538 151 104 167 nfet_01v8 L=150000U W=140000U AS=16800000000P
+ AD=21875000000P PS=380000U PD=460000U
* device instance $1231 r0 *1 71.305,38.99 nfet_01v8
M$1231 167 2001 3505 167 nfet_01v8 L=150000U W=210000U AS=21875000000P
+ AD=40400000000P PS=460000U PD=560000U
* device instance $1232 r0 *1 71.895,38.99 nfet_01v8
M$1232 167 1950 4538 167 nfet_01v8 L=150000U W=210000U AS=21875000000P
+ AD=40400000000P PS=460000U PD=560000U
* device instance $1233 r0 *1 71.305,39.38 nfet_01v8
M$1233 2001 3505 167 167 nfet_01v8 L=150000U W=210000U AS=40400000000P
+ AD=21875000000P PS=560000U PD=460000U
* device instance $1234 r0 *1 71.895,39.38 nfet_01v8
M$1234 1950 4538 167 167 nfet_01v8 L=150000U W=210000U AS=40400000000P
+ AD=21875000000P PS=560000U PD=460000U
* device instance $1235 r0 *1 71.34,39.78 nfet_01v8
M$1235 102 151 2001 167 nfet_01v8 L=150000U W=140000U AS=21875000000P
+ AD=16800000000P PS=460000U PD=380000U
* device instance $1236 r0 *1 71.86,39.78 nfet_01v8
M$1236 103 151 1950 167 nfet_01v8 L=150000U W=140000U AS=21875000000P
+ AD=16800000000P PS=460000U PD=380000U
* device instance $1237 r0 *1 71.34,40.17 nfet_01v8
M$1237 2302 152 102 167 nfet_01v8 L=150000U W=140000U AS=16800000000P
+ AD=21875000000P PS=380000U PD=460000U
* device instance $1238 r0 *1 71.86,40.17 nfet_01v8
M$1238 1312 152 103 167 nfet_01v8 L=150000U W=140000U AS=16800000000P
+ AD=21875000000P PS=380000U PD=460000U
* device instance $1239 r0 *1 71.305,40.57 nfet_01v8
M$1239 167 2620 2302 167 nfet_01v8 L=150000U W=210000U AS=21875000000P
+ AD=40400000000P PS=460000U PD=560000U
* device instance $1240 r0 *1 71.895,40.57 nfet_01v8
M$1240 167 1892 1312 167 nfet_01v8 L=150000U W=210000U AS=21875000000P
+ AD=40400000000P PS=460000U PD=560000U
* device instance $1241 r0 *1 71.305,40.96 nfet_01v8
M$1241 2620 2302 167 167 nfet_01v8 L=150000U W=210000U AS=40400000000P
+ AD=21875000000P PS=560000U PD=460000U
* device instance $1242 r0 *1 71.895,40.96 nfet_01v8
M$1242 1892 1312 167 167 nfet_01v8 L=150000U W=210000U AS=40400000000P
+ AD=21875000000P PS=560000U PD=460000U
* device instance $1243 r0 *1 71.34,41.36 nfet_01v8
M$1243 101 152 2620 167 nfet_01v8 L=150000U W=140000U AS=21875000000P
+ AD=16800000000P PS=460000U PD=380000U
* device instance $1244 r0 *1 71.86,41.36 nfet_01v8
M$1244 104 152 1892 167 nfet_01v8 L=150000U W=140000U AS=21875000000P
+ AD=16800000000P PS=460000U PD=380000U
* device instance $1245 r0 *1 71.34,41.75 nfet_01v8
M$1245 2283 153 101 167 nfet_01v8 L=150000U W=140000U AS=16800000000P
+ AD=21875000000P PS=380000U PD=460000U
* device instance $1246 r0 *1 71.86,41.75 nfet_01v8
M$1246 1367 153 104 167 nfet_01v8 L=150000U W=140000U AS=16800000000P
+ AD=21875000000P PS=380000U PD=460000U
* device instance $1247 r0 *1 71.305,42.15 nfet_01v8
M$1247 167 2589 2283 167 nfet_01v8 L=150000U W=210000U AS=21875000000P
+ AD=40400000000P PS=460000U PD=560000U
* device instance $1248 r0 *1 71.895,42.15 nfet_01v8
M$1248 167 1958 1367 167 nfet_01v8 L=150000U W=210000U AS=21875000000P
+ AD=40400000000P PS=460000U PD=560000U
* device instance $1249 r0 *1 71.305,42.54 nfet_01v8
M$1249 2589 2283 167 167 nfet_01v8 L=150000U W=210000U AS=40400000000P
+ AD=21875000000P PS=560000U PD=460000U
* device instance $1250 r0 *1 71.895,42.54 nfet_01v8
M$1250 1958 1367 167 167 nfet_01v8 L=150000U W=210000U AS=40400000000P
+ AD=21875000000P PS=560000U PD=460000U
* device instance $1251 r0 *1 71.34,42.94 nfet_01v8
M$1251 102 153 2589 167 nfet_01v8 L=150000U W=140000U AS=21875000000P
+ AD=16800000000P PS=460000U PD=380000U
* device instance $1252 r0 *1 71.86,42.94 nfet_01v8
M$1252 103 153 1958 167 nfet_01v8 L=150000U W=140000U AS=21875000000P
+ AD=16800000000P PS=460000U PD=380000U
* device instance $1253 r0 *1 60.44,37.01 nfet_01v8
M$1253 2282 150 86 167 nfet_01v8 L=150000U W=140000U AS=16800000000P
+ AD=21875000000P PS=380000U PD=460000U
* device instance $1254 r0 *1 60.96,37.01 nfet_01v8
M$1254 1032 150 87 167 nfet_01v8 L=150000U W=140000U AS=16800000000P
+ AD=21875000000P PS=380000U PD=460000U
* device instance $1255 r0 *1 60.405,37.41 nfet_01v8
M$1255 167 2588 2282 167 nfet_01v8 L=150000U W=210000U AS=21875000000P
+ AD=40400000000P PS=460000U PD=560000U
* device instance $1256 r0 *1 60.995,37.41 nfet_01v8
M$1256 167 1571 1032 167 nfet_01v8 L=150000U W=210000U AS=21875000000P
+ AD=40400000000P PS=460000U PD=560000U
* device instance $1257 r0 *1 60.405,37.8 nfet_01v8
M$1257 2588 2282 167 167 nfet_01v8 L=150000U W=210000U AS=40400000000P
+ AD=21875000000P PS=560000U PD=460000U
* device instance $1258 r0 *1 60.995,37.8 nfet_01v8
M$1258 1571 1032 167 167 nfet_01v8 L=150000U W=210000U AS=40400000000P
+ AD=21875000000P PS=560000U PD=460000U
* device instance $1259 r0 *1 60.44,38.2 nfet_01v8
M$1259 85 150 2588 167 nfet_01v8 L=150000U W=140000U AS=21875000000P
+ AD=16800000000P PS=460000U PD=380000U
* device instance $1260 r0 *1 60.96,38.2 nfet_01v8
M$1260 88 150 1571 167 nfet_01v8 L=150000U W=140000U AS=21875000000P
+ AD=16800000000P PS=460000U PD=380000U
* device instance $1261 r0 *1 60.44,38.59 nfet_01v8
M$1261 3617 151 85 167 nfet_01v8 L=150000U W=140000U AS=16800000000P
+ AD=21875000000P PS=380000U PD=460000U
* device instance $1262 r0 *1 60.96,38.59 nfet_01v8
M$1262 4300 151 88 167 nfet_01v8 L=150000U W=140000U AS=16800000000P
+ AD=21875000000P PS=380000U PD=460000U
* device instance $1263 r0 *1 60.405,38.99 nfet_01v8
M$1263 167 2034 3617 167 nfet_01v8 L=150000U W=210000U AS=21875000000P
+ AD=40400000000P PS=460000U PD=560000U
* device instance $1264 r0 *1 60.995,38.99 nfet_01v8
M$1264 167 756 4300 167 nfet_01v8 L=150000U W=210000U AS=21875000000P
+ AD=40400000000P PS=460000U PD=560000U
* device instance $1265 r0 *1 60.405,39.38 nfet_01v8
M$1265 2034 3617 167 167 nfet_01v8 L=150000U W=210000U AS=40400000000P
+ AD=21875000000P PS=560000U PD=460000U
* device instance $1266 r0 *1 60.995,39.38 nfet_01v8
M$1266 756 4300 167 167 nfet_01v8 L=150000U W=210000U AS=40400000000P
+ AD=21875000000P PS=560000U PD=460000U
* device instance $1267 r0 *1 60.44,39.78 nfet_01v8
M$1267 86 151 2034 167 nfet_01v8 L=150000U W=140000U AS=21875000000P
+ AD=16800000000P PS=460000U PD=380000U
* device instance $1268 r0 *1 60.96,39.78 nfet_01v8
M$1268 87 151 756 167 nfet_01v8 L=150000U W=140000U AS=21875000000P
+ AD=16800000000P PS=460000U PD=380000U
* device instance $1269 r0 *1 60.44,40.17 nfet_01v8
M$1269 2090 152 86 167 nfet_01v8 L=150000U W=140000U AS=16800000000P
+ AD=21875000000P PS=380000U PD=460000U
* device instance $1270 r0 *1 60.96,40.17 nfet_01v8
M$1270 959 152 87 167 nfet_01v8 L=150000U W=140000U AS=16800000000P
+ AD=21875000000P PS=380000U PD=460000U
* device instance $1271 r0 *1 60.405,40.57 nfet_01v8
M$1271 167 2179 2090 167 nfet_01v8 L=150000U W=210000U AS=21875000000P
+ AD=40400000000P PS=460000U PD=560000U
* device instance $1272 r0 *1 60.995,40.57 nfet_01v8
M$1272 167 1485 959 167 nfet_01v8 L=150000U W=210000U AS=21875000000P
+ AD=40400000000P PS=460000U PD=560000U
* device instance $1273 r0 *1 60.405,40.96 nfet_01v8
M$1273 2179 2090 167 167 nfet_01v8 L=150000U W=210000U AS=40400000000P
+ AD=21875000000P PS=560000U PD=460000U
* device instance $1274 r0 *1 60.995,40.96 nfet_01v8
M$1274 1485 959 167 167 nfet_01v8 L=150000U W=210000U AS=40400000000P
+ AD=21875000000P PS=560000U PD=460000U
* device instance $1275 r0 *1 60.44,41.36 nfet_01v8
M$1275 85 152 2179 167 nfet_01v8 L=150000U W=140000U AS=21875000000P
+ AD=16800000000P PS=460000U PD=380000U
* device instance $1276 r0 *1 60.96,41.36 nfet_01v8
M$1276 88 152 1485 167 nfet_01v8 L=150000U W=140000U AS=21875000000P
+ AD=16800000000P PS=460000U PD=380000U
* device instance $1277 r0 *1 60.44,41.75 nfet_01v8
M$1277 2279 153 85 167 nfet_01v8 L=150000U W=140000U AS=16800000000P
+ AD=21875000000P PS=380000U PD=460000U
* device instance $1278 r0 *1 60.96,41.75 nfet_01v8
M$1278 1039 153 88 167 nfet_01v8 L=150000U W=140000U AS=16800000000P
+ AD=21875000000P PS=380000U PD=460000U
* device instance $1279 r0 *1 60.405,42.15 nfet_01v8
M$1279 167 2584 2279 167 nfet_01v8 L=150000U W=210000U AS=21875000000P
+ AD=40400000000P PS=460000U PD=560000U
* device instance $1280 r0 *1 60.995,42.15 nfet_01v8
M$1280 167 1580 1039 167 nfet_01v8 L=150000U W=210000U AS=21875000000P
+ AD=40400000000P PS=460000U PD=560000U
* device instance $1281 r0 *1 60.405,42.54 nfet_01v8
M$1281 2584 2279 167 167 nfet_01v8 L=150000U W=210000U AS=40400000000P
+ AD=21875000000P PS=560000U PD=460000U
* device instance $1282 r0 *1 60.995,42.54 nfet_01v8
M$1282 1580 1039 167 167 nfet_01v8 L=150000U W=210000U AS=40400000000P
+ AD=21875000000P PS=560000U PD=460000U
* device instance $1283 r0 *1 60.44,42.94 nfet_01v8
M$1283 86 153 2584 167 nfet_01v8 L=150000U W=140000U AS=21875000000P
+ AD=16800000000P PS=460000U PD=380000U
* device instance $1284 r0 *1 60.96,42.94 nfet_01v8
M$1284 87 153 1580 167 nfet_01v8 L=150000U W=140000U AS=21875000000P
+ AD=16800000000P PS=460000U PD=380000U
* device instance $1285 r0 *1 49.54,37.01 nfet_01v8
M$1285 2326 150 70 167 nfet_01v8 L=150000U W=140000U AS=16800000000P
+ AD=21875000000P PS=380000U PD=460000U
* device instance $1286 r0 *1 50.06,37.01 nfet_01v8
M$1286 948 150 71 167 nfet_01v8 L=150000U W=140000U AS=16800000000P
+ AD=21875000000P PS=380000U PD=460000U
* device instance $1287 r0 *1 49.505,37.41 nfet_01v8
M$1287 167 2669 2326 167 nfet_01v8 L=150000U W=210000U AS=21875000000P
+ AD=40400000000P PS=460000U PD=560000U
* device instance $1288 r0 *1 50.095,37.41 nfet_01v8
M$1288 167 1472 948 167 nfet_01v8 L=150000U W=210000U AS=21875000000P
+ AD=40400000000P PS=460000U PD=560000U
* device instance $1289 r0 *1 49.505,37.8 nfet_01v8
M$1289 2669 2326 167 167 nfet_01v8 L=150000U W=210000U AS=40400000000P
+ AD=21875000000P PS=560000U PD=460000U
* device instance $1290 r0 *1 50.095,37.8 nfet_01v8
M$1290 1472 948 167 167 nfet_01v8 L=150000U W=210000U AS=40400000000P
+ AD=21875000000P PS=560000U PD=460000U
* device instance $1291 r0 *1 49.54,38.2 nfet_01v8
M$1291 69 150 2669 167 nfet_01v8 L=150000U W=140000U AS=21875000000P
+ AD=16800000000P PS=460000U PD=380000U
* device instance $1292 r0 *1 50.06,38.2 nfet_01v8
M$1292 72 150 1472 167 nfet_01v8 L=150000U W=140000U AS=21875000000P
+ AD=16800000000P PS=460000U PD=380000U
* device instance $1293 r0 *1 49.54,38.59 nfet_01v8
M$1293 3606 151 69 167 nfet_01v8 L=150000U W=140000U AS=16800000000P
+ AD=21875000000P PS=380000U PD=460000U
* device instance $1294 r0 *1 50.06,38.59 nfet_01v8
M$1294 4305 151 72 167 nfet_01v8 L=150000U W=140000U AS=16800000000P
+ AD=21875000000P PS=380000U PD=460000U
* device instance $1295 r0 *1 49.505,38.99 nfet_01v8
M$1295 167 2035 3606 167 nfet_01v8 L=150000U W=210000U AS=21875000000P
+ AD=40400000000P PS=460000U PD=560000U
* device instance $1296 r0 *1 50.095,38.99 nfet_01v8
M$1296 167 863 4305 167 nfet_01v8 L=150000U W=210000U AS=21875000000P
+ AD=40400000000P PS=460000U PD=560000U
* device instance $1297 r0 *1 49.505,39.38 nfet_01v8
M$1297 2035 3606 167 167 nfet_01v8 L=150000U W=210000U AS=40400000000P
+ AD=21875000000P PS=560000U PD=460000U
* device instance $1298 r0 *1 50.095,39.38 nfet_01v8
M$1298 863 4305 167 167 nfet_01v8 L=150000U W=210000U AS=40400000000P
+ AD=21875000000P PS=560000U PD=460000U
* device instance $1299 r0 *1 49.54,39.78 nfet_01v8
M$1299 70 151 2035 167 nfet_01v8 L=150000U W=140000U AS=21875000000P
+ AD=16800000000P PS=460000U PD=380000U
* device instance $1300 r0 *1 50.06,39.78 nfet_01v8
M$1300 71 151 863 167 nfet_01v8 L=150000U W=140000U AS=21875000000P
+ AD=16800000000P PS=460000U PD=380000U
* device instance $1301 r0 *1 49.54,40.17 nfet_01v8
M$1301 3603 152 70 167 nfet_01v8 L=150000U W=140000U AS=16800000000P
+ AD=21875000000P PS=380000U PD=460000U
* device instance $1302 r0 *1 50.06,40.17 nfet_01v8
M$1302 992 152 71 167 nfet_01v8 L=150000U W=140000U AS=16800000000P
+ AD=21875000000P PS=380000U PD=460000U
* device instance $1303 r0 *1 49.505,40.57 nfet_01v8
M$1303 167 2662 3603 167 nfet_01v8 L=150000U W=210000U AS=21875000000P
+ AD=40400000000P PS=460000U PD=560000U
* device instance $1304 r0 *1 50.095,40.57 nfet_01v8
M$1304 167 1527 992 167 nfet_01v8 L=150000U W=210000U AS=21875000000P
+ AD=40400000000P PS=460000U PD=560000U
* device instance $1305 r0 *1 49.505,40.96 nfet_01v8
M$1305 2662 3603 167 167 nfet_01v8 L=150000U W=210000U AS=40400000000P
+ AD=21875000000P PS=560000U PD=460000U
* device instance $1306 r0 *1 50.095,40.96 nfet_01v8
M$1306 1527 992 167 167 nfet_01v8 L=150000U W=210000U AS=40400000000P
+ AD=21875000000P PS=560000U PD=460000U
* device instance $1307 r0 *1 49.54,41.36 nfet_01v8
M$1307 69 152 2662 167 nfet_01v8 L=150000U W=140000U AS=21875000000P
+ AD=16800000000P PS=460000U PD=380000U
* device instance $1308 r0 *1 50.06,41.36 nfet_01v8
M$1308 72 152 1527 167 nfet_01v8 L=150000U W=140000U AS=21875000000P
+ AD=16800000000P PS=460000U PD=380000U
* device instance $1309 r0 *1 49.54,41.75 nfet_01v8
M$1309 2324 153 69 167 nfet_01v8 L=150000U W=140000U AS=16800000000P
+ AD=21875000000P PS=380000U PD=460000U
* device instance $1310 r0 *1 50.06,41.75 nfet_01v8
M$1310 985 153 72 167 nfet_01v8 L=150000U W=140000U AS=16800000000P
+ AD=21875000000P PS=380000U PD=460000U
* device instance $1311 r0 *1 49.505,42.15 nfet_01v8
M$1311 167 2665 2324 167 nfet_01v8 L=150000U W=210000U AS=21875000000P
+ AD=40400000000P PS=460000U PD=560000U
* device instance $1312 r0 *1 50.095,42.15 nfet_01v8
M$1312 167 1518 985 167 nfet_01v8 L=150000U W=210000U AS=21875000000P
+ AD=40400000000P PS=460000U PD=560000U
* device instance $1313 r0 *1 49.505,42.54 nfet_01v8
M$1313 2665 2324 167 167 nfet_01v8 L=150000U W=210000U AS=40400000000P
+ AD=21875000000P PS=560000U PD=460000U
* device instance $1314 r0 *1 50.095,42.54 nfet_01v8
M$1314 1518 985 167 167 nfet_01v8 L=150000U W=210000U AS=40400000000P
+ AD=21875000000P PS=560000U PD=460000U
* device instance $1315 r0 *1 49.54,42.94 nfet_01v8
M$1315 70 153 2665 167 nfet_01v8 L=150000U W=140000U AS=21875000000P
+ AD=16800000000P PS=460000U PD=380000U
* device instance $1316 r0 *1 50.06,42.94 nfet_01v8
M$1316 71 153 1518 167 nfet_01v8 L=150000U W=140000U AS=21875000000P
+ AD=16800000000P PS=460000U PD=380000U
* device instance $1317 r0 *1 71.34,60.71 nfet_01v8
M$1317 2428 162 102 167 nfet_01v8 L=150000U W=140000U AS=16800000000P
+ AD=21875000000P PS=380000U PD=460000U
* device instance $1318 r0 *1 71.86,60.71 nfet_01v8
M$1318 1348 162 103 167 nfet_01v8 L=150000U W=140000U AS=16800000000P
+ AD=21875000000P PS=380000U PD=460000U
* device instance $1319 r0 *1 71.305,61.11 nfet_01v8
M$1319 167 2865 2428 167 nfet_01v8 L=150000U W=210000U AS=21875000000P
+ AD=40400000000P PS=460000U PD=560000U
* device instance $1320 r0 *1 71.895,61.11 nfet_01v8
M$1320 167 1936 1348 167 nfet_01v8 L=150000U W=210000U AS=21875000000P
+ AD=40400000000P PS=460000U PD=560000U
* device instance $1321 r0 *1 71.305,61.5 nfet_01v8
M$1321 2865 2428 167 167 nfet_01v8 L=150000U W=210000U AS=40400000000P
+ AD=21875000000P PS=560000U PD=460000U
* device instance $1322 r0 *1 71.895,61.5 nfet_01v8
M$1322 1936 1348 167 167 nfet_01v8 L=150000U W=210000U AS=40400000000P
+ AD=21875000000P PS=560000U PD=460000U
* device instance $1323 r0 *1 71.34,61.9 nfet_01v8
M$1323 101 162 2865 167 nfet_01v8 L=150000U W=140000U AS=21875000000P
+ AD=16800000000P PS=460000U PD=380000U
* device instance $1324 r0 *1 71.86,61.9 nfet_01v8
M$1324 104 162 1936 167 nfet_01v8 L=150000U W=140000U AS=21875000000P
+ AD=16800000000P PS=460000U PD=380000U
* device instance $1325 r0 *1 71.34,62.29 nfet_01v8
M$1325 3158 163 101 167 nfet_01v8 L=150000U W=140000U AS=16800000000P
+ AD=21875000000P PS=380000U PD=460000U
* device instance $1326 r0 *1 71.86,62.29 nfet_01v8
M$1326 4477 163 104 167 nfet_01v8 L=150000U W=140000U AS=16800000000P
+ AD=21875000000P PS=380000U PD=460000U
* device instance $1327 r0 *1 71.305,62.69 nfet_01v8
M$1327 167 2799 3158 167 nfet_01v8 L=150000U W=210000U AS=21875000000P
+ AD=40400000000P PS=460000U PD=560000U
* device instance $1328 r0 *1 71.895,62.69 nfet_01v8
M$1328 167 1562 4477 167 nfet_01v8 L=150000U W=210000U AS=21875000000P
+ AD=40400000000P PS=460000U PD=560000U
* device instance $1329 r0 *1 71.305,63.08 nfet_01v8
M$1329 2799 3158 167 167 nfet_01v8 L=150000U W=210000U AS=40400000000P
+ AD=21875000000P PS=560000U PD=460000U
* device instance $1330 r0 *1 71.895,63.08 nfet_01v8
M$1330 1562 4477 167 167 nfet_01v8 L=150000U W=210000U AS=40400000000P
+ AD=21875000000P PS=560000U PD=460000U
* device instance $1331 r0 *1 71.34,63.48 nfet_01v8
M$1331 102 163 2799 167 nfet_01v8 L=150000U W=140000U AS=21875000000P
+ AD=16800000000P PS=460000U PD=380000U
* device instance $1332 r0 *1 71.86,63.48 nfet_01v8
M$1332 103 163 1562 167 nfet_01v8 L=150000U W=140000U AS=21875000000P
+ AD=16800000000P PS=460000U PD=380000U
* device instance $1333 r0 *1 71.34,63.87 nfet_01v8
M$1333 2533 164 102 167 nfet_01v8 L=150000U W=140000U AS=16800000000P
+ AD=21875000000P PS=380000U PD=460000U
* device instance $1334 r0 *1 71.86,63.87 nfet_01v8
M$1334 648 164 103 167 nfet_01v8 L=150000U W=140000U AS=16800000000P
+ AD=21875000000P PS=380000U PD=460000U
* device instance $1335 r0 *1 71.305,64.27 nfet_01v8
M$1335 167 3102 2533 167 nfet_01v8 L=150000U W=210000U AS=21875000000P
+ AD=40400000000P PS=460000U PD=560000U
* device instance $1336 r0 *1 71.895,64.27 nfet_01v8
M$1336 167 814 648 167 nfet_01v8 L=150000U W=210000U AS=21875000000P
+ AD=40400000000P PS=460000U PD=560000U
* device instance $1337 r0 *1 71.305,64.66 nfet_01v8
M$1337 3102 2533 167 167 nfet_01v8 L=150000U W=210000U AS=40400000000P
+ AD=21875000000P PS=560000U PD=460000U
* device instance $1338 r0 *1 71.895,64.66 nfet_01v8
M$1338 814 648 167 167 nfet_01v8 L=150000U W=210000U AS=40400000000P
+ AD=21875000000P PS=560000U PD=460000U
* device instance $1339 r0 *1 71.34,65.06 nfet_01v8
M$1339 101 164 3102 167 nfet_01v8 L=150000U W=140000U AS=21875000000P
+ AD=16800000000P PS=460000U PD=380000U
* device instance $1340 r0 *1 71.86,65.06 nfet_01v8
M$1340 104 164 814 167 nfet_01v8 L=150000U W=140000U AS=21875000000P
+ AD=16800000000P PS=460000U PD=380000U
* device instance $1341 r0 *1 71.34,65.45 nfet_01v8
M$1341 2503 165 101 167 nfet_01v8 L=150000U W=140000U AS=16800000000P
+ AD=21875000000P PS=380000U PD=460000U
* device instance $1342 r0 *1 71.86,65.45 nfet_01v8
M$1342 1055 165 104 167 nfet_01v8 L=150000U W=140000U AS=16800000000P
+ AD=21875000000P PS=380000U PD=460000U
* device instance $1343 r0 *1 71.305,65.85 nfet_01v8
M$1343 167 3034 2503 167 nfet_01v8 L=150000U W=210000U AS=21875000000P
+ AD=40400000000P PS=460000U PD=560000U
* device instance $1344 r0 *1 71.895,65.85 nfet_01v8
M$1344 167 1599 1055 167 nfet_01v8 L=150000U W=210000U AS=21875000000P
+ AD=40400000000P PS=460000U PD=560000U
* device instance $1345 r0 *1 71.305,66.24 nfet_01v8
M$1345 3034 2503 167 167 nfet_01v8 L=150000U W=210000U AS=40400000000P
+ AD=21875000000P PS=560000U PD=460000U
* device instance $1346 r0 *1 71.895,66.24 nfet_01v8
M$1346 1599 1055 167 167 nfet_01v8 L=150000U W=210000U AS=40400000000P
+ AD=21875000000P PS=560000U PD=460000U
* device instance $1347 r0 *1 71.34,66.64 nfet_01v8
M$1347 102 165 3034 167 nfet_01v8 L=150000U W=140000U AS=21875000000P
+ AD=16800000000P PS=460000U PD=380000U
* device instance $1348 r0 *1 71.86,66.64 nfet_01v8
M$1348 103 165 1599 167 nfet_01v8 L=150000U W=140000U AS=21875000000P
+ AD=16800000000P PS=460000U PD=380000U
* device instance $1349 r0 *1 38.64,37.01 nfet_01v8
M$1349 2351 150 54 167 nfet_01v8 L=150000U W=140000U AS=16800000000P
+ AD=21875000000P PS=380000U PD=460000U
* device instance $1350 r0 *1 39.16,37.01 nfet_01v8
M$1350 1240 150 55 167 nfet_01v8 L=150000U W=140000U AS=16800000000P
+ AD=21875000000P PS=380000U PD=460000U
* device instance $1351 r0 *1 38.605,37.41 nfet_01v8
M$1351 167 2731 2351 167 nfet_01v8 L=150000U W=210000U AS=21875000000P
+ AD=40400000000P PS=460000U PD=560000U
* device instance $1352 r0 *1 39.195,37.41 nfet_01v8
M$1352 167 1812 1240 167 nfet_01v8 L=150000U W=210000U AS=21875000000P
+ AD=40400000000P PS=460000U PD=560000U
* device instance $1353 r0 *1 38.605,37.8 nfet_01v8
M$1353 2731 2351 167 167 nfet_01v8 L=150000U W=210000U AS=40400000000P
+ AD=21875000000P PS=560000U PD=460000U
* device instance $1354 r0 *1 39.195,37.8 nfet_01v8
M$1354 1812 1240 167 167 nfet_01v8 L=150000U W=210000U AS=40400000000P
+ AD=21875000000P PS=560000U PD=460000U
* device instance $1355 r0 *1 38.64,38.2 nfet_01v8
M$1355 53 150 2731 167 nfet_01v8 L=150000U W=140000U AS=21875000000P
+ AD=16800000000P PS=460000U PD=380000U
* device instance $1356 r0 *1 39.16,38.2 nfet_01v8
M$1356 56 150 1812 167 nfet_01v8 L=150000U W=140000U AS=21875000000P
+ AD=16800000000P PS=460000U PD=380000U
* device instance $1357 r0 *1 38.64,38.59 nfet_01v8
M$1357 3674 151 53 167 nfet_01v8 L=150000U W=140000U AS=16800000000P
+ AD=21875000000P PS=380000U PD=460000U
* device instance $1358 r0 *1 39.16,38.59 nfet_01v8
M$1358 4427 151 56 167 nfet_01v8 L=150000U W=140000U AS=16800000000P
+ AD=21875000000P PS=380000U PD=460000U
* device instance $1359 r0 *1 38.605,38.99 nfet_01v8
M$1359 167 2695 3674 167 nfet_01v8 L=150000U W=210000U AS=21875000000P
+ AD=40400000000P PS=460000U PD=560000U
* device instance $1360 r0 *1 39.195,38.99 nfet_01v8
M$1360 167 722 4427 167 nfet_01v8 L=150000U W=210000U AS=21875000000P
+ AD=40400000000P PS=460000U PD=560000U
* device instance $1361 r0 *1 38.605,39.38 nfet_01v8
M$1361 2695 3674 167 167 nfet_01v8 L=150000U W=210000U AS=40400000000P
+ AD=21875000000P PS=560000U PD=460000U
* device instance $1362 r0 *1 39.195,39.38 nfet_01v8
M$1362 722 4427 167 167 nfet_01v8 L=150000U W=210000U AS=40400000000P
+ AD=21875000000P PS=560000U PD=460000U
* device instance $1363 r0 *1 38.64,39.78 nfet_01v8
M$1363 54 151 2695 167 nfet_01v8 L=150000U W=140000U AS=21875000000P
+ AD=16800000000P PS=460000U PD=380000U
* device instance $1364 r0 *1 39.16,39.78 nfet_01v8
M$1364 55 151 722 167 nfet_01v8 L=150000U W=140000U AS=21875000000P
+ AD=16800000000P PS=460000U PD=380000U
* device instance $1365 r0 *1 38.64,40.17 nfet_01v8
M$1365 2333 152 54 167 nfet_01v8 L=150000U W=140000U AS=16800000000P
+ AD=21875000000P PS=380000U PD=460000U
* device instance $1366 r0 *1 39.16,40.17 nfet_01v8
M$1366 596 152 55 167 nfet_01v8 L=150000U W=140000U AS=16800000000P
+ AD=21875000000P PS=380000U PD=460000U
* device instance $1367 r0 *1 38.605,40.57 nfet_01v8
M$1367 167 2684 2333 167 nfet_01v8 L=150000U W=210000U AS=21875000000P
+ AD=40400000000P PS=460000U PD=560000U
* device instance $1368 r0 *1 39.195,40.57 nfet_01v8
M$1368 167 713 596 167 nfet_01v8 L=150000U W=210000U AS=21875000000P
+ AD=40400000000P PS=460000U PD=560000U
* device instance $1369 r0 *1 38.605,40.96 nfet_01v8
M$1369 2684 2333 167 167 nfet_01v8 L=150000U W=210000U AS=40400000000P
+ AD=21875000000P PS=560000U PD=460000U
* device instance $1370 r0 *1 39.195,40.96 nfet_01v8
M$1370 713 596 167 167 nfet_01v8 L=150000U W=210000U AS=40400000000P
+ AD=21875000000P PS=560000U PD=460000U
* device instance $1371 r0 *1 38.64,41.36 nfet_01v8
M$1371 53 152 2684 167 nfet_01v8 L=150000U W=140000U AS=21875000000P
+ AD=16800000000P PS=460000U PD=380000U
* device instance $1372 r0 *1 39.16,41.36 nfet_01v8
M$1372 56 152 713 167 nfet_01v8 L=150000U W=140000U AS=21875000000P
+ AD=16800000000P PS=460000U PD=380000U
* device instance $1373 r0 *1 38.64,41.75 nfet_01v8
M$1373 3673 153 53 167 nfet_01v8 L=150000U W=140000U AS=16800000000P
+ AD=21875000000P PS=380000U PD=460000U
* device instance $1374 r0 *1 39.16,41.75 nfet_01v8
M$1374 1237 153 56 167 nfet_01v8 L=150000U W=140000U AS=16800000000P
+ AD=21875000000P PS=380000U PD=460000U
* device instance $1375 r0 *1 38.605,42.15 nfet_01v8
M$1375 167 2693 3673 167 nfet_01v8 L=150000U W=210000U AS=21875000000P
+ AD=40400000000P PS=460000U PD=560000U
* device instance $1376 r0 *1 39.195,42.15 nfet_01v8
M$1376 167 1809 1237 167 nfet_01v8 L=150000U W=210000U AS=21875000000P
+ AD=40400000000P PS=460000U PD=560000U
* device instance $1377 r0 *1 38.605,42.54 nfet_01v8
M$1377 2693 3673 167 167 nfet_01v8 L=150000U W=210000U AS=40400000000P
+ AD=21875000000P PS=560000U PD=460000U
* device instance $1378 r0 *1 39.195,42.54 nfet_01v8
M$1378 1809 1237 167 167 nfet_01v8 L=150000U W=210000U AS=40400000000P
+ AD=21875000000P PS=560000U PD=460000U
* device instance $1379 r0 *1 38.64,42.94 nfet_01v8
M$1379 54 153 2693 167 nfet_01v8 L=150000U W=140000U AS=21875000000P
+ AD=16800000000P PS=460000U PD=380000U
* device instance $1380 r0 *1 39.16,42.94 nfet_01v8
M$1380 55 153 1809 167 nfet_01v8 L=150000U W=140000U AS=21875000000P
+ AD=16800000000P PS=460000U PD=380000U
* device instance $1381 r0 *1 27.74,37.01 nfet_01v8
M$1381 2339 150 38 167 nfet_01v8 L=150000U W=140000U AS=16800000000P
+ AD=21875000000P PS=380000U PD=460000U
* device instance $1382 r0 *1 28.26,37.01 nfet_01v8
M$1382 1253 150 39 167 nfet_01v8 L=150000U W=140000U AS=16800000000P
+ AD=21875000000P PS=380000U PD=460000U
* device instance $1383 r0 *1 27.705,37.41 nfet_01v8
M$1383 167 2703 2339 167 nfet_01v8 L=150000U W=210000U AS=21875000000P
+ AD=40400000000P PS=460000U PD=560000U
* device instance $1384 r0 *1 28.295,37.41 nfet_01v8
M$1384 167 1826 1253 167 nfet_01v8 L=150000U W=210000U AS=21875000000P
+ AD=40400000000P PS=460000U PD=560000U
* device instance $1385 r0 *1 27.705,37.8 nfet_01v8
M$1385 2703 2339 167 167 nfet_01v8 L=150000U W=210000U AS=40400000000P
+ AD=21875000000P PS=560000U PD=460000U
* device instance $1386 r0 *1 28.295,37.8 nfet_01v8
M$1386 1826 1253 167 167 nfet_01v8 L=150000U W=210000U AS=40400000000P
+ AD=21875000000P PS=560000U PD=460000U
* device instance $1387 r0 *1 27.74,38.2 nfet_01v8
M$1387 37 150 2703 167 nfet_01v8 L=150000U W=140000U AS=21875000000P
+ AD=16800000000P PS=460000U PD=380000U
* device instance $1388 r0 *1 28.26,38.2 nfet_01v8
M$1388 40 150 1826 167 nfet_01v8 L=150000U W=140000U AS=21875000000P
+ AD=16800000000P PS=460000U PD=380000U
* device instance $1389 r0 *1 27.74,38.59 nfet_01v8
M$1389 3630 151 37 167 nfet_01v8 L=150000U W=140000U AS=16800000000P
+ AD=21875000000P PS=380000U PD=460000U
* device instance $1390 r0 *1 28.26,38.59 nfet_01v8
M$1390 4422 151 40 167 nfet_01v8 L=150000U W=140000U AS=16800000000P
+ AD=21875000000P PS=380000U PD=460000U
* device instance $1391 r0 *1 27.705,38.99 nfet_01v8
M$1391 167 2057 3630 167 nfet_01v8 L=150000U W=210000U AS=21875000000P
+ AD=40400000000P PS=460000U PD=560000U
* device instance $1392 r0 *1 28.295,38.99 nfet_01v8
M$1392 167 1827 4422 167 nfet_01v8 L=150000U W=210000U AS=21875000000P
+ AD=40400000000P PS=460000U PD=560000U
* device instance $1393 r0 *1 27.705,39.38 nfet_01v8
M$1393 2057 3630 167 167 nfet_01v8 L=150000U W=210000U AS=40400000000P
+ AD=21875000000P PS=560000U PD=460000U
* device instance $1394 r0 *1 28.295,39.38 nfet_01v8
M$1394 1827 4422 167 167 nfet_01v8 L=150000U W=210000U AS=40400000000P
+ AD=21875000000P PS=560000U PD=460000U
* device instance $1395 r0 *1 27.74,39.78 nfet_01v8
M$1395 38 151 2057 167 nfet_01v8 L=150000U W=140000U AS=21875000000P
+ AD=16800000000P PS=460000U PD=380000U
* device instance $1396 r0 *1 28.26,39.78 nfet_01v8
M$1396 39 151 1827 167 nfet_01v8 L=150000U W=140000U AS=21875000000P
+ AD=16800000000P PS=460000U PD=380000U
* device instance $1397 r0 *1 27.74,40.17 nfet_01v8
M$1397 2123 152 38 167 nfet_01v8 L=150000U W=140000U AS=16800000000P
+ AD=21875000000P PS=380000U PD=460000U
* device instance $1398 r0 *1 28.26,40.17 nfet_01v8
M$1398 601 152 39 167 nfet_01v8 L=150000U W=140000U AS=16800000000P
+ AD=21875000000P PS=380000U PD=460000U
* device instance $1399 r0 *1 27.705,40.57 nfet_01v8
M$1399 167 2256 2123 167 nfet_01v8 L=150000U W=210000U AS=21875000000P
+ AD=40400000000P PS=460000U PD=560000U
* device instance $1400 r0 *1 28.295,40.57 nfet_01v8
M$1400 167 723 601 167 nfet_01v8 L=150000U W=210000U AS=21875000000P
+ AD=40400000000P PS=460000U PD=560000U
* device instance $1401 r0 *1 27.705,40.96 nfet_01v8
M$1401 2256 2123 167 167 nfet_01v8 L=150000U W=210000U AS=40400000000P
+ AD=21875000000P PS=560000U PD=460000U
* device instance $1402 r0 *1 28.295,40.96 nfet_01v8
M$1402 723 601 167 167 nfet_01v8 L=150000U W=210000U AS=40400000000P
+ AD=21875000000P PS=560000U PD=460000U
* device instance $1403 r0 *1 27.74,41.36 nfet_01v8
M$1403 37 152 2256 167 nfet_01v8 L=150000U W=140000U AS=21875000000P
+ AD=16800000000P PS=460000U PD=380000U
* device instance $1404 r0 *1 28.26,41.36 nfet_01v8
M$1404 40 152 723 167 nfet_01v8 L=150000U W=140000U AS=21875000000P
+ AD=16800000000P PS=460000U PD=380000U
* device instance $1405 r0 *1 27.74,41.75 nfet_01v8
M$1405 2338 153 37 167 nfet_01v8 L=150000U W=140000U AS=16800000000P
+ AD=21875000000P PS=380000U PD=460000U
* device instance $1406 r0 *1 28.26,41.75 nfet_01v8
M$1406 1259 153 40 167 nfet_01v8 L=150000U W=140000U AS=16800000000P
+ AD=21875000000P PS=380000U PD=460000U
* device instance $1407 r0 *1 27.705,42.15 nfet_01v8
M$1407 167 2700 2338 167 nfet_01v8 L=150000U W=210000U AS=21875000000P
+ AD=40400000000P PS=460000U PD=560000U
* device instance $1408 r0 *1 28.295,42.15 nfet_01v8
M$1408 167 1835 1259 167 nfet_01v8 L=150000U W=210000U AS=21875000000P
+ AD=40400000000P PS=460000U PD=560000U
* device instance $1409 r0 *1 27.705,42.54 nfet_01v8
M$1409 2700 2338 167 167 nfet_01v8 L=150000U W=210000U AS=40400000000P
+ AD=21875000000P PS=560000U PD=460000U
* device instance $1410 r0 *1 28.295,42.54 nfet_01v8
M$1410 1835 1259 167 167 nfet_01v8 L=150000U W=210000U AS=40400000000P
+ AD=21875000000P PS=560000U PD=460000U
* device instance $1411 r0 *1 27.74,42.94 nfet_01v8
M$1411 38 153 2700 167 nfet_01v8 L=150000U W=140000U AS=21875000000P
+ AD=16800000000P PS=460000U PD=380000U
* device instance $1412 r0 *1 28.26,42.94 nfet_01v8
M$1412 39 153 1835 167 nfet_01v8 L=150000U W=140000U AS=21875000000P
+ AD=16800000000P PS=460000U PD=380000U
* device instance $1413 r0 *1 16.84,37.01 nfet_01v8
M$1413 2541 150 22 167 nfet_01v8 L=150000U W=140000U AS=16800000000P
+ AD=21875000000P PS=380000U PD=460000U
* device instance $1414 r0 *1 17.36,37.01 nfet_01v8
M$1414 1217 150 23 167 nfet_01v8 L=150000U W=140000U AS=16800000000P
+ AD=21875000000P PS=380000U PD=460000U
* device instance $1415 r0 *1 16.805,37.41 nfet_01v8
M$1415 167 3116 2541 167 nfet_01v8 L=150000U W=210000U AS=21875000000P
+ AD=40400000000P PS=460000U PD=560000U
* device instance $1416 r0 *1 17.395,37.41 nfet_01v8
M$1416 167 1788 1217 167 nfet_01v8 L=150000U W=210000U AS=21875000000P
+ AD=40400000000P PS=460000U PD=560000U
* device instance $1417 r0 *1 16.805,37.8 nfet_01v8
M$1417 3116 2541 167 167 nfet_01v8 L=150000U W=210000U AS=40400000000P
+ AD=21875000000P PS=560000U PD=460000U
* device instance $1418 r0 *1 17.395,37.8 nfet_01v8
M$1418 1788 1217 167 167 nfet_01v8 L=150000U W=210000U AS=40400000000P
+ AD=21875000000P PS=560000U PD=460000U
* device instance $1419 r0 *1 16.84,38.2 nfet_01v8
M$1419 21 150 3116 167 nfet_01v8 L=150000U W=140000U AS=21875000000P
+ AD=16800000000P PS=460000U PD=380000U
* device instance $1420 r0 *1 17.36,38.2 nfet_01v8
M$1420 24 150 1788 167 nfet_01v8 L=150000U W=140000U AS=21875000000P
+ AD=16800000000P PS=460000U PD=380000U
* device instance $1421 r0 *1 16.84,38.59 nfet_01v8
M$1421 3636 151 21 167 nfet_01v8 L=150000U W=140000U AS=16800000000P
+ AD=21875000000P PS=380000U PD=460000U
* device instance $1422 r0 *1 17.36,38.59 nfet_01v8
M$1422 4409 151 24 167 nfet_01v8 L=150000U W=140000U AS=16800000000P
+ AD=21875000000P PS=380000U PD=460000U
* device instance $1423 r0 *1 16.805,38.99 nfet_01v8
M$1423 167 3109 3636 167 nfet_01v8 L=150000U W=210000U AS=21875000000P
+ AD=40400000000P PS=460000U PD=560000U
* device instance $1424 r0 *1 17.395,38.99 nfet_01v8
M$1424 167 725 4409 167 nfet_01v8 L=150000U W=210000U AS=21875000000P
+ AD=40400000000P PS=460000U PD=560000U
* device instance $1425 r0 *1 16.805,39.38 nfet_01v8
M$1425 3109 3636 167 167 nfet_01v8 L=150000U W=210000U AS=40400000000P
+ AD=21875000000P PS=560000U PD=460000U
* device instance $1426 r0 *1 17.395,39.38 nfet_01v8
M$1426 725 4409 167 167 nfet_01v8 L=150000U W=210000U AS=40400000000P
+ AD=21875000000P PS=560000U PD=460000U
* device instance $1427 r0 *1 16.84,39.78 nfet_01v8
M$1427 22 151 3109 167 nfet_01v8 L=150000U W=140000U AS=21875000000P
+ AD=16800000000P PS=460000U PD=380000U
* device instance $1428 r0 *1 17.36,39.78 nfet_01v8
M$1428 23 151 725 167 nfet_01v8 L=150000U W=140000U AS=21875000000P
+ AD=16800000000P PS=460000U PD=380000U
* device instance $1429 r0 *1 16.84,40.17 nfet_01v8
M$1429 3736 152 22 167 nfet_01v8 L=150000U W=140000U AS=16800000000P
+ AD=21875000000P PS=380000U PD=460000U
* device instance $1430 r0 *1 17.36,40.17 nfet_01v8
M$1430 609 152 23 167 nfet_01v8 L=150000U W=140000U AS=16800000000P
+ AD=21875000000P PS=380000U PD=460000U
* device instance $1431 r0 *1 16.805,40.57 nfet_01v8
M$1431 167 3060 3736 167 nfet_01v8 L=150000U W=210000U AS=21875000000P
+ AD=40400000000P PS=460000U PD=560000U
* device instance $1432 r0 *1 17.395,40.57 nfet_01v8
M$1432 167 736 609 167 nfet_01v8 L=150000U W=210000U AS=21875000000P
+ AD=40400000000P PS=460000U PD=560000U
* device instance $1433 r0 *1 16.805,40.96 nfet_01v8
M$1433 3060 3736 167 167 nfet_01v8 L=150000U W=210000U AS=40400000000P
+ AD=21875000000P PS=560000U PD=460000U
* device instance $1434 r0 *1 17.395,40.96 nfet_01v8
M$1434 736 609 167 167 nfet_01v8 L=150000U W=210000U AS=40400000000P
+ AD=21875000000P PS=560000U PD=460000U
* device instance $1435 r0 *1 16.84,41.36 nfet_01v8
M$1435 21 152 3060 167 nfet_01v8 L=150000U W=140000U AS=21875000000P
+ AD=16800000000P PS=460000U PD=380000U
* device instance $1436 r0 *1 17.36,41.36 nfet_01v8
M$1436 24 152 736 167 nfet_01v8 L=150000U W=140000U AS=21875000000P
+ AD=16800000000P PS=460000U PD=380000U
* device instance $1437 r0 *1 16.84,41.75 nfet_01v8
M$1437 2534 153 21 167 nfet_01v8 L=150000U W=140000U AS=16800000000P
+ AD=21875000000P PS=380000U PD=460000U
* device instance $1438 r0 *1 17.36,41.75 nfet_01v8
M$1438 1368 153 24 167 nfet_01v8 L=150000U W=140000U AS=16800000000P
+ AD=21875000000P PS=380000U PD=460000U
* device instance $1439 r0 *1 16.805,42.15 nfet_01v8
M$1439 167 3104 2534 167 nfet_01v8 L=150000U W=210000U AS=21875000000P
+ AD=40400000000P PS=460000U PD=560000U
* device instance $1440 r0 *1 17.395,42.15 nfet_01v8
M$1440 167 1959 1368 167 nfet_01v8 L=150000U W=210000U AS=21875000000P
+ AD=40400000000P PS=460000U PD=560000U
* device instance $1441 r0 *1 16.805,42.54 nfet_01v8
M$1441 3104 2534 167 167 nfet_01v8 L=150000U W=210000U AS=40400000000P
+ AD=21875000000P PS=560000U PD=460000U
* device instance $1442 r0 *1 17.395,42.54 nfet_01v8
M$1442 1959 1368 167 167 nfet_01v8 L=150000U W=210000U AS=40400000000P
+ AD=21875000000P PS=560000U PD=460000U
* device instance $1443 r0 *1 16.84,42.94 nfet_01v8
M$1443 22 153 3104 167 nfet_01v8 L=150000U W=140000U AS=21875000000P
+ AD=16800000000P PS=460000U PD=380000U
* device instance $1444 r0 *1 17.36,42.94 nfet_01v8
M$1444 23 153 1959 167 nfet_01v8 L=150000U W=140000U AS=21875000000P
+ AD=16800000000P PS=460000U PD=380000U
* device instance $1445 r0 *1 5.94,37.01 nfet_01v8
M$1445 2519 150 6 167 nfet_01v8 L=150000U W=140000U AS=16800000000P
+ AD=21875000000P PS=380000U PD=460000U
* device instance $1446 r0 *1 6.46,37.01 nfet_01v8
M$1446 1305 150 7 167 nfet_01v8 L=150000U W=140000U AS=16800000000P
+ AD=21875000000P PS=380000U PD=460000U
* device instance $1447 r0 *1 5.905,37.41 nfet_01v8
M$1447 167 3072 2519 167 nfet_01v8 L=150000U W=210000U AS=21875000000P
+ AD=40400000000P PS=460000U PD=560000U
* device instance $1448 r0 *1 6.495,37.41 nfet_01v8
M$1448 167 1883 1305 167 nfet_01v8 L=150000U W=210000U AS=21875000000P
+ AD=40400000000P PS=460000U PD=560000U
* device instance $1449 r0 *1 5.905,37.8 nfet_01v8
M$1449 3072 2519 167 167 nfet_01v8 L=150000U W=210000U AS=40400000000P
+ AD=21875000000P PS=560000U PD=460000U
* device instance $1450 r0 *1 6.495,37.8 nfet_01v8
M$1450 1883 1305 167 167 nfet_01v8 L=150000U W=210000U AS=40400000000P
+ AD=21875000000P PS=560000U PD=460000U
* device instance $1451 r0 *1 5.94,38.2 nfet_01v8
M$1451 5 150 3072 167 nfet_01v8 L=150000U W=140000U AS=21875000000P
+ AD=16800000000P PS=460000U PD=380000U
* device instance $1452 r0 *1 6.46,38.2 nfet_01v8
M$1452 8 150 1883 167 nfet_01v8 L=150000U W=140000U AS=21875000000P
+ AD=16800000000P PS=460000U PD=380000U
* device instance $1453 r0 *1 5.94,38.59 nfet_01v8
M$1453 3730 151 5 167 nfet_01v8 L=150000U W=140000U AS=16800000000P
+ AD=21875000000P PS=380000U PD=460000U
* device instance $1454 r0 *1 6.46,38.59 nfet_01v8
M$1454 4456 151 8 167 nfet_01v8 L=150000U W=140000U AS=16800000000P
+ AD=21875000000P PS=380000U PD=460000U
* device instance $1455 r0 *1 5.905,38.99 nfet_01v8
M$1455 167 2042 3730 167 nfet_01v8 L=150000U W=210000U AS=21875000000P
+ AD=40400000000P PS=460000U PD=560000U
* device instance $1456 r0 *1 6.495,38.99 nfet_01v8
M$1456 167 681 4456 167 nfet_01v8 L=150000U W=210000U AS=21875000000P
+ AD=40400000000P PS=460000U PD=560000U
* device instance $1457 r0 *1 5.905,39.38 nfet_01v8
M$1457 2042 3730 167 167 nfet_01v8 L=150000U W=210000U AS=40400000000P
+ AD=21875000000P PS=560000U PD=460000U
* device instance $1458 r0 *1 6.495,39.38 nfet_01v8
M$1458 681 4456 167 167 nfet_01v8 L=150000U W=210000U AS=40400000000P
+ AD=21875000000P PS=560000U PD=460000U
* device instance $1459 r0 *1 5.94,39.78 nfet_01v8
M$1459 6 151 2042 167 nfet_01v8 L=150000U W=140000U AS=21875000000P
+ AD=16800000000P PS=460000U PD=380000U
* device instance $1460 r0 *1 6.46,39.78 nfet_01v8
M$1460 7 151 681 167 nfet_01v8 L=150000U W=140000U AS=21875000000P
+ AD=16800000000P PS=460000U PD=380000U
* device instance $1461 r0 *1 5.94,40.17 nfet_01v8
M$1461 2523 152 6 167 nfet_01v8 L=150000U W=140000U AS=16800000000P
+ AD=21875000000P PS=380000U PD=460000U
* device instance $1462 r0 *1 6.46,40.17 nfet_01v8
M$1462 1332 152 7 167 nfet_01v8 L=150000U W=140000U AS=16800000000P
+ AD=21875000000P PS=380000U PD=460000U
* device instance $1463 r0 *1 5.905,40.57 nfet_01v8
M$1463 167 3081 2523 167 nfet_01v8 L=150000U W=210000U AS=21875000000P
+ AD=40400000000P PS=460000U PD=560000U
* device instance $1464 r0 *1 6.495,40.57 nfet_01v8
M$1464 167 1914 1332 167 nfet_01v8 L=150000U W=210000U AS=21875000000P
+ AD=40400000000P PS=460000U PD=560000U
* device instance $1465 r0 *1 5.905,40.96 nfet_01v8
M$1465 3081 2523 167 167 nfet_01v8 L=150000U W=210000U AS=40400000000P
+ AD=21875000000P PS=560000U PD=460000U
* device instance $1466 r0 *1 6.495,40.96 nfet_01v8
M$1466 1914 1332 167 167 nfet_01v8 L=150000U W=210000U AS=40400000000P
+ AD=21875000000P PS=560000U PD=460000U
* device instance $1467 r0 *1 5.94,41.36 nfet_01v8
M$1467 5 152 3081 167 nfet_01v8 L=150000U W=140000U AS=21875000000P
+ AD=16800000000P PS=460000U PD=380000U
* device instance $1468 r0 *1 6.46,41.36 nfet_01v8
M$1468 8 152 1914 167 nfet_01v8 L=150000U W=140000U AS=21875000000P
+ AD=16800000000P PS=460000U PD=380000U
* device instance $1469 r0 *1 5.94,41.75 nfet_01v8
M$1469 3729 153 5 167 nfet_01v8 L=150000U W=140000U AS=16800000000P
+ AD=21875000000P PS=380000U PD=460000U
* device instance $1470 r0 *1 6.46,41.75 nfet_01v8
M$1470 1316 153 8 167 nfet_01v8 L=150000U W=140000U AS=16800000000P
+ AD=21875000000P PS=380000U PD=460000U
* device instance $1471 r0 *1 5.905,42.15 nfet_01v8
M$1471 167 3074 3729 167 nfet_01v8 L=150000U W=210000U AS=21875000000P
+ AD=40400000000P PS=460000U PD=560000U
* device instance $1472 r0 *1 6.495,42.15 nfet_01v8
M$1472 167 1896 1316 167 nfet_01v8 L=150000U W=210000U AS=21875000000P
+ AD=40400000000P PS=460000U PD=560000U
* device instance $1473 r0 *1 5.905,42.54 nfet_01v8
M$1473 3074 3729 167 167 nfet_01v8 L=150000U W=210000U AS=40400000000P
+ AD=21875000000P PS=560000U PD=460000U
* device instance $1474 r0 *1 6.495,42.54 nfet_01v8
M$1474 1896 1316 167 167 nfet_01v8 L=150000U W=210000U AS=40400000000P
+ AD=21875000000P PS=560000U PD=460000U
* device instance $1475 r0 *1 5.94,42.94 nfet_01v8
M$1475 6 153 3074 167 nfet_01v8 L=150000U W=140000U AS=21875000000P
+ AD=16800000000P PS=460000U PD=380000U
* device instance $1476 r0 *1 6.46,42.94 nfet_01v8
M$1476 7 153 1896 167 nfet_01v8 L=150000U W=140000U AS=21875000000P
+ AD=16800000000P PS=460000U PD=380000U
* device instance $1477 r0 *1 38.64,60.71 nfet_01v8
M$1477 3521 162 54 167 nfet_01v8 L=150000U W=140000U AS=16800000000P
+ AD=21875000000P PS=380000U PD=460000U
* device instance $1478 r0 *1 39.16,60.71 nfet_01v8
M$1478 876 162 55 167 nfet_01v8 L=150000U W=140000U AS=16800000000P
+ AD=21875000000P PS=380000U PD=460000U
* device instance $1479 r0 *1 38.605,61.11 nfet_01v8
M$1479 167 3004 3521 167 nfet_01v8 L=150000U W=210000U AS=21875000000P
+ AD=40400000000P PS=460000U PD=560000U
* device instance $1480 r0 *1 39.195,61.11 nfet_01v8
M$1480 167 1385 876 167 nfet_01v8 L=150000U W=210000U AS=21875000000P
+ AD=40400000000P PS=460000U PD=560000U
* device instance $1481 r0 *1 38.605,61.5 nfet_01v8
M$1481 3004 3521 167 167 nfet_01v8 L=150000U W=210000U AS=40400000000P
+ AD=21875000000P PS=560000U PD=460000U
* device instance $1482 r0 *1 39.195,61.5 nfet_01v8
M$1482 1385 876 167 167 nfet_01v8 L=150000U W=210000U AS=40400000000P
+ AD=21875000000P PS=560000U PD=460000U
* device instance $1483 r0 *1 38.64,61.9 nfet_01v8
M$1483 53 162 3004 167 nfet_01v8 L=150000U W=140000U AS=21875000000P
+ AD=16800000000P PS=460000U PD=380000U
* device instance $1484 r0 *1 39.16,61.9 nfet_01v8
M$1484 56 162 1385 167 nfet_01v8 L=150000U W=140000U AS=21875000000P
+ AD=16800000000P PS=460000U PD=380000U
* device instance $1485 r0 *1 38.64,62.29 nfet_01v8
M$1485 3497 163 53 167 nfet_01v8 L=150000U W=140000U AS=16800000000P
+ AD=21875000000P PS=380000U PD=460000U
* device instance $1486 r0 *1 39.16,62.29 nfet_01v8
M$1486 4410 163 56 167 nfet_01v8 L=150000U W=140000U AS=16800000000P
+ AD=21875000000P PS=380000U PD=460000U
* device instance $1487 r0 *1 38.605,62.69 nfet_01v8
M$1487 167 2552 3497 167 nfet_01v8 L=150000U W=210000U AS=21875000000P
+ AD=40400000000P PS=460000U PD=560000U
* device instance $1488 r0 *1 39.195,62.69 nfet_01v8
M$1488 167 1783 4410 167 nfet_01v8 L=150000U W=210000U AS=21875000000P
+ AD=40400000000P PS=460000U PD=560000U
* device instance $1489 r0 *1 38.605,63.08 nfet_01v8
M$1489 2552 3497 167 167 nfet_01v8 L=150000U W=210000U AS=40400000000P
+ AD=21875000000P PS=560000U PD=460000U
* device instance $1490 r0 *1 39.195,63.08 nfet_01v8
M$1490 1783 4410 167 167 nfet_01v8 L=150000U W=210000U AS=40400000000P
+ AD=21875000000P PS=560000U PD=460000U
* device instance $1491 r0 *1 38.64,63.48 nfet_01v8
M$1491 54 163 2552 167 nfet_01v8 L=150000U W=140000U AS=21875000000P
+ AD=16800000000P PS=460000U PD=380000U
* device instance $1492 r0 *1 39.16,63.48 nfet_01v8
M$1492 55 163 1783 167 nfet_01v8 L=150000U W=140000U AS=21875000000P
+ AD=16800000000P PS=460000U PD=380000U
* device instance $1493 r0 *1 38.64,63.87 nfet_01v8
M$1493 3498 164 54 167 nfet_01v8 L=150000U W=140000U AS=16800000000P
+ AD=21875000000P PS=380000U PD=460000U
* device instance $1494 r0 *1 39.16,63.87 nfet_01v8
M$1494 606 164 55 167 nfet_01v8 L=150000U W=140000U AS=16800000000P
+ AD=21875000000P PS=380000U PD=460000U
* device instance $1495 r0 *1 38.605,64.27 nfet_01v8
M$1495 167 2579 3498 167 nfet_01v8 L=150000U W=210000U AS=21875000000P
+ AD=40400000000P PS=460000U PD=560000U
* device instance $1496 r0 *1 39.195,64.27 nfet_01v8
M$1496 167 729 606 167 nfet_01v8 L=150000U W=210000U AS=21875000000P
+ AD=40400000000P PS=460000U PD=560000U
* device instance $1497 r0 *1 38.605,64.66 nfet_01v8
M$1497 2579 3498 167 167 nfet_01v8 L=150000U W=210000U AS=40400000000P
+ AD=21875000000P PS=560000U PD=460000U
* device instance $1498 r0 *1 39.195,64.66 nfet_01v8
M$1498 729 606 167 167 nfet_01v8 L=150000U W=210000U AS=40400000000P
+ AD=21875000000P PS=560000U PD=460000U
* device instance $1499 r0 *1 38.64,65.06 nfet_01v8
M$1499 53 164 2579 167 nfet_01v8 L=150000U W=140000U AS=21875000000P
+ AD=16800000000P PS=460000U PD=380000U
* device instance $1500 r0 *1 39.16,65.06 nfet_01v8
M$1500 56 164 729 167 nfet_01v8 L=150000U W=140000U AS=21875000000P
+ AD=16800000000P PS=460000U PD=380000U
* device instance $1501 r0 *1 38.64,65.45 nfet_01v8
M$1501 2315 165 53 167 nfet_01v8 L=150000U W=140000U AS=16800000000P
+ AD=21875000000P PS=380000U PD=460000U
* device instance $1502 r0 *1 39.16,65.45 nfet_01v8
M$1502 1329 165 56 167 nfet_01v8 L=150000U W=140000U AS=16800000000P
+ AD=21875000000P PS=380000U PD=460000U
* device instance $1503 r0 *1 38.605,65.85 nfet_01v8
M$1503 167 2648 2315 167 nfet_01v8 L=150000U W=210000U AS=21875000000P
+ AD=40400000000P PS=460000U PD=560000U
* device instance $1504 r0 *1 39.195,65.85 nfet_01v8
M$1504 167 1910 1329 167 nfet_01v8 L=150000U W=210000U AS=21875000000P
+ AD=40400000000P PS=460000U PD=560000U
* device instance $1505 r0 *1 38.605,66.24 nfet_01v8
M$1505 2648 2315 167 167 nfet_01v8 L=150000U W=210000U AS=40400000000P
+ AD=21875000000P PS=560000U PD=460000U
* device instance $1506 r0 *1 39.195,66.24 nfet_01v8
M$1506 1910 1329 167 167 nfet_01v8 L=150000U W=210000U AS=40400000000P
+ AD=21875000000P PS=560000U PD=460000U
* device instance $1507 r0 *1 38.64,66.64 nfet_01v8
M$1507 54 165 2648 167 nfet_01v8 L=150000U W=140000U AS=21875000000P
+ AD=16800000000P PS=460000U PD=380000U
* device instance $1508 r0 *1 39.16,66.64 nfet_01v8
M$1508 55 165 1910 167 nfet_01v8 L=150000U W=140000U AS=21875000000P
+ AD=16800000000P PS=460000U PD=380000U
* device instance $1509 r0 *1 82.24,44.91 nfet_01v8
M$1509 2293 154 118 167 nfet_01v8 L=150000U W=140000U AS=16800000000P
+ AD=21875000000P PS=380000U PD=460000U
* device instance $1510 r0 *1 82.76,44.91 nfet_01v8
M$1510 1025 154 119 167 nfet_01v8 L=150000U W=140000U AS=16800000000P
+ AD=21875000000P PS=380000U PD=460000U
* device instance $1511 r0 *1 82.205,45.31 nfet_01v8
M$1511 167 2609 2293 167 nfet_01v8 L=150000U W=210000U AS=21875000000P
+ AD=40400000000P PS=460000U PD=560000U
* device instance $1512 r0 *1 82.795,45.31 nfet_01v8
M$1512 167 1563 1025 167 nfet_01v8 L=150000U W=210000U AS=21875000000P
+ AD=40400000000P PS=460000U PD=560000U
* device instance $1513 r0 *1 82.205,45.7 nfet_01v8
M$1513 2609 2293 167 167 nfet_01v8 L=150000U W=210000U AS=40400000000P
+ AD=21875000000P PS=560000U PD=460000U
* device instance $1514 r0 *1 82.795,45.7 nfet_01v8
M$1514 1563 1025 167 167 nfet_01v8 L=150000U W=210000U AS=40400000000P
+ AD=21875000000P PS=560000U PD=460000U
* device instance $1515 r0 *1 82.24,46.1 nfet_01v8
M$1515 117 154 2609 167 nfet_01v8 L=150000U W=140000U AS=21875000000P
+ AD=16800000000P PS=460000U PD=380000U
* device instance $1516 r0 *1 82.76,46.1 nfet_01v8
M$1516 120 154 1563 167 nfet_01v8 L=150000U W=140000U AS=21875000000P
+ AD=16800000000P PS=460000U PD=380000U
* device instance $1517 r0 *1 82.24,46.49 nfet_01v8
M$1517 3589 155 117 167 nfet_01v8 L=150000U W=140000U AS=16800000000P
+ AD=21875000000P PS=380000U PD=460000U
* device instance $1518 r0 *1 82.76,46.49 nfet_01v8
M$1518 4491 155 120 167 nfet_01v8 L=150000U W=140000U AS=16800000000P
+ AD=21875000000P PS=380000U PD=460000U
* device instance $1519 r0 *1 82.205,46.89 nfet_01v8
M$1519 167 2628 3589 167 nfet_01v8 L=150000U W=210000U AS=21875000000P
+ AD=40400000000P PS=460000U PD=560000U
* device instance $1520 r0 *1 82.795,46.89 nfet_01v8
M$1520 167 828 4491 167 nfet_01v8 L=150000U W=210000U AS=21875000000P
+ AD=40400000000P PS=460000U PD=560000U
* device instance $1521 r0 *1 82.205,47.28 nfet_01v8
M$1521 2628 3589 167 167 nfet_01v8 L=150000U W=210000U AS=40400000000P
+ AD=21875000000P PS=560000U PD=460000U
* device instance $1522 r0 *1 82.795,47.28 nfet_01v8
M$1522 828 4491 167 167 nfet_01v8 L=150000U W=210000U AS=40400000000P
+ AD=21875000000P PS=560000U PD=460000U
* device instance $1523 r0 *1 82.24,47.68 nfet_01v8
M$1523 118 155 2628 167 nfet_01v8 L=150000U W=140000U AS=21875000000P
+ AD=16800000000P PS=460000U PD=380000U
* device instance $1524 r0 *1 82.76,47.68 nfet_01v8
M$1524 119 155 828 167 nfet_01v8 L=150000U W=140000U AS=21875000000P
+ AD=16800000000P PS=460000U PD=380000U
* device instance $1525 r0 *1 82.24,48.07 nfet_01v8
M$1525 3591 156 118 167 nfet_01v8 L=150000U W=140000U AS=16800000000P
+ AD=21875000000P PS=380000U PD=460000U
* device instance $1526 r0 *1 82.76,48.07 nfet_01v8
M$1526 1310 156 119 167 nfet_01v8 L=150000U W=140000U AS=16800000000P
+ AD=21875000000P PS=380000U PD=460000U
* device instance $1527 r0 *1 82.205,48.47 nfet_01v8
M$1527 167 2608 3591 167 nfet_01v8 L=150000U W=210000U AS=21875000000P
+ AD=40400000000P PS=460000U PD=560000U
* device instance $1528 r0 *1 82.795,48.47 nfet_01v8
M$1528 167 1890 1310 167 nfet_01v8 L=150000U W=210000U AS=21875000000P
+ AD=40400000000P PS=460000U PD=560000U
* device instance $1529 r0 *1 82.205,48.86 nfet_01v8
M$1529 2608 3591 167 167 nfet_01v8 L=150000U W=210000U AS=40400000000P
+ AD=21875000000P PS=560000U PD=460000U
* device instance $1530 r0 *1 82.795,48.86 nfet_01v8
M$1530 1890 1310 167 167 nfet_01v8 L=150000U W=210000U AS=40400000000P
+ AD=21875000000P PS=560000U PD=460000U
* device instance $1531 r0 *1 82.24,49.26 nfet_01v8
M$1531 117 156 2608 167 nfet_01v8 L=150000U W=140000U AS=21875000000P
+ AD=16800000000P PS=460000U PD=380000U
* device instance $1532 r0 *1 82.76,49.26 nfet_01v8
M$1532 120 156 1890 167 nfet_01v8 L=150000U W=140000U AS=21875000000P
+ AD=16800000000P PS=460000U PD=380000U
* device instance $1533 r0 *1 82.24,49.65 nfet_01v8
M$1533 3588 157 117 167 nfet_01v8 L=150000U W=140000U AS=16800000000P
+ AD=21875000000P PS=380000U PD=460000U
* device instance $1534 r0 *1 82.76,49.65 nfet_01v8
M$1534 1008 157 120 167 nfet_01v8 L=150000U W=140000U AS=16800000000P
+ AD=21875000000P PS=380000U PD=460000U
* device instance $1535 r0 *1 82.205,50.05 nfet_01v8
M$1535 167 2627 3588 167 nfet_01v8 L=150000U W=210000U AS=21875000000P
+ AD=40400000000P PS=460000U PD=560000U
* device instance $1536 r0 *1 82.795,50.05 nfet_01v8
M$1536 167 1543 1008 167 nfet_01v8 L=150000U W=210000U AS=21875000000P
+ AD=40400000000P PS=460000U PD=560000U
* device instance $1537 r0 *1 82.205,50.44 nfet_01v8
M$1537 2627 3588 167 167 nfet_01v8 L=150000U W=210000U AS=40400000000P
+ AD=21875000000P PS=560000U PD=460000U
* device instance $1538 r0 *1 82.795,50.44 nfet_01v8
M$1538 1543 1008 167 167 nfet_01v8 L=150000U W=210000U AS=40400000000P
+ AD=21875000000P PS=560000U PD=460000U
* device instance $1539 r0 *1 82.24,50.84 nfet_01v8
M$1539 118 157 2627 167 nfet_01v8 L=150000U W=140000U AS=21875000000P
+ AD=16800000000P PS=460000U PD=380000U
* device instance $1540 r0 *1 82.76,50.84 nfet_01v8
M$1540 119 157 1543 167 nfet_01v8 L=150000U W=140000U AS=21875000000P
+ AD=16800000000P PS=460000U PD=380000U
* device instance $1541 r0 *1 71.34,44.91 nfet_01v8
M$1541 2306 154 102 167 nfet_01v8 L=150000U W=140000U AS=16800000000P
+ AD=21875000000P PS=380000U PD=460000U
* device instance $1542 r0 *1 71.86,44.91 nfet_01v8
M$1542 1304 154 103 167 nfet_01v8 L=150000U W=140000U AS=16800000000P
+ AD=21875000000P PS=380000U PD=460000U
* device instance $1543 r0 *1 71.305,45.31 nfet_01v8
M$1543 167 2629 2306 167 nfet_01v8 L=150000U W=210000U AS=21875000000P
+ AD=40400000000P PS=460000U PD=560000U
* device instance $1544 r0 *1 71.895,45.31 nfet_01v8
M$1544 167 1882 1304 167 nfet_01v8 L=150000U W=210000U AS=21875000000P
+ AD=40400000000P PS=460000U PD=560000U
* device instance $1545 r0 *1 71.305,45.7 nfet_01v8
M$1545 2629 2306 167 167 nfet_01v8 L=150000U W=210000U AS=40400000000P
+ AD=21875000000P PS=560000U PD=460000U
* device instance $1546 r0 *1 71.895,45.7 nfet_01v8
M$1546 1882 1304 167 167 nfet_01v8 L=150000U W=210000U AS=40400000000P
+ AD=21875000000P PS=560000U PD=460000U
* device instance $1547 r0 *1 71.34,46.1 nfet_01v8
M$1547 101 154 2629 167 nfet_01v8 L=150000U W=140000U AS=21875000000P
+ AD=16800000000P PS=460000U PD=380000U
* device instance $1548 r0 *1 71.86,46.1 nfet_01v8
M$1548 104 154 1882 167 nfet_01v8 L=150000U W=140000U AS=21875000000P
+ AD=16800000000P PS=460000U PD=380000U
* device instance $1549 r0 *1 71.34,46.49 nfet_01v8
M$1549 3597 155 101 167 nfet_01v8 L=150000U W=140000U AS=16800000000P
+ AD=21875000000P PS=380000U PD=460000U
* device instance $1550 r0 *1 71.86,46.49 nfet_01v8
M$1550 4485 155 104 167 nfet_01v8 L=150000U W=140000U AS=16800000000P
+ AD=21875000000P PS=380000U PD=460000U
* device instance $1551 r0 *1 71.305,46.89 nfet_01v8
M$1551 167 2258 3597 167 nfet_01v8 L=150000U W=210000U AS=21875000000P
+ AD=40400000000P PS=460000U PD=560000U
* device instance $1552 r0 *1 71.895,46.89 nfet_01v8
M$1552 167 793 4485 167 nfet_01v8 L=150000U W=210000U AS=21875000000P
+ AD=40400000000P PS=460000U PD=560000U
* device instance $1553 r0 *1 71.305,47.28 nfet_01v8
M$1553 2258 3597 167 167 nfet_01v8 L=150000U W=210000U AS=40400000000P
+ AD=21875000000P PS=560000U PD=460000U
* device instance $1554 r0 *1 71.895,47.28 nfet_01v8
M$1554 793 4485 167 167 nfet_01v8 L=150000U W=210000U AS=40400000000P
+ AD=21875000000P PS=560000U PD=460000U
* device instance $1555 r0 *1 71.34,47.68 nfet_01v8
M$1555 102 155 2258 167 nfet_01v8 L=150000U W=140000U AS=21875000000P
+ AD=16800000000P PS=460000U PD=380000U
* device instance $1556 r0 *1 71.86,47.68 nfet_01v8
M$1556 103 155 793 167 nfet_01v8 L=150000U W=140000U AS=21875000000P
+ AD=16800000000P PS=460000U PD=380000U
* device instance $1557 r0 *1 71.34,48.07 nfet_01v8
M$1557 2118 156 102 167 nfet_01v8 L=150000U W=140000U AS=16800000000P
+ AD=21875000000P PS=380000U PD=460000U
* device instance $1558 r0 *1 71.86,48.07 nfet_01v8
M$1558 622 156 103 167 nfet_01v8 L=150000U W=140000U AS=16800000000P
+ AD=21875000000P PS=380000U PD=460000U
* device instance $1559 r0 *1 71.305,48.47 nfet_01v8
M$1559 167 2245 2118 167 nfet_01v8 L=150000U W=210000U AS=21875000000P
+ AD=40400000000P PS=460000U PD=560000U
* device instance $1560 r0 *1 71.895,48.47 nfet_01v8
M$1560 167 765 622 167 nfet_01v8 L=150000U W=210000U AS=21875000000P
+ AD=40400000000P PS=460000U PD=560000U
* device instance $1561 r0 *1 71.305,48.86 nfet_01v8
M$1561 2245 2118 167 167 nfet_01v8 L=150000U W=210000U AS=40400000000P
+ AD=21875000000P PS=560000U PD=460000U
* device instance $1562 r0 *1 71.895,48.86 nfet_01v8
M$1562 765 622 167 167 nfet_01v8 L=150000U W=210000U AS=40400000000P
+ AD=21875000000P PS=560000U PD=460000U
* device instance $1563 r0 *1 71.34,49.26 nfet_01v8
M$1563 101 156 2245 167 nfet_01v8 L=150000U W=140000U AS=21875000000P
+ AD=16800000000P PS=460000U PD=380000U
* device instance $1564 r0 *1 71.86,49.26 nfet_01v8
M$1564 104 156 765 167 nfet_01v8 L=150000U W=140000U AS=21875000000P
+ AD=16800000000P PS=460000U PD=380000U
* device instance $1565 r0 *1 71.34,49.65 nfet_01v8
M$1565 2297 157 101 167 nfet_01v8 L=150000U W=140000U AS=16800000000P
+ AD=21875000000P PS=380000U PD=460000U
* device instance $1566 r0 *1 71.86,49.65 nfet_01v8
M$1566 1321 157 104 167 nfet_01v8 L=150000U W=140000U AS=16800000000P
+ AD=21875000000P PS=380000U PD=460000U
* device instance $1567 r0 *1 71.305,50.05 nfet_01v8
M$1567 167 2614 2297 167 nfet_01v8 L=150000U W=210000U AS=21875000000P
+ AD=40400000000P PS=460000U PD=560000U
* device instance $1568 r0 *1 71.895,50.05 nfet_01v8
M$1568 167 1901 1321 167 nfet_01v8 L=150000U W=210000U AS=21875000000P
+ AD=40400000000P PS=460000U PD=560000U
* device instance $1569 r0 *1 71.305,50.44 nfet_01v8
M$1569 2614 2297 167 167 nfet_01v8 L=150000U W=210000U AS=40400000000P
+ AD=21875000000P PS=560000U PD=460000U
* device instance $1570 r0 *1 71.895,50.44 nfet_01v8
M$1570 1901 1321 167 167 nfet_01v8 L=150000U W=210000U AS=40400000000P
+ AD=21875000000P PS=560000U PD=460000U
* device instance $1571 r0 *1 71.34,50.84 nfet_01v8
M$1571 102 157 2614 167 nfet_01v8 L=150000U W=140000U AS=21875000000P
+ AD=16800000000P PS=460000U PD=380000U
* device instance $1572 r0 *1 71.86,50.84 nfet_01v8
M$1572 103 157 1901 167 nfet_01v8 L=150000U W=140000U AS=21875000000P
+ AD=16800000000P PS=460000U PD=380000U
* device instance $1573 r0 *1 16.84,52.81 nfet_01v8
M$1573 2309 158 22 167 nfet_01v8 L=150000U W=140000U AS=16800000000P
+ AD=21875000000P PS=380000U PD=460000U
* device instance $1574 r0 *1 17.36,52.81 nfet_01v8
M$1574 1288 158 23 167 nfet_01v8 L=150000U W=140000U AS=16800000000P
+ AD=21875000000P PS=380000U PD=460000U
* device instance $1575 r0 *1 16.805,53.21 nfet_01v8
M$1575 167 2640 2309 167 nfet_01v8 L=150000U W=210000U AS=21875000000P
+ AD=40400000000P PS=460000U PD=560000U
* device instance $1576 r0 *1 17.395,53.21 nfet_01v8
M$1576 167 1865 1288 167 nfet_01v8 L=150000U W=210000U AS=21875000000P
+ AD=40400000000P PS=460000U PD=560000U
* device instance $1577 r0 *1 16.805,53.6 nfet_01v8
M$1577 2640 2309 167 167 nfet_01v8 L=150000U W=210000U AS=40400000000P
+ AD=21875000000P PS=560000U PD=460000U
* device instance $1578 r0 *1 17.395,53.6 nfet_01v8
M$1578 1865 1288 167 167 nfet_01v8 L=150000U W=210000U AS=40400000000P
+ AD=21875000000P PS=560000U PD=460000U
* device instance $1579 r0 *1 16.84,54 nfet_01v8
M$1579 21 158 2640 167 nfet_01v8 L=150000U W=140000U AS=21875000000P
+ AD=16800000000P PS=460000U PD=380000U
* device instance $1580 r0 *1 17.36,54 nfet_01v8
M$1580 24 158 1865 167 nfet_01v8 L=150000U W=140000U AS=21875000000P
+ AD=16800000000P PS=460000U PD=380000U
* device instance $1581 r0 *1 16.84,54.39 nfet_01v8
M$1581 3701 159 21 167 nfet_01v8 L=150000U W=140000U AS=16800000000P
+ AD=21875000000P PS=380000U PD=460000U
* device instance $1582 r0 *1 17.36,54.39 nfet_01v8
M$1582 4462 159 24 167 nfet_01v8 L=150000U W=140000U AS=16800000000P
+ AD=21875000000P PS=380000U PD=460000U
* device instance $1583 r0 *1 16.805,54.79 nfet_01v8
M$1583 167 1997 3701 167 nfet_01v8 L=150000U W=210000U AS=21875000000P
+ AD=40400000000P PS=460000U PD=560000U
* device instance $1584 r0 *1 17.395,54.79 nfet_01v8
M$1584 167 861 4462 167 nfet_01v8 L=150000U W=210000U AS=21875000000P
+ AD=40400000000P PS=460000U PD=560000U
* device instance $1585 r0 *1 16.805,55.18 nfet_01v8
M$1585 1997 3701 167 167 nfet_01v8 L=150000U W=210000U AS=40400000000P
+ AD=21875000000P PS=560000U PD=460000U
* device instance $1586 r0 *1 17.395,55.18 nfet_01v8
M$1586 861 4462 167 167 nfet_01v8 L=150000U W=210000U AS=40400000000P
+ AD=21875000000P PS=560000U PD=460000U
* device instance $1587 r0 *1 16.84,55.58 nfet_01v8
M$1587 22 159 1997 167 nfet_01v8 L=150000U W=140000U AS=21875000000P
+ AD=16800000000P PS=460000U PD=380000U
* device instance $1588 r0 *1 17.36,55.58 nfet_01v8
M$1588 23 159 861 167 nfet_01v8 L=150000U W=140000U AS=21875000000P
+ AD=16800000000P PS=460000U PD=380000U
* device instance $1589 r0 *1 16.84,55.97 nfet_01v8
M$1589 2098 160 22 167 nfet_01v8 L=150000U W=140000U AS=16800000000P
+ AD=21875000000P PS=380000U PD=460000U
* device instance $1590 r0 *1 17.36,55.97 nfet_01v8
M$1590 670 160 23 167 nfet_01v8 L=150000U W=140000U AS=16800000000P
+ AD=21875000000P PS=380000U PD=460000U
* device instance $1591 r0 *1 16.805,56.37 nfet_01v8
M$1591 167 2195 2098 167 nfet_01v8 L=150000U W=210000U AS=21875000000P
+ AD=40400000000P PS=460000U PD=560000U
* device instance $1592 r0 *1 17.395,56.37 nfet_01v8
M$1592 167 868 670 167 nfet_01v8 L=150000U W=210000U AS=21875000000P
+ AD=40400000000P PS=460000U PD=560000U
* device instance $1593 r0 *1 16.805,56.76 nfet_01v8
M$1593 2195 2098 167 167 nfet_01v8 L=150000U W=210000U AS=40400000000P
+ AD=21875000000P PS=560000U PD=460000U
* device instance $1594 r0 *1 17.395,56.76 nfet_01v8
M$1594 868 670 167 167 nfet_01v8 L=150000U W=210000U AS=40400000000P
+ AD=21875000000P PS=560000U PD=460000U
* device instance $1595 r0 *1 16.84,57.16 nfet_01v8
M$1595 21 160 2195 167 nfet_01v8 L=150000U W=140000U AS=21875000000P
+ AD=16800000000P PS=460000U PD=380000U
* device instance $1596 r0 *1 17.36,57.16 nfet_01v8
M$1596 24 160 868 167 nfet_01v8 L=150000U W=140000U AS=21875000000P
+ AD=16800000000P PS=460000U PD=380000U
* device instance $1597 r0 *1 16.84,57.55 nfet_01v8
M$1597 3697 161 21 167 nfet_01v8 L=150000U W=140000U AS=16800000000P
+ AD=21875000000P PS=380000U PD=460000U
* device instance $1598 r0 *1 17.36,57.55 nfet_01v8
M$1598 893 161 24 167 nfet_01v8 L=150000U W=140000U AS=16800000000P
+ AD=21875000000P PS=380000U PD=460000U
* device instance $1599 r0 *1 16.805,57.95 nfet_01v8
M$1599 167 2974 3697 167 nfet_01v8 L=150000U W=210000U AS=21875000000P
+ AD=40400000000P PS=460000U PD=560000U
* device instance $1600 r0 *1 17.395,57.95 nfet_01v8
M$1600 167 1408 893 167 nfet_01v8 L=150000U W=210000U AS=21875000000P
+ AD=40400000000P PS=460000U PD=560000U
* device instance $1601 r0 *1 16.805,58.34 nfet_01v8
M$1601 2974 3697 167 167 nfet_01v8 L=150000U W=210000U AS=40400000000P
+ AD=21875000000P PS=560000U PD=460000U
* device instance $1602 r0 *1 17.395,58.34 nfet_01v8
M$1602 1408 893 167 167 nfet_01v8 L=150000U W=210000U AS=40400000000P
+ AD=21875000000P PS=560000U PD=460000U
* device instance $1603 r0 *1 16.84,58.74 nfet_01v8
M$1603 22 161 2974 167 nfet_01v8 L=150000U W=140000U AS=21875000000P
+ AD=16800000000P PS=460000U PD=380000U
* device instance $1604 r0 *1 17.36,58.74 nfet_01v8
M$1604 23 161 1408 167 nfet_01v8 L=150000U W=140000U AS=21875000000P
+ AD=16800000000P PS=460000U PD=380000U
* device instance $1605 r0 *1 27.74,52.81 nfet_01v8
M$1605 3486 158 38 167 nfet_01v8 L=150000U W=140000U AS=16800000000P
+ AD=21875000000P PS=380000U PD=460000U
* device instance $1606 r0 *1 28.26,52.81 nfet_01v8
M$1606 1284 158 39 167 nfet_01v8 L=150000U W=140000U AS=16800000000P
+ AD=21875000000P PS=380000U PD=460000U
* device instance $1607 r0 *1 27.705,53.21 nfet_01v8
M$1607 167 2636 3486 167 nfet_01v8 L=150000U W=210000U AS=21875000000P
+ AD=40400000000P PS=460000U PD=560000U
* device instance $1608 r0 *1 28.295,53.21 nfet_01v8
M$1608 167 1861 1284 167 nfet_01v8 L=150000U W=210000U AS=21875000000P
+ AD=40400000000P PS=460000U PD=560000U
* device instance $1609 r0 *1 27.705,53.6 nfet_01v8
M$1609 2636 3486 167 167 nfet_01v8 L=150000U W=210000U AS=40400000000P
+ AD=21875000000P PS=560000U PD=460000U
* device instance $1610 r0 *1 28.295,53.6 nfet_01v8
M$1610 1861 1284 167 167 nfet_01v8 L=150000U W=210000U AS=40400000000P
+ AD=21875000000P PS=560000U PD=460000U
* device instance $1611 r0 *1 27.74,54 nfet_01v8
M$1611 37 158 2636 167 nfet_01v8 L=150000U W=140000U AS=21875000000P
+ AD=16800000000P PS=460000U PD=380000U
* device instance $1612 r0 *1 28.26,54 nfet_01v8
M$1612 40 158 1861 167 nfet_01v8 L=150000U W=140000U AS=21875000000P
+ AD=16800000000P PS=460000U PD=380000U
* device instance $1613 r0 *1 27.74,54.39 nfet_01v8
M$1613 3517 159 37 167 nfet_01v8 L=150000U W=140000U AS=16800000000P
+ AD=21875000000P PS=380000U PD=460000U
* device instance $1614 r0 *1 28.26,54.39 nfet_01v8
M$1614 4442 159 40 167 nfet_01v8 L=150000U W=140000U AS=16800000000P
+ AD=21875000000P PS=380000U PD=460000U
* device instance $1615 r0 *1 27.705,54.79 nfet_01v8
M$1615 167 2146 3517 167 nfet_01v8 L=150000U W=210000U AS=21875000000P
+ AD=40400000000P PS=460000U PD=560000U
* device instance $1616 r0 *1 28.295,54.79 nfet_01v8
M$1616 167 1397 4442 167 nfet_01v8 L=150000U W=210000U AS=21875000000P
+ AD=40400000000P PS=460000U PD=560000U
* device instance $1617 r0 *1 27.705,55.18 nfet_01v8
M$1617 2146 3517 167 167 nfet_01v8 L=150000U W=210000U AS=40400000000P
+ AD=21875000000P PS=560000U PD=460000U
* device instance $1618 r0 *1 28.295,55.18 nfet_01v8
M$1618 1397 4442 167 167 nfet_01v8 L=150000U W=210000U AS=40400000000P
+ AD=21875000000P PS=560000U PD=460000U
* device instance $1619 r0 *1 27.74,55.58 nfet_01v8
M$1619 38 159 2146 167 nfet_01v8 L=150000U W=140000U AS=21875000000P
+ AD=16800000000P PS=460000U PD=380000U
* device instance $1620 r0 *1 28.26,55.58 nfet_01v8
M$1620 39 159 1397 167 nfet_01v8 L=150000U W=140000U AS=21875000000P
+ AD=16800000000P PS=460000U PD=380000U
* device instance $1621 r0 *1 27.74,55.97 nfet_01v8
M$1621 2073 160 38 167 nfet_01v8 L=150000U W=140000U AS=16800000000P
+ AD=21875000000P PS=380000U PD=460000U
* device instance $1622 r0 *1 28.26,55.97 nfet_01v8
M$1622 928 160 39 167 nfet_01v8 L=150000U W=140000U AS=16800000000P
+ AD=21875000000P PS=380000U PD=460000U
* device instance $1623 r0 *1 27.705,56.37 nfet_01v8
M$1623 167 2149 2073 167 nfet_01v8 L=150000U W=210000U AS=21875000000P
+ AD=40400000000P PS=460000U PD=560000U
* device instance $1624 r0 *1 28.295,56.37 nfet_01v8
M$1624 167 1446 928 167 nfet_01v8 L=150000U W=210000U AS=21875000000P
+ AD=40400000000P PS=460000U PD=560000U
* device instance $1625 r0 *1 27.705,56.76 nfet_01v8
M$1625 2149 2073 167 167 nfet_01v8 L=150000U W=210000U AS=40400000000P
+ AD=21875000000P PS=560000U PD=460000U
* device instance $1626 r0 *1 28.295,56.76 nfet_01v8
M$1626 1446 928 167 167 nfet_01v8 L=150000U W=210000U AS=40400000000P
+ AD=21875000000P PS=560000U PD=460000U
* device instance $1627 r0 *1 27.74,57.16 nfet_01v8
M$1627 37 160 2149 167 nfet_01v8 L=150000U W=140000U AS=21875000000P
+ AD=16800000000P PS=460000U PD=380000U
* device instance $1628 r0 *1 28.26,57.16 nfet_01v8
M$1628 40 160 1446 167 nfet_01v8 L=150000U W=140000U AS=21875000000P
+ AD=16800000000P PS=460000U PD=380000U
* device instance $1629 r0 *1 27.74,57.55 nfet_01v8
M$1629 3548 161 37 167 nfet_01v8 L=150000U W=140000U AS=16800000000P
+ AD=21875000000P PS=380000U PD=460000U
* device instance $1630 r0 *1 28.26,57.55 nfet_01v8
M$1630 924 161 40 167 nfet_01v8 L=150000U W=140000U AS=16800000000P
+ AD=21875000000P PS=380000U PD=460000U
* device instance $1631 r0 *1 27.705,57.95 nfet_01v8
M$1631 167 2591 3548 167 nfet_01v8 L=150000U W=210000U AS=21875000000P
+ AD=40400000000P PS=460000U PD=560000U
* device instance $1632 r0 *1 28.295,57.95 nfet_01v8
M$1632 167 1442 924 167 nfet_01v8 L=150000U W=210000U AS=21875000000P
+ AD=40400000000P PS=460000U PD=560000U
* device instance $1633 r0 *1 27.705,58.34 nfet_01v8
M$1633 2591 3548 167 167 nfet_01v8 L=150000U W=210000U AS=40400000000P
+ AD=21875000000P PS=560000U PD=460000U
* device instance $1634 r0 *1 28.295,58.34 nfet_01v8
M$1634 1442 924 167 167 nfet_01v8 L=150000U W=210000U AS=40400000000P
+ AD=21875000000P PS=560000U PD=460000U
* device instance $1635 r0 *1 27.74,58.74 nfet_01v8
M$1635 38 161 2591 167 nfet_01v8 L=150000U W=140000U AS=21875000000P
+ AD=16800000000P PS=460000U PD=380000U
* device instance $1636 r0 *1 28.26,58.74 nfet_01v8
M$1636 39 161 1442 167 nfet_01v8 L=150000U W=140000U AS=21875000000P
+ AD=16800000000P PS=460000U PD=380000U
* device instance $1637 r0 *1 38.64,52.81 nfet_01v8
M$1637 3487 158 54 167 nfet_01v8 L=150000U W=140000U AS=16800000000P
+ AD=21875000000P PS=380000U PD=460000U
* device instance $1638 r0 *1 39.16,52.81 nfet_01v8
M$1638 1278 158 55 167 nfet_01v8 L=150000U W=140000U AS=16800000000P
+ AD=21875000000P PS=380000U PD=460000U
* device instance $1639 r0 *1 38.605,53.21 nfet_01v8
M$1639 167 2635 3487 167 nfet_01v8 L=150000U W=210000U AS=21875000000P
+ AD=40400000000P PS=460000U PD=560000U
* device instance $1640 r0 *1 39.195,53.21 nfet_01v8
M$1640 167 1855 1278 167 nfet_01v8 L=150000U W=210000U AS=21875000000P
+ AD=40400000000P PS=460000U PD=560000U
* device instance $1641 r0 *1 38.605,53.6 nfet_01v8
M$1641 2635 3487 167 167 nfet_01v8 L=150000U W=210000U AS=40400000000P
+ AD=21875000000P PS=560000U PD=460000U
* device instance $1642 r0 *1 39.195,53.6 nfet_01v8
M$1642 1855 1278 167 167 nfet_01v8 L=150000U W=210000U AS=40400000000P
+ AD=21875000000P PS=560000U PD=460000U
* device instance $1643 r0 *1 38.64,54 nfet_01v8
M$1643 53 158 2635 167 nfet_01v8 L=150000U W=140000U AS=21875000000P
+ AD=16800000000P PS=460000U PD=380000U
* device instance $1644 r0 *1 39.16,54 nfet_01v8
M$1644 56 158 1855 167 nfet_01v8 L=150000U W=140000U AS=21875000000P
+ AD=16800000000P PS=460000U PD=380000U
* device instance $1645 r0 *1 38.64,54.39 nfet_01v8
M$1645 3523 159 53 167 nfet_01v8 L=150000U W=140000U AS=16800000000P
+ AD=21875000000P PS=380000U PD=460000U
* device instance $1646 r0 *1 39.16,54.39 nfet_01v8
M$1646 4440 159 56 167 nfet_01v8 L=150000U W=140000U AS=16800000000P
+ AD=21875000000P PS=380000U PD=460000U
* device instance $1647 r0 *1 38.605,54.79 nfet_01v8
M$1647 167 2053 3523 167 nfet_01v8 L=150000U W=210000U AS=21875000000P
+ AD=40400000000P PS=460000U PD=560000U
* device instance $1648 r0 *1 39.195,54.79 nfet_01v8
M$1648 167 1399 4440 167 nfet_01v8 L=150000U W=210000U AS=21875000000P
+ AD=40400000000P PS=460000U PD=560000U
* device instance $1649 r0 *1 38.605,55.18 nfet_01v8
M$1649 2053 3523 167 167 nfet_01v8 L=150000U W=210000U AS=40400000000P
+ AD=21875000000P PS=560000U PD=460000U
* device instance $1650 r0 *1 39.195,55.18 nfet_01v8
M$1650 1399 4440 167 167 nfet_01v8 L=150000U W=210000U AS=40400000000P
+ AD=21875000000P PS=560000U PD=460000U
* device instance $1651 r0 *1 38.64,55.58 nfet_01v8
M$1651 54 159 2053 167 nfet_01v8 L=150000U W=140000U AS=21875000000P
+ AD=16800000000P PS=460000U PD=380000U
* device instance $1652 r0 *1 39.16,55.58 nfet_01v8
M$1652 55 159 1399 167 nfet_01v8 L=150000U W=140000U AS=21875000000P
+ AD=16800000000P PS=460000U PD=380000U
* device instance $1653 r0 *1 38.64,55.97 nfet_01v8
M$1653 3524 160 54 167 nfet_01v8 L=150000U W=140000U AS=16800000000P
+ AD=21875000000P PS=380000U PD=460000U
* device instance $1654 r0 *1 39.16,55.97 nfet_01v8
M$1654 597 160 55 167 nfet_01v8 L=150000U W=140000U AS=16800000000P
+ AD=21875000000P PS=380000U PD=460000U
* device instance $1655 r0 *1 38.605,56.37 nfet_01v8
M$1655 167 2239 3524 167 nfet_01v8 L=150000U W=210000U AS=21875000000P
+ AD=40400000000P PS=460000U PD=560000U
* device instance $1656 r0 *1 39.195,56.37 nfet_01v8
M$1656 167 715 597 167 nfet_01v8 L=150000U W=210000U AS=21875000000P
+ AD=40400000000P PS=460000U PD=560000U
* device instance $1657 r0 *1 38.605,56.76 nfet_01v8
M$1657 2239 3524 167 167 nfet_01v8 L=150000U W=210000U AS=40400000000P
+ AD=21875000000P PS=560000U PD=460000U
* device instance $1658 r0 *1 39.195,56.76 nfet_01v8
M$1658 715 597 167 167 nfet_01v8 L=150000U W=210000U AS=40400000000P
+ AD=21875000000P PS=560000U PD=460000U
* device instance $1659 r0 *1 38.64,57.16 nfet_01v8
M$1659 53 160 2239 167 nfet_01v8 L=150000U W=140000U AS=21875000000P
+ AD=16800000000P PS=460000U PD=380000U
* device instance $1660 r0 *1 39.16,57.16 nfet_01v8
M$1660 56 160 715 167 nfet_01v8 L=150000U W=140000U AS=21875000000P
+ AD=16800000000P PS=460000U PD=380000U
* device instance $1661 r0 *1 38.64,57.55 nfet_01v8
M$1661 2493 161 53 167 nfet_01v8 L=150000U W=140000U AS=16800000000P
+ AD=21875000000P PS=380000U PD=460000U
* device instance $1662 r0 *1 39.16,57.55 nfet_01v8
M$1662 897 161 56 167 nfet_01v8 L=150000U W=140000U AS=16800000000P
+ AD=21875000000P PS=380000U PD=460000U
* device instance $1663 r0 *1 38.605,57.95 nfet_01v8
M$1663 167 3006 2493 167 nfet_01v8 L=150000U W=210000U AS=21875000000P
+ AD=40400000000P PS=460000U PD=560000U
* device instance $1664 r0 *1 39.195,57.95 nfet_01v8
M$1664 167 1414 897 167 nfet_01v8 L=150000U W=210000U AS=21875000000P
+ AD=40400000000P PS=460000U PD=560000U
* device instance $1665 r0 *1 38.605,58.34 nfet_01v8
M$1665 3006 2493 167 167 nfet_01v8 L=150000U W=210000U AS=40400000000P
+ AD=21875000000P PS=560000U PD=460000U
* device instance $1666 r0 *1 39.195,58.34 nfet_01v8
M$1666 1414 897 167 167 nfet_01v8 L=150000U W=210000U AS=40400000000P
+ AD=21875000000P PS=560000U PD=460000U
* device instance $1667 r0 *1 38.64,58.74 nfet_01v8
M$1667 54 161 3006 167 nfet_01v8 L=150000U W=140000U AS=21875000000P
+ AD=16800000000P PS=460000U PD=380000U
* device instance $1668 r0 *1 39.16,58.74 nfet_01v8
M$1668 55 161 1414 167 nfet_01v8 L=150000U W=140000U AS=21875000000P
+ AD=16800000000P PS=460000U PD=380000U
* device instance $1669 r0 *1 49.54,52.81 nfet_01v8
M$1669 2472 158 70 167 nfet_01v8 L=150000U W=140000U AS=16800000000P
+ AD=21875000000P PS=380000U PD=460000U
* device instance $1670 r0 *1 50.06,52.81 nfet_01v8
M$1670 1112 158 71 167 nfet_01v8 L=150000U W=140000U AS=16800000000P
+ AD=21875000000P PS=380000U PD=460000U
* device instance $1671 r0 *1 49.505,53.21 nfet_01v8
M$1671 167 2968 2472 167 nfet_01v8 L=150000U W=210000U AS=21875000000P
+ AD=40400000000P PS=460000U PD=560000U
* device instance $1672 r0 *1 50.095,53.21 nfet_01v8
M$1672 167 1665 1112 167 nfet_01v8 L=150000U W=210000U AS=21875000000P
+ AD=40400000000P PS=460000U PD=560000U
* device instance $1673 r0 *1 49.505,53.6 nfet_01v8
M$1673 2968 2472 167 167 nfet_01v8 L=150000U W=210000U AS=40400000000P
+ AD=21875000000P PS=560000U PD=460000U
* device instance $1674 r0 *1 50.095,53.6 nfet_01v8
M$1674 1665 1112 167 167 nfet_01v8 L=150000U W=210000U AS=40400000000P
+ AD=21875000000P PS=560000U PD=460000U
* device instance $1675 r0 *1 49.54,54 nfet_01v8
M$1675 69 158 2968 167 nfet_01v8 L=150000U W=140000U AS=21875000000P
+ AD=16800000000P PS=460000U PD=380000U
* device instance $1676 r0 *1 50.06,54 nfet_01v8
M$1676 72 158 1665 167 nfet_01v8 L=150000U W=140000U AS=21875000000P
+ AD=16800000000P PS=460000U PD=380000U
* device instance $1677 r0 *1 49.54,54.39 nfet_01v8
M$1677 3569 159 69 167 nfet_01v8 L=150000U W=140000U AS=16800000000P
+ AD=21875000000P PS=380000U PD=460000U
* device instance $1678 r0 *1 50.06,54.39 nfet_01v8
M$1678 4336 159 72 167 nfet_01v8 L=150000U W=140000U AS=16800000000P
+ AD=21875000000P PS=380000U PD=460000U
* device instance $1679 r0 *1 49.505,54.79 nfet_01v8
M$1679 167 2170 3569 167 nfet_01v8 L=150000U W=210000U AS=21875000000P
+ AD=40400000000P PS=460000U PD=560000U
* device instance $1680 r0 *1 50.095,54.79 nfet_01v8
M$1680 167 751 4336 167 nfet_01v8 L=150000U W=210000U AS=21875000000P
+ AD=40400000000P PS=460000U PD=560000U
* device instance $1681 r0 *1 49.505,55.18 nfet_01v8
M$1681 2170 3569 167 167 nfet_01v8 L=150000U W=210000U AS=40400000000P
+ AD=21875000000P PS=560000U PD=460000U
* device instance $1682 r0 *1 50.095,55.18 nfet_01v8
M$1682 751 4336 167 167 nfet_01v8 L=150000U W=210000U AS=40400000000P
+ AD=21875000000P PS=560000U PD=460000U
* device instance $1683 r0 *1 49.54,55.58 nfet_01v8
M$1683 70 159 2170 167 nfet_01v8 L=150000U W=140000U AS=21875000000P
+ AD=16800000000P PS=460000U PD=380000U
* device instance $1684 r0 *1 50.06,55.58 nfet_01v8
M$1684 71 159 751 167 nfet_01v8 L=150000U W=140000U AS=21875000000P
+ AD=16800000000P PS=460000U PD=380000U
* device instance $1685 r0 *1 49.54,55.97 nfet_01v8
M$1685 2277 160 70 167 nfet_01v8 L=150000U W=140000U AS=16800000000P
+ AD=21875000000P PS=380000U PD=460000U
* device instance $1686 r0 *1 50.06,55.97 nfet_01v8
M$1686 1100 160 71 167 nfet_01v8 L=150000U W=140000U AS=16800000000P
+ AD=21875000000P PS=380000U PD=460000U
* device instance $1687 r0 *1 49.505,56.37 nfet_01v8
M$1687 167 2576 2277 167 nfet_01v8 L=150000U W=210000U AS=21875000000P
+ AD=40400000000P PS=460000U PD=560000U
* device instance $1688 r0 *1 50.095,56.37 nfet_01v8
M$1688 167 1650 1100 167 nfet_01v8 L=150000U W=210000U AS=21875000000P
+ AD=40400000000P PS=460000U PD=560000U
* device instance $1689 r0 *1 49.505,56.76 nfet_01v8
M$1689 2576 2277 167 167 nfet_01v8 L=150000U W=210000U AS=40400000000P
+ AD=21875000000P PS=560000U PD=460000U
* device instance $1690 r0 *1 50.095,56.76 nfet_01v8
M$1690 1650 1100 167 167 nfet_01v8 L=150000U W=210000U AS=40400000000P
+ AD=21875000000P PS=560000U PD=460000U
* device instance $1691 r0 *1 49.54,57.16 nfet_01v8
M$1691 69 160 2576 167 nfet_01v8 L=150000U W=140000U AS=21875000000P
+ AD=16800000000P PS=460000U PD=380000U
* device instance $1692 r0 *1 50.06,57.16 nfet_01v8
M$1692 72 160 1650 167 nfet_01v8 L=150000U W=140000U AS=21875000000P
+ AD=16800000000P PS=460000U PD=380000U
* device instance $1693 r0 *1 49.54,57.55 nfet_01v8
M$1693 3172 161 69 167 nfet_01v8 L=150000U W=140000U AS=16800000000P
+ AD=21875000000P PS=380000U PD=460000U
* device instance $1694 r0 *1 50.06,57.55 nfet_01v8
M$1694 1109 161 72 167 nfet_01v8 L=150000U W=140000U AS=16800000000P
+ AD=21875000000P PS=380000U PD=460000U
* device instance $1695 r0 *1 49.505,57.95 nfet_01v8
M$1695 167 2572 3172 167 nfet_01v8 L=150000U W=210000U AS=21875000000P
+ AD=40400000000P PS=460000U PD=560000U
* device instance $1696 r0 *1 50.095,57.95 nfet_01v8
M$1696 167 1661 1109 167 nfet_01v8 L=150000U W=210000U AS=21875000000P
+ AD=40400000000P PS=460000U PD=560000U
* device instance $1697 r0 *1 49.505,58.34 nfet_01v8
M$1697 2572 3172 167 167 nfet_01v8 L=150000U W=210000U AS=40400000000P
+ AD=21875000000P PS=560000U PD=460000U
* device instance $1698 r0 *1 50.095,58.34 nfet_01v8
M$1698 1661 1109 167 167 nfet_01v8 L=150000U W=210000U AS=40400000000P
+ AD=21875000000P PS=560000U PD=460000U
* device instance $1699 r0 *1 49.54,58.74 nfet_01v8
M$1699 70 161 2572 167 nfet_01v8 L=150000U W=140000U AS=21875000000P
+ AD=16800000000P PS=460000U PD=380000U
* device instance $1700 r0 *1 50.06,58.74 nfet_01v8
M$1700 71 161 1661 167 nfet_01v8 L=150000U W=140000U AS=21875000000P
+ AD=16800000000P PS=460000U PD=380000U
* device instance $1701 r0 *1 60.44,52.81 nfet_01v8
M$1701 3179 158 86 167 nfet_01v8 L=150000U W=140000U AS=16800000000P
+ AD=21875000000P PS=380000U PD=460000U
* device instance $1702 r0 *1 60.96,52.81 nfet_01v8
M$1702 1076 158 87 167 nfet_01v8 L=150000U W=140000U AS=16800000000P
+ AD=21875000000P PS=380000U PD=460000U
* device instance $1703 r0 *1 60.405,53.21 nfet_01v8
M$1703 167 2951 3179 167 nfet_01v8 L=150000U W=210000U AS=21875000000P
+ AD=40400000000P PS=460000U PD=560000U
* device instance $1704 r0 *1 60.995,53.21 nfet_01v8
M$1704 167 1621 1076 167 nfet_01v8 L=150000U W=210000U AS=21875000000P
+ AD=40400000000P PS=460000U PD=560000U
* device instance $1705 r0 *1 60.405,53.6 nfet_01v8
M$1705 2951 3179 167 167 nfet_01v8 L=150000U W=210000U AS=40400000000P
+ AD=21875000000P PS=560000U PD=460000U
* device instance $1706 r0 *1 60.995,53.6 nfet_01v8
M$1706 1621 1076 167 167 nfet_01v8 L=150000U W=210000U AS=40400000000P
+ AD=21875000000P PS=560000U PD=460000U
* device instance $1707 r0 *1 60.44,54 nfet_01v8
M$1707 85 158 2951 167 nfet_01v8 L=150000U W=140000U AS=21875000000P
+ AD=16800000000P PS=460000U PD=380000U
* device instance $1708 r0 *1 60.96,54 nfet_01v8
M$1708 88 158 1621 167 nfet_01v8 L=150000U W=140000U AS=21875000000P
+ AD=16800000000P PS=460000U PD=380000U
* device instance $1709 r0 *1 60.44,54.39 nfet_01v8
M$1709 3578 159 85 167 nfet_01v8 L=150000U W=140000U AS=16800000000P
+ AD=21875000000P PS=380000U PD=460000U
* device instance $1710 r0 *1 60.96,54.39 nfet_01v8
M$1710 4317 159 88 167 nfet_01v8 L=150000U W=140000U AS=16800000000P
+ AD=21875000000P PS=380000U PD=460000U
* device instance $1711 r0 *1 60.405,54.79 nfet_01v8
M$1711 167 2567 3578 167 nfet_01v8 L=150000U W=210000U AS=21875000000P
+ AD=40400000000P PS=460000U PD=560000U
* device instance $1712 r0 *1 60.995,54.79 nfet_01v8
M$1712 167 1638 4317 167 nfet_01v8 L=150000U W=210000U AS=21875000000P
+ AD=40400000000P PS=460000U PD=560000U
* device instance $1713 r0 *1 60.405,55.18 nfet_01v8
M$1713 2567 3578 167 167 nfet_01v8 L=150000U W=210000U AS=40400000000P
+ AD=21875000000P PS=560000U PD=460000U
* device instance $1714 r0 *1 60.995,55.18 nfet_01v8
M$1714 1638 4317 167 167 nfet_01v8 L=150000U W=210000U AS=40400000000P
+ AD=21875000000P PS=560000U PD=460000U
* device instance $1715 r0 *1 60.44,55.58 nfet_01v8
M$1715 86 159 2567 167 nfet_01v8 L=150000U W=140000U AS=21875000000P
+ AD=16800000000P PS=460000U PD=380000U
* device instance $1716 r0 *1 60.96,55.58 nfet_01v8
M$1716 87 159 1638 167 nfet_01v8 L=150000U W=140000U AS=21875000000P
+ AD=16800000000P PS=460000U PD=380000U
* device instance $1717 r0 *1 60.44,55.97 nfet_01v8
M$1717 3580 160 86 167 nfet_01v8 L=150000U W=140000U AS=16800000000P
+ AD=21875000000P PS=380000U PD=460000U
* device instance $1718 r0 *1 60.96,55.97 nfet_01v8
M$1718 600 160 87 167 nfet_01v8 L=150000U W=140000U AS=16800000000P
+ AD=21875000000P PS=380000U PD=460000U
* device instance $1719 r0 *1 60.405,56.37 nfet_01v8
M$1719 167 2561 3580 167 nfet_01v8 L=150000U W=210000U AS=21875000000P
+ AD=40400000000P PS=460000U PD=560000U
* device instance $1720 r0 *1 60.995,56.37 nfet_01v8
M$1720 167 720 600 167 nfet_01v8 L=150000U W=210000U AS=21875000000P
+ AD=40400000000P PS=460000U PD=560000U
* device instance $1721 r0 *1 60.405,56.76 nfet_01v8
M$1721 2561 3580 167 167 nfet_01v8 L=150000U W=210000U AS=40400000000P
+ AD=21875000000P PS=560000U PD=460000U
* device instance $1722 r0 *1 60.995,56.76 nfet_01v8
M$1722 720 600 167 167 nfet_01v8 L=150000U W=210000U AS=40400000000P
+ AD=21875000000P PS=560000U PD=460000U
* device instance $1723 r0 *1 60.44,57.16 nfet_01v8
M$1723 85 160 2561 167 nfet_01v8 L=150000U W=140000U AS=21875000000P
+ AD=16800000000P PS=460000U PD=380000U
* device instance $1724 r0 *1 60.96,57.16 nfet_01v8
M$1724 88 160 720 167 nfet_01v8 L=150000U W=140000U AS=21875000000P
+ AD=16800000000P PS=460000U PD=380000U
* device instance $1725 r0 *1 60.44,57.55 nfet_01v8
M$1725 2278 161 85 167 nfet_01v8 L=150000U W=140000U AS=16800000000P
+ AD=21875000000P PS=380000U PD=460000U
* device instance $1726 r0 *1 60.96,57.55 nfet_01v8
M$1726 1065 161 88 167 nfet_01v8 L=150000U W=140000U AS=16800000000P
+ AD=21875000000P PS=380000U PD=460000U
* device instance $1727 r0 *1 60.405,57.95 nfet_01v8
M$1727 167 2580 2278 167 nfet_01v8 L=150000U W=210000U AS=21875000000P
+ AD=40400000000P PS=460000U PD=560000U
* device instance $1728 r0 *1 60.995,57.95 nfet_01v8
M$1728 167 1609 1065 167 nfet_01v8 L=150000U W=210000U AS=21875000000P
+ AD=40400000000P PS=460000U PD=560000U
* device instance $1729 r0 *1 60.405,58.34 nfet_01v8
M$1729 2580 2278 167 167 nfet_01v8 L=150000U W=210000U AS=40400000000P
+ AD=21875000000P PS=560000U PD=460000U
* device instance $1730 r0 *1 60.995,58.34 nfet_01v8
M$1730 1609 1065 167 167 nfet_01v8 L=150000U W=210000U AS=40400000000P
+ AD=21875000000P PS=560000U PD=460000U
* device instance $1731 r0 *1 60.44,58.74 nfet_01v8
M$1731 86 161 2580 167 nfet_01v8 L=150000U W=140000U AS=21875000000P
+ AD=16800000000P PS=460000U PD=380000U
* device instance $1732 r0 *1 60.96,58.74 nfet_01v8
M$1732 87 161 1609 167 nfet_01v8 L=150000U W=140000U AS=21875000000P
+ AD=16800000000P PS=460000U PD=380000U
* device instance $1733 r0 *1 5.94,52.81 nfet_01v8
M$1733 3491 158 6 167 nfet_01v8 L=150000U W=140000U AS=16800000000P
+ AD=21875000000P PS=380000U PD=460000U
* device instance $1734 r0 *1 6.46,52.81 nfet_01v8
M$1734 1255 158 7 167 nfet_01v8 L=150000U W=140000U AS=16800000000P
+ AD=21875000000P PS=380000U PD=460000U
* device instance $1735 r0 *1 5.905,53.21 nfet_01v8
M$1735 167 2652 3491 167 nfet_01v8 L=150000U W=210000U AS=21875000000P
+ AD=40400000000P PS=460000U PD=560000U
* device instance $1736 r0 *1 6.495,53.21 nfet_01v8
M$1736 167 1830 1255 167 nfet_01v8 L=150000U W=210000U AS=21875000000P
+ AD=40400000000P PS=460000U PD=560000U
* device instance $1737 r0 *1 5.905,53.6 nfet_01v8
M$1737 2652 3491 167 167 nfet_01v8 L=150000U W=210000U AS=40400000000P
+ AD=21875000000P PS=560000U PD=460000U
* device instance $1738 r0 *1 6.495,53.6 nfet_01v8
M$1738 1830 1255 167 167 nfet_01v8 L=150000U W=210000U AS=40400000000P
+ AD=21875000000P PS=560000U PD=460000U
* device instance $1739 r0 *1 5.94,54 nfet_01v8
M$1739 5 158 2652 167 nfet_01v8 L=150000U W=140000U AS=21875000000P
+ AD=16800000000P PS=460000U PD=380000U
* device instance $1740 r0 *1 6.46,54 nfet_01v8
M$1740 8 158 1830 167 nfet_01v8 L=150000U W=140000U AS=21875000000P
+ AD=16800000000P PS=460000U PD=380000U
* device instance $1741 r0 *1 5.94,54.39 nfet_01v8
M$1741 3691 159 5 167 nfet_01v8 L=150000U W=140000U AS=16800000000P
+ AD=21875000000P PS=380000U PD=460000U
* device instance $1742 r0 *1 6.46,54.39 nfet_01v8
M$1742 4437 159 8 167 nfet_01v8 L=150000U W=140000U AS=16800000000P
+ AD=21875000000P PS=380000U PD=460000U
* device instance $1743 r0 *1 5.905,54.79 nfet_01v8
M$1743 167 2253 3691 167 nfet_01v8 L=150000U W=210000U AS=21875000000P
+ AD=40400000000P PS=460000U PD=560000U
* device instance $1744 r0 *1 6.495,54.79 nfet_01v8
M$1744 167 1379 4437 167 nfet_01v8 L=150000U W=210000U AS=21875000000P
+ AD=40400000000P PS=460000U PD=560000U
* device instance $1745 r0 *1 5.905,55.18 nfet_01v8
M$1745 2253 3691 167 167 nfet_01v8 L=150000U W=210000U AS=40400000000P
+ AD=21875000000P PS=560000U PD=460000U
* device instance $1746 r0 *1 6.495,55.18 nfet_01v8
M$1746 1379 4437 167 167 nfet_01v8 L=150000U W=210000U AS=40400000000P
+ AD=21875000000P PS=560000U PD=460000U
* device instance $1747 r0 *1 5.94,55.58 nfet_01v8
M$1747 6 159 2253 167 nfet_01v8 L=150000U W=140000U AS=21875000000P
+ AD=16800000000P PS=460000U PD=380000U
* device instance $1748 r0 *1 6.46,55.58 nfet_01v8
M$1748 7 159 1379 167 nfet_01v8 L=150000U W=140000U AS=21875000000P
+ AD=16800000000P PS=460000U PD=380000U
* device instance $1749 r0 *1 5.94,55.97 nfet_01v8
M$1749 2454 160 6 167 nfet_01v8 L=150000U W=140000U AS=16800000000P
+ AD=21875000000P PS=380000U PD=460000U
* device instance $1750 r0 *1 6.46,55.97 nfet_01v8
M$1750 896 160 7 167 nfet_01v8 L=150000U W=140000U AS=16800000000P
+ AD=21875000000P PS=380000U PD=460000U
* device instance $1751 r0 *1 5.905,56.37 nfet_01v8
M$1751 167 2928 2454 167 nfet_01v8 L=150000U W=210000U AS=21875000000P
+ AD=40400000000P PS=460000U PD=560000U
* device instance $1752 r0 *1 6.495,56.37 nfet_01v8
M$1752 167 1413 896 167 nfet_01v8 L=150000U W=210000U AS=21875000000P
+ AD=40400000000P PS=460000U PD=560000U
* device instance $1753 r0 *1 5.905,56.76 nfet_01v8
M$1753 2928 2454 167 167 nfet_01v8 L=150000U W=210000U AS=40400000000P
+ AD=21875000000P PS=560000U PD=460000U
* device instance $1754 r0 *1 6.495,56.76 nfet_01v8
M$1754 1413 896 167 167 nfet_01v8 L=150000U W=210000U AS=40400000000P
+ AD=21875000000P PS=560000U PD=460000U
* device instance $1755 r0 *1 5.94,57.16 nfet_01v8
M$1755 5 160 2928 167 nfet_01v8 L=150000U W=140000U AS=21875000000P
+ AD=16800000000P PS=460000U PD=380000U
* device instance $1756 r0 *1 6.46,57.16 nfet_01v8
M$1756 8 160 1413 167 nfet_01v8 L=150000U W=140000U AS=21875000000P
+ AD=16800000000P PS=460000U PD=380000U
* device instance $1757 r0 *1 5.94,57.55 nfet_01v8
M$1757 3718 161 5 167 nfet_01v8 L=150000U W=140000U AS=16800000000P
+ AD=21875000000P PS=380000U PD=460000U
* device instance $1758 r0 *1 6.46,57.55 nfet_01v8
M$1758 886 161 8 167 nfet_01v8 L=150000U W=140000U AS=16800000000P
+ AD=21875000000P PS=380000U PD=460000U
* device instance $1759 r0 *1 5.905,57.95 nfet_01v8
M$1759 167 2922 3718 167 nfet_01v8 L=150000U W=210000U AS=21875000000P
+ AD=40400000000P PS=460000U PD=560000U
* device instance $1760 r0 *1 6.495,57.95 nfet_01v8
M$1760 167 1398 886 167 nfet_01v8 L=150000U W=210000U AS=21875000000P
+ AD=40400000000P PS=460000U PD=560000U
* device instance $1761 r0 *1 5.905,58.34 nfet_01v8
M$1761 2922 3718 167 167 nfet_01v8 L=150000U W=210000U AS=40400000000P
+ AD=21875000000P PS=560000U PD=460000U
* device instance $1762 r0 *1 6.495,58.34 nfet_01v8
M$1762 1398 886 167 167 nfet_01v8 L=150000U W=210000U AS=40400000000P
+ AD=21875000000P PS=560000U PD=460000U
* device instance $1763 r0 *1 5.94,58.74 nfet_01v8
M$1763 6 161 2922 167 nfet_01v8 L=150000U W=140000U AS=21875000000P
+ AD=16800000000P PS=460000U PD=380000U
* device instance $1764 r0 *1 6.46,58.74 nfet_01v8
M$1764 7 161 1398 167 nfet_01v8 L=150000U W=140000U AS=21875000000P
+ AD=16800000000P PS=460000U PD=380000U
* device instance $1765 r0 *1 71.34,52.81 nfet_01v8
M$1765 2469 158 102 167 nfet_01v8 L=150000U W=140000U AS=16800000000P
+ AD=21875000000P PS=380000U PD=460000U
* device instance $1766 r0 *1 71.86,52.81 nfet_01v8
M$1766 1071 158 103 167 nfet_01v8 L=150000U W=140000U AS=16800000000P
+ AD=21875000000P PS=380000U PD=460000U
* device instance $1767 r0 *1 71.305,53.21 nfet_01v8
M$1767 167 2964 2469 167 nfet_01v8 L=150000U W=210000U AS=21875000000P
+ AD=40400000000P PS=460000U PD=560000U
* device instance $1768 r0 *1 71.895,53.21 nfet_01v8
M$1768 167 1616 1071 167 nfet_01v8 L=150000U W=210000U AS=21875000000P
+ AD=40400000000P PS=460000U PD=560000U
* device instance $1769 r0 *1 71.305,53.6 nfet_01v8
M$1769 2964 2469 167 167 nfet_01v8 L=150000U W=210000U AS=40400000000P
+ AD=21875000000P PS=560000U PD=460000U
* device instance $1770 r0 *1 71.895,53.6 nfet_01v8
M$1770 1616 1071 167 167 nfet_01v8 L=150000U W=210000U AS=40400000000P
+ AD=21875000000P PS=560000U PD=460000U
* device instance $1771 r0 *1 71.34,54 nfet_01v8
M$1771 101 158 2964 167 nfet_01v8 L=150000U W=140000U AS=21875000000P
+ AD=16800000000P PS=460000U PD=380000U
* device instance $1772 r0 *1 71.86,54 nfet_01v8
M$1772 104 158 1616 167 nfet_01v8 L=150000U W=140000U AS=21875000000P
+ AD=16800000000P PS=460000U PD=380000U
* device instance $1773 r0 *1 71.34,54.39 nfet_01v8
M$1773 3131 159 101 167 nfet_01v8 L=150000U W=140000U AS=16800000000P
+ AD=21875000000P PS=380000U PD=460000U
* device instance $1774 r0 *1 71.86,54.39 nfet_01v8
M$1774 4531 159 104 167 nfet_01v8 L=150000U W=140000U AS=16800000000P
+ AD=21875000000P PS=380000U PD=460000U
* device instance $1775 r0 *1 71.305,54.79 nfet_01v8
M$1775 167 1987 3131 167 nfet_01v8 L=150000U W=210000U AS=21875000000P
+ AD=40400000000P PS=460000U PD=560000U
* device instance $1776 r0 *1 71.895,54.79 nfet_01v8
M$1776 167 674 4531 167 nfet_01v8 L=150000U W=210000U AS=21875000000P
+ AD=40400000000P PS=460000U PD=560000U
* device instance $1777 r0 *1 71.305,55.18 nfet_01v8
M$1777 1987 3131 167 167 nfet_01v8 L=150000U W=210000U AS=40400000000P
+ AD=21875000000P PS=560000U PD=460000U
* device instance $1778 r0 *1 71.895,55.18 nfet_01v8
M$1778 674 4531 167 167 nfet_01v8 L=150000U W=210000U AS=40400000000P
+ AD=21875000000P PS=560000U PD=460000U
* device instance $1779 r0 *1 71.34,55.58 nfet_01v8
M$1779 102 159 1987 167 nfet_01v8 L=150000U W=140000U AS=21875000000P
+ AD=16800000000P PS=460000U PD=380000U
* device instance $1780 r0 *1 71.86,55.58 nfet_01v8
M$1780 103 159 674 167 nfet_01v8 L=150000U W=140000U AS=21875000000P
+ AD=16800000000P PS=460000U PD=380000U
* device instance $1781 r0 *1 71.34,55.97 nfet_01v8
M$1781 2105 160 102 167 nfet_01v8 L=150000U W=140000U AS=16800000000P
+ AD=21875000000P PS=380000U PD=460000U
* device instance $1782 r0 *1 71.86,55.97 nfet_01v8
M$1782 656 160 103 167 nfet_01v8 L=150000U W=140000U AS=16800000000P
+ AD=21875000000P PS=380000U PD=460000U
* device instance $1783 r0 *1 71.305,56.37 nfet_01v8
M$1783 167 2213 2105 167 nfet_01v8 L=150000U W=210000U AS=21875000000P
+ AD=40400000000P PS=460000U PD=560000U
* device instance $1784 r0 *1 71.895,56.37 nfet_01v8
M$1784 167 836 656 167 nfet_01v8 L=150000U W=210000U AS=21875000000P
+ AD=40400000000P PS=460000U PD=560000U
* device instance $1785 r0 *1 71.305,56.76 nfet_01v8
M$1785 2213 2105 167 167 nfet_01v8 L=150000U W=210000U AS=40400000000P
+ AD=21875000000P PS=560000U PD=460000U
* device instance $1786 r0 *1 71.895,56.76 nfet_01v8
M$1786 836 656 167 167 nfet_01v8 L=150000U W=210000U AS=40400000000P
+ AD=21875000000P PS=560000U PD=460000U
* device instance $1787 r0 *1 71.34,57.16 nfet_01v8
M$1787 101 160 2213 167 nfet_01v8 L=150000U W=140000U AS=21875000000P
+ AD=16800000000P PS=460000U PD=380000U
* device instance $1788 r0 *1 71.86,57.16 nfet_01v8
M$1788 104 160 836 167 nfet_01v8 L=150000U W=140000U AS=21875000000P
+ AD=16800000000P PS=460000U PD=380000U
* device instance $1789 r0 *1 71.34,57.55 nfet_01v8
M$1789 2418 161 101 167 nfet_01v8 L=150000U W=140000U AS=16800000000P
+ AD=21875000000P PS=380000U PD=460000U
* device instance $1790 r0 *1 71.86,57.55 nfet_01v8
M$1790 1342 161 104 167 nfet_01v8 L=150000U W=140000U AS=16800000000P
+ AD=21875000000P PS=380000U PD=460000U
* device instance $1791 r0 *1 71.305,57.95 nfet_01v8
M$1791 167 2844 2418 167 nfet_01v8 L=150000U W=210000U AS=21875000000P
+ AD=40400000000P PS=460000U PD=560000U
* device instance $1792 r0 *1 71.895,57.95 nfet_01v8
M$1792 167 1928 1342 167 nfet_01v8 L=150000U W=210000U AS=21875000000P
+ AD=40400000000P PS=460000U PD=560000U
* device instance $1793 r0 *1 71.305,58.34 nfet_01v8
M$1793 2844 2418 167 167 nfet_01v8 L=150000U W=210000U AS=40400000000P
+ AD=21875000000P PS=560000U PD=460000U
* device instance $1794 r0 *1 71.895,58.34 nfet_01v8
M$1794 1928 1342 167 167 nfet_01v8 L=150000U W=210000U AS=40400000000P
+ AD=21875000000P PS=560000U PD=460000U
* device instance $1795 r0 *1 71.34,58.74 nfet_01v8
M$1795 102 161 2844 167 nfet_01v8 L=150000U W=140000U AS=21875000000P
+ AD=16800000000P PS=460000U PD=380000U
* device instance $1796 r0 *1 71.86,58.74 nfet_01v8
M$1796 103 161 1928 167 nfet_01v8 L=150000U W=140000U AS=21875000000P
+ AD=16800000000P PS=460000U PD=380000U
* device instance $1797 r0 *1 60.44,44.91 nfet_01v8
M$1797 2319 154 86 167 nfet_01v8 L=150000U W=140000U AS=16800000000P
+ AD=21875000000P PS=380000U PD=460000U
* device instance $1798 r0 *1 60.96,44.91 nfet_01v8
M$1798 1178 154 87 167 nfet_01v8 L=150000U W=140000U AS=16800000000P
+ AD=21875000000P PS=380000U PD=460000U
* device instance $1799 r0 *1 60.405,45.31 nfet_01v8
M$1799 167 2654 2319 167 nfet_01v8 L=150000U W=210000U AS=21875000000P
+ AD=40400000000P PS=460000U PD=560000U
* device instance $1800 r0 *1 60.995,45.31 nfet_01v8
M$1800 167 1741 1178 167 nfet_01v8 L=150000U W=210000U AS=21875000000P
+ AD=40400000000P PS=460000U PD=560000U
* device instance $1801 r0 *1 60.405,45.7 nfet_01v8
M$1801 2654 2319 167 167 nfet_01v8 L=150000U W=210000U AS=40400000000P
+ AD=21875000000P PS=560000U PD=460000U
* device instance $1802 r0 *1 60.995,45.7 nfet_01v8
M$1802 1741 1178 167 167 nfet_01v8 L=150000U W=210000U AS=40400000000P
+ AD=21875000000P PS=560000U PD=460000U
* device instance $1803 r0 *1 60.44,46.1 nfet_01v8
M$1803 85 154 2654 167 nfet_01v8 L=150000U W=140000U AS=21875000000P
+ AD=16800000000P PS=460000U PD=380000U
* device instance $1804 r0 *1 60.96,46.1 nfet_01v8
M$1804 88 154 1741 167 nfet_01v8 L=150000U W=140000U AS=21875000000P
+ AD=16800000000P PS=460000U PD=380000U
* device instance $1805 r0 *1 60.44,46.49 nfet_01v8
M$1805 3554 155 85 167 nfet_01v8 L=150000U W=140000U AS=16800000000P
+ AD=21875000000P PS=380000U PD=460000U
* device instance $1806 r0 *1 60.96,46.49 nfet_01v8
M$1806 4372 155 88 167 nfet_01v8 L=150000U W=140000U AS=16800000000P
+ AD=21875000000P PS=380000U PD=460000U
* device instance $1807 r0 *1 60.405,46.89 nfet_01v8
M$1807 167 1985 3554 167 nfet_01v8 L=150000U W=210000U AS=21875000000P
+ AD=40400000000P PS=460000U PD=560000U
* device instance $1808 r0 *1 60.995,46.89 nfet_01v8
M$1808 167 1736 4372 167 nfet_01v8 L=150000U W=210000U AS=21875000000P
+ AD=40400000000P PS=460000U PD=560000U
* device instance $1809 r0 *1 60.405,47.28 nfet_01v8
M$1809 1985 3554 167 167 nfet_01v8 L=150000U W=210000U AS=40400000000P
+ AD=21875000000P PS=560000U PD=460000U
* device instance $1810 r0 *1 60.995,47.28 nfet_01v8
M$1810 1736 4372 167 167 nfet_01v8 L=150000U W=210000U AS=40400000000P
+ AD=21875000000P PS=560000U PD=460000U
* device instance $1811 r0 *1 60.44,47.68 nfet_01v8
M$1811 86 155 1985 167 nfet_01v8 L=150000U W=140000U AS=21875000000P
+ AD=16800000000P PS=460000U PD=380000U
* device instance $1812 r0 *1 60.96,47.68 nfet_01v8
M$1812 87 155 1736 167 nfet_01v8 L=150000U W=140000U AS=21875000000P
+ AD=16800000000P PS=460000U PD=380000U
* device instance $1813 r0 *1 60.44,48.07 nfet_01v8
M$1813 2097 156 86 167 nfet_01v8 L=150000U W=140000U AS=16800000000P
+ AD=21875000000P PS=380000U PD=460000U
* device instance $1814 r0 *1 60.96,48.07 nfet_01v8
M$1814 1180 156 87 167 nfet_01v8 L=150000U W=140000U AS=16800000000P
+ AD=21875000000P PS=380000U PD=460000U
* device instance $1815 r0 *1 60.405,48.47 nfet_01v8
M$1815 167 2193 2097 167 nfet_01v8 L=150000U W=210000U AS=21875000000P
+ AD=40400000000P PS=460000U PD=560000U
* device instance $1816 r0 *1 60.995,48.47 nfet_01v8
M$1816 167 1743 1180 167 nfet_01v8 L=150000U W=210000U AS=21875000000P
+ AD=40400000000P PS=460000U PD=560000U
* device instance $1817 r0 *1 60.405,48.86 nfet_01v8
M$1817 2193 2097 167 167 nfet_01v8 L=150000U W=210000U AS=40400000000P
+ AD=21875000000P PS=560000U PD=460000U
* device instance $1818 r0 *1 60.995,48.86 nfet_01v8
M$1818 1743 1180 167 167 nfet_01v8 L=150000U W=210000U AS=40400000000P
+ AD=21875000000P PS=560000U PD=460000U
* device instance $1819 r0 *1 60.44,49.26 nfet_01v8
M$1819 85 156 2193 167 nfet_01v8 L=150000U W=140000U AS=21875000000P
+ AD=16800000000P PS=460000U PD=380000U
* device instance $1820 r0 *1 60.96,49.26 nfet_01v8
M$1820 88 156 1743 167 nfet_01v8 L=150000U W=140000U AS=21875000000P
+ AD=16800000000P PS=460000U PD=380000U
* device instance $1821 r0 *1 60.44,49.65 nfet_01v8
M$1821 2317 157 85 167 nfet_01v8 L=150000U W=140000U AS=16800000000P
+ AD=21875000000P PS=380000U PD=460000U
* device instance $1822 r0 *1 60.96,49.65 nfet_01v8
M$1822 1153 157 88 167 nfet_01v8 L=150000U W=140000U AS=16800000000P
+ AD=21875000000P PS=380000U PD=460000U
* device instance $1823 r0 *1 60.405,50.05 nfet_01v8
M$1823 167 2651 2317 167 nfet_01v8 L=150000U W=210000U AS=21875000000P
+ AD=40400000000P PS=460000U PD=560000U
* device instance $1824 r0 *1 60.995,50.05 nfet_01v8
M$1824 167 1711 1153 167 nfet_01v8 L=150000U W=210000U AS=21875000000P
+ AD=40400000000P PS=460000U PD=560000U
* device instance $1825 r0 *1 60.405,50.44 nfet_01v8
M$1825 2651 2317 167 167 nfet_01v8 L=150000U W=210000U AS=40400000000P
+ AD=21875000000P PS=560000U PD=460000U
* device instance $1826 r0 *1 60.995,50.44 nfet_01v8
M$1826 1711 1153 167 167 nfet_01v8 L=150000U W=210000U AS=40400000000P
+ AD=21875000000P PS=560000U PD=460000U
* device instance $1827 r0 *1 60.44,50.84 nfet_01v8
M$1827 86 157 2651 167 nfet_01v8 L=150000U W=140000U AS=21875000000P
+ AD=16800000000P PS=460000U PD=380000U
* device instance $1828 r0 *1 60.96,50.84 nfet_01v8
M$1828 87 157 1711 167 nfet_01v8 L=150000U W=140000U AS=21875000000P
+ AD=16800000000P PS=460000U PD=380000U
* device instance $1829 r0 *1 5.94,29.11 nfet_01v8
M$1829 2412 146 6 167 nfet_01v8 L=150000U W=140000U AS=16800000000P
+ AD=21875000000P PS=380000U PD=460000U
* device instance $1830 r0 *1 6.46,29.11 nfet_01v8
M$1830 1356 146 7 167 nfet_01v8 L=150000U W=140000U AS=16800000000P
+ AD=21875000000P PS=380000U PD=460000U
* device instance $1831 r0 *1 5.905,29.51 nfet_01v8
M$1831 167 2836 2412 167 nfet_01v8 L=150000U W=210000U AS=21875000000P
+ AD=40400000000P PS=460000U PD=560000U
* device instance $1832 r0 *1 6.495,29.51 nfet_01v8
M$1832 167 1945 1356 167 nfet_01v8 L=150000U W=210000U AS=21875000000P
+ AD=40400000000P PS=460000U PD=560000U
* device instance $1833 r0 *1 5.905,29.9 nfet_01v8
M$1833 2836 2412 167 167 nfet_01v8 L=150000U W=210000U AS=40400000000P
+ AD=21875000000P PS=560000U PD=460000U
* device instance $1834 r0 *1 6.495,29.9 nfet_01v8
M$1834 1945 1356 167 167 nfet_01v8 L=150000U W=210000U AS=40400000000P
+ AD=21875000000P PS=560000U PD=460000U
* device instance $1835 r0 *1 5.94,30.3 nfet_01v8
M$1835 5 146 2836 167 nfet_01v8 L=150000U W=140000U AS=21875000000P
+ AD=16800000000P PS=460000U PD=380000U
* device instance $1836 r0 *1 6.46,30.3 nfet_01v8
M$1836 8 146 1945 167 nfet_01v8 L=150000U W=140000U AS=21875000000P
+ AD=16800000000P PS=460000U PD=380000U
* device instance $1837 r0 *1 5.94,30.69 nfet_01v8
M$1837 3264 147 5 167 nfet_01v8 L=150000U W=140000U AS=16800000000P
+ AD=21875000000P PS=380000U PD=460000U
* device instance $1838 r0 *1 6.46,30.69 nfet_01v8
M$1838 4537 147 8 167 nfet_01v8 L=150000U W=140000U AS=16800000000P
+ AD=21875000000P PS=380000U PD=460000U
* device instance $1839 r0 *1 5.905,31.09 nfet_01v8
M$1839 167 2224 3264 167 nfet_01v8 L=150000U W=210000U AS=21875000000P
+ AD=40400000000P PS=460000U PD=560000U
* device instance $1840 r0 *1 6.495,31.09 nfet_01v8
M$1840 167 1943 4537 167 nfet_01v8 L=150000U W=210000U AS=21875000000P
+ AD=40400000000P PS=460000U PD=560000U
* device instance $1841 r0 *1 5.905,31.48 nfet_01v8
M$1841 2224 3264 167 167 nfet_01v8 L=150000U W=210000U AS=40400000000P
+ AD=21875000000P PS=560000U PD=460000U
* device instance $1842 r0 *1 6.495,31.48 nfet_01v8
M$1842 1943 4537 167 167 nfet_01v8 L=150000U W=210000U AS=40400000000P
+ AD=21875000000P PS=560000U PD=460000U
* device instance $1843 r0 *1 5.94,31.88 nfet_01v8
M$1843 6 147 2224 167 nfet_01v8 L=150000U W=140000U AS=21875000000P
+ AD=16800000000P PS=460000U PD=380000U
* device instance $1844 r0 *1 6.46,31.88 nfet_01v8
M$1844 7 147 1943 167 nfet_01v8 L=150000U W=140000U AS=21875000000P
+ AD=16800000000P PS=460000U PD=380000U
* device instance $1845 r0 *1 5.94,32.27 nfet_01v8
M$1845 3263 148 6 167 nfet_01v8 L=150000U W=140000U AS=16800000000P
+ AD=21875000000P PS=380000U PD=460000U
* device instance $1846 r0 *1 6.46,32.27 nfet_01v8
M$1846 1353 148 7 167 nfet_01v8 L=150000U W=140000U AS=16800000000P
+ AD=21875000000P PS=380000U PD=460000U
* device instance $1847 r0 *1 5.905,32.67 nfet_01v8
M$1847 167 2227 3263 167 nfet_01v8 L=150000U W=210000U AS=21875000000P
+ AD=40400000000P PS=460000U PD=560000U
* device instance $1848 r0 *1 6.495,32.67 nfet_01v8
M$1848 167 1941 1353 167 nfet_01v8 L=150000U W=210000U AS=21875000000P
+ AD=40400000000P PS=460000U PD=560000U
* device instance $1849 r0 *1 5.905,33.06 nfet_01v8
M$1849 2227 3263 167 167 nfet_01v8 L=150000U W=210000U AS=40400000000P
+ AD=21875000000P PS=560000U PD=460000U
* device instance $1850 r0 *1 6.495,33.06 nfet_01v8
M$1850 1941 1353 167 167 nfet_01v8 L=150000U W=210000U AS=40400000000P
+ AD=21875000000P PS=560000U PD=460000U
* device instance $1851 r0 *1 5.94,33.46 nfet_01v8
M$1851 5 148 2227 167 nfet_01v8 L=150000U W=140000U AS=21875000000P
+ AD=16800000000P PS=460000U PD=380000U
* device instance $1852 r0 *1 6.46,33.46 nfet_01v8
M$1852 8 148 1941 167 nfet_01v8 L=150000U W=140000U AS=21875000000P
+ AD=16800000000P PS=460000U PD=380000U
* device instance $1853 r0 *1 5.94,33.85 nfet_01v8
M$1853 2424 149 5 167 nfet_01v8 L=150000U W=140000U AS=16800000000P
+ AD=21875000000P PS=380000U PD=460000U
* device instance $1854 r0 *1 6.46,33.85 nfet_01v8
M$1854 1351 149 8 167 nfet_01v8 L=150000U W=140000U AS=16800000000P
+ AD=21875000000P PS=380000U PD=460000U
* device instance $1855 r0 *1 5.905,34.25 nfet_01v8
M$1855 167 2859 2424 167 nfet_01v8 L=150000U W=210000U AS=21875000000P
+ AD=40400000000P PS=460000U PD=560000U
* device instance $1856 r0 *1 6.495,34.25 nfet_01v8
M$1856 167 1939 1351 167 nfet_01v8 L=150000U W=210000U AS=21875000000P
+ AD=40400000000P PS=460000U PD=560000U
* device instance $1857 r0 *1 5.905,34.64 nfet_01v8
M$1857 2859 2424 167 167 nfet_01v8 L=150000U W=210000U AS=40400000000P
+ AD=21875000000P PS=560000U PD=460000U
* device instance $1858 r0 *1 6.495,34.64 nfet_01v8
M$1858 1939 1351 167 167 nfet_01v8 L=150000U W=210000U AS=40400000000P
+ AD=21875000000P PS=560000U PD=460000U
* device instance $1859 r0 *1 5.94,35.04 nfet_01v8
M$1859 6 149 2859 167 nfet_01v8 L=150000U W=140000U AS=21875000000P
+ AD=16800000000P PS=460000U PD=380000U
* device instance $1860 r0 *1 6.46,35.04 nfet_01v8
M$1860 7 149 1939 167 nfet_01v8 L=150000U W=140000U AS=21875000000P
+ AD=16800000000P PS=460000U PD=380000U
* device instance $1861 r0 *1 49.54,60.71 nfet_01v8
M$1861 3566 162 70 167 nfet_01v8 L=150000U W=140000U AS=16800000000P
+ AD=21875000000P PS=380000U PD=460000U
* device instance $1862 r0 *1 50.06,60.71 nfet_01v8
M$1862 1102 162 71 167 nfet_01v8 L=150000U W=140000U AS=16800000000P
+ AD=21875000000P PS=380000U PD=460000U
* device instance $1863 r0 *1 49.505,61.11 nfet_01v8
M$1863 167 2571 3566 167 nfet_01v8 L=150000U W=210000U AS=21875000000P
+ AD=40400000000P PS=460000U PD=560000U
* device instance $1864 r0 *1 50.095,61.11 nfet_01v8
M$1864 167 1653 1102 167 nfet_01v8 L=150000U W=210000U AS=21875000000P
+ AD=40400000000P PS=460000U PD=560000U
* device instance $1865 r0 *1 49.505,61.5 nfet_01v8
M$1865 2571 3566 167 167 nfet_01v8 L=150000U W=210000U AS=40400000000P
+ AD=21875000000P PS=560000U PD=460000U
* device instance $1866 r0 *1 50.095,61.5 nfet_01v8
M$1866 1653 1102 167 167 nfet_01v8 L=150000U W=210000U AS=40400000000P
+ AD=21875000000P PS=560000U PD=460000U
* device instance $1867 r0 *1 49.54,61.9 nfet_01v8
M$1867 69 162 2571 167 nfet_01v8 L=150000U W=140000U AS=21875000000P
+ AD=16800000000P PS=460000U PD=380000U
* device instance $1868 r0 *1 50.06,61.9 nfet_01v8
M$1868 72 162 1653 167 nfet_01v8 L=150000U W=140000U AS=21875000000P
+ AD=16800000000P PS=460000U PD=380000U
* device instance $1869 r0 *1 49.54,62.29 nfet_01v8
M$1869 3150 163 69 167 nfet_01v8 L=150000U W=140000U AS=16800000000P
+ AD=21875000000P PS=380000U PD=460000U
* device instance $1870 r0 *1 50.06,62.29 nfet_01v8
M$1870 4490 163 72 167 nfet_01v8 L=150000U W=140000U AS=16800000000P
+ AD=21875000000P PS=380000U PD=460000U
* device instance $1871 r0 *1 49.505,62.69 nfet_01v8
M$1871 167 2631 3150 167 nfet_01v8 L=150000U W=210000U AS=21875000000P
+ AD=40400000000P PS=460000U PD=560000U
* device instance $1872 r0 *1 50.095,62.69 nfet_01v8
M$1872 167 1589 4490 167 nfet_01v8 L=150000U W=210000U AS=21875000000P
+ AD=40400000000P PS=460000U PD=560000U
* device instance $1873 r0 *1 49.505,63.08 nfet_01v8
M$1873 2631 3150 167 167 nfet_01v8 L=150000U W=210000U AS=40400000000P
+ AD=21875000000P PS=560000U PD=460000U
* device instance $1874 r0 *1 50.095,63.08 nfet_01v8
M$1874 1589 4490 167 167 nfet_01v8 L=150000U W=210000U AS=40400000000P
+ AD=21875000000P PS=560000U PD=460000U
* device instance $1875 r0 *1 49.54,63.48 nfet_01v8
M$1875 70 163 2631 167 nfet_01v8 L=150000U W=140000U AS=21875000000P
+ AD=16800000000P PS=460000U PD=380000U
* device instance $1876 r0 *1 50.06,63.48 nfet_01v8
M$1876 71 163 1589 167 nfet_01v8 L=150000U W=140000U AS=21875000000P
+ AD=16800000000P PS=460000U PD=380000U
* device instance $1877 r0 *1 49.54,63.87 nfet_01v8
M$1877 3144 164 70 167 nfet_01v8 L=150000U W=140000U AS=16800000000P
+ AD=21875000000P PS=380000U PD=460000U
* device instance $1878 r0 *1 50.06,63.87 nfet_01v8
M$1878 664 164 71 167 nfet_01v8 L=150000U W=140000U AS=16800000000P
+ AD=21875000000P PS=380000U PD=460000U
* device instance $1879 r0 *1 49.505,64.27 nfet_01v8
M$1879 167 2157 3144 167 nfet_01v8 L=150000U W=210000U AS=21875000000P
+ AD=40400000000P PS=460000U PD=560000U
* device instance $1880 r0 *1 50.095,64.27 nfet_01v8
M$1880 167 853 664 167 nfet_01v8 L=150000U W=210000U AS=21875000000P
+ AD=40400000000P PS=460000U PD=560000U
* device instance $1881 r0 *1 49.505,64.66 nfet_01v8
M$1881 2157 3144 167 167 nfet_01v8 L=150000U W=210000U AS=40400000000P
+ AD=21875000000P PS=560000U PD=460000U
* device instance $1882 r0 *1 50.095,64.66 nfet_01v8
M$1882 853 664 167 167 nfet_01v8 L=150000U W=210000U AS=40400000000P
+ AD=21875000000P PS=560000U PD=460000U
* device instance $1883 r0 *1 49.54,65.06 nfet_01v8
M$1883 69 164 2157 167 nfet_01v8 L=150000U W=140000U AS=21875000000P
+ AD=16800000000P PS=460000U PD=380000U
* device instance $1884 r0 *1 50.06,65.06 nfet_01v8
M$1884 72 164 853 167 nfet_01v8 L=150000U W=140000U AS=21875000000P
+ AD=16800000000P PS=460000U PD=380000U
* device instance $1885 r0 *1 49.54,65.45 nfet_01v8
M$1885 2329 165 69 167 nfet_01v8 L=150000U W=140000U AS=16800000000P
+ AD=21875000000P PS=380000U PD=460000U
* device instance $1886 r0 *1 50.06,65.45 nfet_01v8
M$1886 1238 165 72 167 nfet_01v8 L=150000U W=140000U AS=16800000000P
+ AD=21875000000P PS=380000U PD=460000U
* device instance $1887 r0 *1 49.505,65.85 nfet_01v8
M$1887 167 2674 2329 167 nfet_01v8 L=150000U W=210000U AS=21875000000P
+ AD=40400000000P PS=460000U PD=560000U
* device instance $1888 r0 *1 50.095,65.85 nfet_01v8
M$1888 167 1810 1238 167 nfet_01v8 L=150000U W=210000U AS=21875000000P
+ AD=40400000000P PS=460000U PD=560000U
* device instance $1889 r0 *1 49.505,66.24 nfet_01v8
M$1889 2674 2329 167 167 nfet_01v8 L=150000U W=210000U AS=40400000000P
+ AD=21875000000P PS=560000U PD=460000U
* device instance $1890 r0 *1 50.095,66.24 nfet_01v8
M$1890 1810 1238 167 167 nfet_01v8 L=150000U W=210000U AS=40400000000P
+ AD=21875000000P PS=560000U PD=460000U
* device instance $1891 r0 *1 49.54,66.64 nfet_01v8
M$1891 70 165 2674 167 nfet_01v8 L=150000U W=140000U AS=21875000000P
+ AD=16800000000P PS=460000U PD=380000U
* device instance $1892 r0 *1 50.06,66.64 nfet_01v8
M$1892 71 165 1810 167 nfet_01v8 L=150000U W=140000U AS=21875000000P
+ AD=16800000000P PS=460000U PD=380000U
* device instance $1893 r0 *1 5.94,44.91 nfet_01v8
M$1893 2516 154 6 167 nfet_01v8 L=150000U W=140000U AS=16800000000P
+ AD=21875000000P PS=380000U PD=460000U
* device instance $1894 r0 *1 6.46,44.91 nfet_01v8
M$1894 1327 154 7 167 nfet_01v8 L=150000U W=140000U AS=16800000000P
+ AD=21875000000P PS=380000U PD=460000U
* device instance $1895 r0 *1 5.905,45.31 nfet_01v8
M$1895 167 3067 2516 167 nfet_01v8 L=150000U W=210000U AS=21875000000P
+ AD=40400000000P PS=460000U PD=560000U
* device instance $1896 r0 *1 6.495,45.31 nfet_01v8
M$1896 167 1908 1327 167 nfet_01v8 L=150000U W=210000U AS=21875000000P
+ AD=40400000000P PS=460000U PD=560000U
* device instance $1897 r0 *1 5.905,45.7 nfet_01v8
M$1897 3067 2516 167 167 nfet_01v8 L=150000U W=210000U AS=40400000000P
+ AD=21875000000P PS=560000U PD=460000U
* device instance $1898 r0 *1 6.495,45.7 nfet_01v8
M$1898 1908 1327 167 167 nfet_01v8 L=150000U W=210000U AS=40400000000P
+ AD=21875000000P PS=560000U PD=460000U
* device instance $1899 r0 *1 5.94,46.1 nfet_01v8
M$1899 5 154 3067 167 nfet_01v8 L=150000U W=140000U AS=21875000000P
+ AD=16800000000P PS=460000U PD=380000U
* device instance $1900 r0 *1 6.46,46.1 nfet_01v8
M$1900 8 154 1908 167 nfet_01v8 L=150000U W=140000U AS=21875000000P
+ AD=16800000000P PS=460000U PD=380000U
* device instance $1901 r0 *1 5.94,46.49 nfet_01v8
M$1901 3753 155 5 167 nfet_01v8 L=150000U W=140000U AS=16800000000P
+ AD=21875000000P PS=380000U PD=460000U
* device instance $1902 r0 *1 6.46,46.49 nfet_01v8
M$1902 4452 155 8 167 nfet_01v8 L=150000U W=140000U AS=16800000000P
+ AD=21875000000P PS=380000U PD=460000U
* device instance $1903 r0 *1 5.905,46.89 nfet_01v8
M$1903 167 3063 3753 167 nfet_01v8 L=150000U W=210000U AS=21875000000P
+ AD=40400000000P PS=460000U PD=560000U
* device instance $1904 r0 *1 6.495,46.89 nfet_01v8
M$1904 167 1458 4452 167 nfet_01v8 L=150000U W=210000U AS=21875000000P
+ AD=40400000000P PS=460000U PD=560000U
* device instance $1905 r0 *1 5.905,47.28 nfet_01v8
M$1905 3063 3753 167 167 nfet_01v8 L=150000U W=210000U AS=40400000000P
+ AD=21875000000P PS=560000U PD=460000U
* device instance $1906 r0 *1 6.495,47.28 nfet_01v8
M$1906 1458 4452 167 167 nfet_01v8 L=150000U W=210000U AS=40400000000P
+ AD=21875000000P PS=560000U PD=460000U
* device instance $1907 r0 *1 5.94,47.68 nfet_01v8
M$1907 6 155 3063 167 nfet_01v8 L=150000U W=140000U AS=21875000000P
+ AD=16800000000P PS=460000U PD=380000U
* device instance $1908 r0 *1 6.46,47.68 nfet_01v8
M$1908 7 155 1458 167 nfet_01v8 L=150000U W=140000U AS=21875000000P
+ AD=16800000000P PS=460000U PD=380000U
* device instance $1909 r0 *1 5.94,48.07 nfet_01v8
M$1909 2071 156 6 167 nfet_01v8 L=150000U W=140000U AS=16800000000P
+ AD=21875000000P PS=380000U PD=460000U
* device instance $1910 r0 *1 6.46,48.07 nfet_01v8
M$1910 880 156 7 167 nfet_01v8 L=150000U W=140000U AS=16800000000P
+ AD=21875000000P PS=380000U PD=460000U
* device instance $1911 r0 *1 5.905,48.47 nfet_01v8
M$1911 167 2139 2071 167 nfet_01v8 L=150000U W=210000U AS=21875000000P
+ AD=40400000000P PS=460000U PD=560000U
* device instance $1912 r0 *1 6.495,48.47 nfet_01v8
M$1912 167 1390 880 167 nfet_01v8 L=150000U W=210000U AS=21875000000P
+ AD=40400000000P PS=460000U PD=560000U
* device instance $1913 r0 *1 5.905,48.86 nfet_01v8
M$1913 2139 2071 167 167 nfet_01v8 L=150000U W=210000U AS=40400000000P
+ AD=21875000000P PS=560000U PD=460000U
* device instance $1914 r0 *1 6.495,48.86 nfet_01v8
M$1914 1390 880 167 167 nfet_01v8 L=150000U W=210000U AS=40400000000P
+ AD=21875000000P PS=560000U PD=460000U
* device instance $1915 r0 *1 5.94,49.26 nfet_01v8
M$1915 5 156 2139 167 nfet_01v8 L=150000U W=140000U AS=21875000000P
+ AD=16800000000P PS=460000U PD=380000U
* device instance $1916 r0 *1 6.46,49.26 nfet_01v8
M$1916 8 156 1390 167 nfet_01v8 L=150000U W=140000U AS=21875000000P
+ AD=16800000000P PS=460000U PD=380000U
* device instance $1917 r0 *1 5.94,49.65 nfet_01v8
M$1917 2515 157 5 167 nfet_01v8 L=150000U W=140000U AS=16800000000P
+ AD=21875000000P PS=380000U PD=460000U
* device instance $1918 r0 *1 6.46,49.65 nfet_01v8
M$1918 937 157 8 167 nfet_01v8 L=150000U W=140000U AS=16800000000P
+ AD=21875000000P PS=380000U PD=460000U
* device instance $1919 r0 *1 5.905,50.05 nfet_01v8
M$1919 167 3066 2515 167 nfet_01v8 L=150000U W=210000U AS=21875000000P
+ AD=40400000000P PS=460000U PD=560000U
* device instance $1920 r0 *1 6.495,50.05 nfet_01v8
M$1920 167 1460 937 167 nfet_01v8 L=150000U W=210000U AS=21875000000P
+ AD=40400000000P PS=460000U PD=560000U
* device instance $1921 r0 *1 5.905,50.44 nfet_01v8
M$1921 3066 2515 167 167 nfet_01v8 L=150000U W=210000U AS=40400000000P
+ AD=21875000000P PS=560000U PD=460000U
* device instance $1922 r0 *1 6.495,50.44 nfet_01v8
M$1922 1460 937 167 167 nfet_01v8 L=150000U W=210000U AS=40400000000P
+ AD=21875000000P PS=560000U PD=460000U
* device instance $1923 r0 *1 5.94,50.84 nfet_01v8
M$1923 6 157 3066 167 nfet_01v8 L=150000U W=140000U AS=21875000000P
+ AD=16800000000P PS=460000U PD=380000U
* device instance $1924 r0 *1 6.46,50.84 nfet_01v8
M$1924 7 157 1460 167 nfet_01v8 L=150000U W=140000U AS=21875000000P
+ AD=16800000000P PS=460000U PD=380000U
* device instance $1925 r0 *1 16.84,44.91 nfet_01v8
M$1925 3745 154 22 167 nfet_01v8 L=150000U W=140000U AS=16800000000P
+ AD=21875000000P PS=380000U PD=460000U
* device instance $1926 r0 *1 17.36,44.91 nfet_01v8
M$1926 875 154 23 167 nfet_01v8 L=150000U W=140000U AS=16800000000P
+ AD=21875000000P PS=380000U PD=460000U
* device instance $1927 r0 *1 16.805,45.31 nfet_01v8
M$1927 167 3123 3745 167 nfet_01v8 L=150000U W=210000U AS=21875000000P
+ AD=40400000000P PS=460000U PD=560000U
* device instance $1928 r0 *1 17.395,45.31 nfet_01v8
M$1928 167 1384 875 167 nfet_01v8 L=150000U W=210000U AS=21875000000P
+ AD=40400000000P PS=460000U PD=560000U
* device instance $1929 r0 *1 16.805,45.7 nfet_01v8
M$1929 3123 3745 167 167 nfet_01v8 L=150000U W=210000U AS=40400000000P
+ AD=21875000000P PS=560000U PD=460000U
* device instance $1930 r0 *1 17.395,45.7 nfet_01v8
M$1930 1384 875 167 167 nfet_01v8 L=150000U W=210000U AS=40400000000P
+ AD=21875000000P PS=560000U PD=460000U
* device instance $1931 r0 *1 16.84,46.1 nfet_01v8
M$1931 21 154 3123 167 nfet_01v8 L=150000U W=140000U AS=21875000000P
+ AD=16800000000P PS=460000U PD=380000U
* device instance $1932 r0 *1 17.36,46.1 nfet_01v8
M$1932 24 154 1384 167 nfet_01v8 L=150000U W=140000U AS=21875000000P
+ AD=16800000000P PS=460000U PD=380000U
* device instance $1933 r0 *1 16.84,46.49 nfet_01v8
M$1933 3746 155 21 167 nfet_01v8 L=150000U W=140000U AS=16800000000P
+ AD=21875000000P PS=380000U PD=460000U
* device instance $1934 r0 *1 17.36,46.49 nfet_01v8
M$1934 4468 155 24 167 nfet_01v8 L=150000U W=140000U AS=16800000000P
+ AD=21875000000P PS=380000U PD=460000U
* device instance $1935 r0 *1 16.805,46.89 nfet_01v8
M$1935 167 2962 3746 167 nfet_01v8 L=150000U W=210000U AS=21875000000P
+ AD=40400000000P PS=460000U PD=560000U
* device instance $1936 r0 *1 17.395,46.89 nfet_01v8
M$1936 167 1457 4468 167 nfet_01v8 L=150000U W=210000U AS=21875000000P
+ AD=40400000000P PS=460000U PD=560000U
* device instance $1937 r0 *1 16.805,47.28 nfet_01v8
M$1937 2962 3746 167 167 nfet_01v8 L=150000U W=210000U AS=40400000000P
+ AD=21875000000P PS=560000U PD=460000U
* device instance $1938 r0 *1 17.395,47.28 nfet_01v8
M$1938 1457 4468 167 167 nfet_01v8 L=150000U W=210000U AS=40400000000P
+ AD=21875000000P PS=560000U PD=460000U
* device instance $1939 r0 *1 16.84,47.68 nfet_01v8
M$1939 22 155 2962 167 nfet_01v8 L=150000U W=140000U AS=21875000000P
+ AD=16800000000P PS=460000U PD=380000U
* device instance $1940 r0 *1 17.36,47.68 nfet_01v8
M$1940 23 155 1457 167 nfet_01v8 L=150000U W=140000U AS=21875000000P
+ AD=16800000000P PS=460000U PD=380000U
* device instance $1941 r0 *1 16.84,48.07 nfet_01v8
M$1941 3744 156 22 167 nfet_01v8 L=150000U W=140000U AS=16800000000P
+ AD=21875000000P PS=380000U PD=460000U
* device instance $1942 r0 *1 17.36,48.07 nfet_01v8
M$1942 895 156 23 167 nfet_01v8 L=150000U W=140000U AS=16800000000P
+ AD=21875000000P PS=380000U PD=460000U
* device instance $1943 r0 *1 16.805,48.47 nfet_01v8
M$1943 167 2963 3744 167 nfet_01v8 L=150000U W=210000U AS=21875000000P
+ AD=40400000000P PS=460000U PD=560000U
* device instance $1944 r0 *1 17.395,48.47 nfet_01v8
M$1944 167 1412 895 167 nfet_01v8 L=150000U W=210000U AS=21875000000P
+ AD=40400000000P PS=460000U PD=560000U
* device instance $1945 r0 *1 16.805,48.86 nfet_01v8
M$1945 2963 3744 167 167 nfet_01v8 L=150000U W=210000U AS=40400000000P
+ AD=21875000000P PS=560000U PD=460000U
* device instance $1946 r0 *1 17.395,48.86 nfet_01v8
M$1946 1412 895 167 167 nfet_01v8 L=150000U W=210000U AS=40400000000P
+ AD=21875000000P PS=560000U PD=460000U
* device instance $1947 r0 *1 16.84,49.26 nfet_01v8
M$1947 21 156 2963 167 nfet_01v8 L=150000U W=140000U AS=21875000000P
+ AD=16800000000P PS=460000U PD=380000U
* device instance $1948 r0 *1 17.36,49.26 nfet_01v8
M$1948 24 156 1412 167 nfet_01v8 L=150000U W=140000U AS=21875000000P
+ AD=16800000000P PS=460000U PD=380000U
* device instance $1949 r0 *1 16.84,49.65 nfet_01v8
M$1949 3743 157 21 167 nfet_01v8 L=150000U W=140000U AS=16800000000P
+ AD=21875000000P PS=380000U PD=460000U
* device instance $1950 r0 *1 17.36,49.65 nfet_01v8
M$1950 912 157 24 167 nfet_01v8 L=150000U W=140000U AS=16800000000P
+ AD=21875000000P PS=380000U PD=460000U
* device instance $1951 r0 *1 16.805,50.05 nfet_01v8
M$1951 167 2961 3743 167 nfet_01v8 L=150000U W=210000U AS=21875000000P
+ AD=40400000000P PS=460000U PD=560000U
* device instance $1952 r0 *1 17.395,50.05 nfet_01v8
M$1952 167 1429 912 167 nfet_01v8 L=150000U W=210000U AS=21875000000P
+ AD=40400000000P PS=460000U PD=560000U
* device instance $1953 r0 *1 16.805,50.44 nfet_01v8
M$1953 2961 3743 167 167 nfet_01v8 L=150000U W=210000U AS=40400000000P
+ AD=21875000000P PS=560000U PD=460000U
* device instance $1954 r0 *1 17.395,50.44 nfet_01v8
M$1954 1429 912 167 167 nfet_01v8 L=150000U W=210000U AS=40400000000P
+ AD=21875000000P PS=560000U PD=460000U
* device instance $1955 r0 *1 16.84,50.84 nfet_01v8
M$1955 22 157 2961 167 nfet_01v8 L=150000U W=140000U AS=21875000000P
+ AD=16800000000P PS=460000U PD=380000U
* device instance $1956 r0 *1 17.36,50.84 nfet_01v8
M$1956 23 157 1429 167 nfet_01v8 L=150000U W=140000U AS=21875000000P
+ AD=16800000000P PS=460000U PD=380000U
* device instance $1957 r0 *1 27.74,44.91 nfet_01v8
M$1957 3622 154 38 167 nfet_01v8 L=150000U W=140000U AS=16800000000P
+ AD=21875000000P PS=380000U PD=460000U
* device instance $1958 r0 *1 28.26,44.91 nfet_01v8
M$1958 1243 154 39 167 nfet_01v8 L=150000U W=140000U AS=16800000000P
+ AD=21875000000P PS=380000U PD=460000U
* device instance $1959 r0 *1 27.705,45.31 nfet_01v8
M$1959 167 2801 3622 167 nfet_01v8 L=150000U W=210000U AS=21875000000P
+ AD=40400000000P PS=460000U PD=560000U
* device instance $1960 r0 *1 28.295,45.31 nfet_01v8
M$1960 167 1815 1243 167 nfet_01v8 L=150000U W=210000U AS=21875000000P
+ AD=40400000000P PS=460000U PD=560000U
* device instance $1961 r0 *1 27.705,45.7 nfet_01v8
M$1961 2801 3622 167 167 nfet_01v8 L=150000U W=210000U AS=40400000000P
+ AD=21875000000P PS=560000U PD=460000U
* device instance $1962 r0 *1 28.295,45.7 nfet_01v8
M$1962 1815 1243 167 167 nfet_01v8 L=150000U W=210000U AS=40400000000P
+ AD=21875000000P PS=560000U PD=460000U
* device instance $1963 r0 *1 27.74,46.1 nfet_01v8
M$1963 37 154 2801 167 nfet_01v8 L=150000U W=140000U AS=21875000000P
+ AD=16800000000P PS=460000U PD=380000U
* device instance $1964 r0 *1 28.26,46.1 nfet_01v8
M$1964 40 154 1815 167 nfet_01v8 L=150000U W=140000U AS=21875000000P
+ AD=16800000000P PS=460000U PD=380000U
* device instance $1965 r0 *1 27.74,46.49 nfet_01v8
M$1965 3623 155 37 167 nfet_01v8 L=150000U W=140000U AS=16800000000P
+ AD=21875000000P PS=380000U PD=460000U
* device instance $1966 r0 *1 28.26,46.49 nfet_01v8
M$1966 4394 155 40 167 nfet_01v8 L=150000U W=140000U AS=16800000000P
+ AD=21875000000P PS=380000U PD=460000U
* device instance $1967 r0 *1 27.705,46.89 nfet_01v8
M$1967 167 2137 3623 167 nfet_01v8 L=150000U W=210000U AS=21875000000P
+ AD=40400000000P PS=460000U PD=560000U
* device instance $1968 r0 *1 28.295,46.89 nfet_01v8
M$1968 167 697 4394 167 nfet_01v8 L=150000U W=210000U AS=21875000000P
+ AD=40400000000P PS=460000U PD=560000U
* device instance $1969 r0 *1 27.705,47.28 nfet_01v8
M$1969 2137 3623 167 167 nfet_01v8 L=150000U W=210000U AS=40400000000P
+ AD=21875000000P PS=560000U PD=460000U
* device instance $1970 r0 *1 28.295,47.28 nfet_01v8
M$1970 697 4394 167 167 nfet_01v8 L=150000U W=210000U AS=40400000000P
+ AD=21875000000P PS=560000U PD=460000U
* device instance $1971 r0 *1 27.74,47.68 nfet_01v8
M$1971 38 155 2137 167 nfet_01v8 L=150000U W=140000U AS=21875000000P
+ AD=16800000000P PS=460000U PD=380000U
* device instance $1972 r0 *1 28.26,47.68 nfet_01v8
M$1972 39 155 697 167 nfet_01v8 L=150000U W=140000U AS=21875000000P
+ AD=16800000000P PS=460000U PD=380000U
* device instance $1973 r0 *1 27.74,48.07 nfet_01v8
M$1973 2390 156 38 167 nfet_01v8 L=150000U W=140000U AS=16800000000P
+ AD=21875000000P PS=380000U PD=460000U
* device instance $1974 r0 *1 28.26,48.07 nfet_01v8
M$1974 1265 156 39 167 nfet_01v8 L=150000U W=140000U AS=16800000000P
+ AD=21875000000P PS=380000U PD=460000U
* device instance $1975 r0 *1 27.705,48.47 nfet_01v8
M$1975 167 2800 2390 167 nfet_01v8 L=150000U W=210000U AS=21875000000P
+ AD=40400000000P PS=460000U PD=560000U
* device instance $1976 r0 *1 28.295,48.47 nfet_01v8
M$1976 167 1842 1265 167 nfet_01v8 L=150000U W=210000U AS=21875000000P
+ AD=40400000000P PS=460000U PD=560000U
* device instance $1977 r0 *1 27.705,48.86 nfet_01v8
M$1977 2800 2390 167 167 nfet_01v8 L=150000U W=210000U AS=40400000000P
+ AD=21875000000P PS=560000U PD=460000U
* device instance $1978 r0 *1 28.295,48.86 nfet_01v8
M$1978 1842 1265 167 167 nfet_01v8 L=150000U W=210000U AS=40400000000P
+ AD=21875000000P PS=560000U PD=460000U
* device instance $1979 r0 *1 27.74,49.26 nfet_01v8
M$1979 37 156 2800 167 nfet_01v8 L=150000U W=140000U AS=21875000000P
+ AD=16800000000P PS=460000U PD=380000U
* device instance $1980 r0 *1 28.26,49.26 nfet_01v8
M$1980 40 156 1842 167 nfet_01v8 L=150000U W=140000U AS=21875000000P
+ AD=16800000000P PS=460000U PD=380000U
* device instance $1981 r0 *1 27.74,49.65 nfet_01v8
M$1981 2388 157 37 167 nfet_01v8 L=150000U W=140000U AS=16800000000P
+ AD=21875000000P PS=380000U PD=460000U
* device instance $1982 r0 *1 28.26,49.65 nfet_01v8
M$1982 1281 157 40 167 nfet_01v8 L=150000U W=140000U AS=16800000000P
+ AD=21875000000P PS=380000U PD=460000U
* device instance $1983 r0 *1 27.705,50.05 nfet_01v8
M$1983 167 2796 2388 167 nfet_01v8 L=150000U W=210000U AS=21875000000P
+ AD=40400000000P PS=460000U PD=560000U
* device instance $1984 r0 *1 28.295,50.05 nfet_01v8
M$1984 167 1858 1281 167 nfet_01v8 L=150000U W=210000U AS=21875000000P
+ AD=40400000000P PS=460000U PD=560000U
* device instance $1985 r0 *1 27.705,50.44 nfet_01v8
M$1985 2796 2388 167 167 nfet_01v8 L=150000U W=210000U AS=40400000000P
+ AD=21875000000P PS=560000U PD=460000U
* device instance $1986 r0 *1 28.295,50.44 nfet_01v8
M$1986 1858 1281 167 167 nfet_01v8 L=150000U W=210000U AS=40400000000P
+ AD=21875000000P PS=560000U PD=460000U
* device instance $1987 r0 *1 27.74,50.84 nfet_01v8
M$1987 38 157 2796 167 nfet_01v8 L=150000U W=140000U AS=21875000000P
+ AD=16800000000P PS=460000U PD=380000U
* device instance $1988 r0 *1 28.26,50.84 nfet_01v8
M$1988 39 157 1858 167 nfet_01v8 L=150000U W=140000U AS=21875000000P
+ AD=16800000000P PS=460000U PD=380000U
* device instance $1989 r0 *1 38.64,44.91 nfet_01v8
M$1989 3645 154 54 167 nfet_01v8 L=150000U W=140000U AS=16800000000P
+ AD=21875000000P PS=380000U PD=460000U
* device instance $1990 r0 *1 39.16,44.91 nfet_01v8
M$1990 1202 154 55 167 nfet_01v8 L=150000U W=140000U AS=16800000000P
+ AD=21875000000P PS=380000U PD=460000U
* device instance $1991 r0 *1 38.605,45.31 nfet_01v8
M$1991 167 2755 3645 167 nfet_01v8 L=150000U W=210000U AS=21875000000P
+ AD=40400000000P PS=460000U PD=560000U
* device instance $1992 r0 *1 39.195,45.31 nfet_01v8
M$1992 167 1772 1202 167 nfet_01v8 L=150000U W=210000U AS=21875000000P
+ AD=40400000000P PS=460000U PD=560000U
* device instance $1993 r0 *1 38.605,45.7 nfet_01v8
M$1993 2755 3645 167 167 nfet_01v8 L=150000U W=210000U AS=40400000000P
+ AD=21875000000P PS=560000U PD=460000U
* device instance $1994 r0 *1 39.195,45.7 nfet_01v8
M$1994 1772 1202 167 167 nfet_01v8 L=150000U W=210000U AS=40400000000P
+ AD=21875000000P PS=560000U PD=460000U
* device instance $1995 r0 *1 38.64,46.1 nfet_01v8
M$1995 53 154 2755 167 nfet_01v8 L=150000U W=140000U AS=21875000000P
+ AD=16800000000P PS=460000U PD=380000U
* device instance $1996 r0 *1 39.16,46.1 nfet_01v8
M$1996 56 154 1772 167 nfet_01v8 L=150000U W=140000U AS=21875000000P
+ AD=16800000000P PS=460000U PD=380000U
* device instance $1997 r0 *1 38.64,46.49 nfet_01v8
M$1997 3641 155 53 167 nfet_01v8 L=150000U W=140000U AS=16800000000P
+ AD=21875000000P PS=380000U PD=460000U
* device instance $1998 r0 *1 39.16,46.49 nfet_01v8
M$1998 4391 155 56 167 nfet_01v8 L=150000U W=140000U AS=16800000000P
+ AD=21875000000P PS=380000U PD=460000U
* device instance $1999 r0 *1 38.605,46.89 nfet_01v8
M$1999 167 2013 3641 167 nfet_01v8 L=150000U W=210000U AS=21875000000P
+ AD=40400000000P PS=460000U PD=560000U
* device instance $2000 r0 *1 39.195,46.89 nfet_01v8
M$2000 167 739 4391 167 nfet_01v8 L=150000U W=210000U AS=21875000000P
+ AD=40400000000P PS=460000U PD=560000U
* device instance $2001 r0 *1 38.605,47.28 nfet_01v8
M$2001 2013 3641 167 167 nfet_01v8 L=150000U W=210000U AS=40400000000P
+ AD=21875000000P PS=560000U PD=460000U
* device instance $2002 r0 *1 39.195,47.28 nfet_01v8
M$2002 739 4391 167 167 nfet_01v8 L=150000U W=210000U AS=40400000000P
+ AD=21875000000P PS=560000U PD=460000U
* device instance $2003 r0 *1 38.64,47.68 nfet_01v8
M$2003 54 155 2013 167 nfet_01v8 L=150000U W=140000U AS=21875000000P
+ AD=16800000000P PS=460000U PD=380000U
* device instance $2004 r0 *1 39.16,47.68 nfet_01v8
M$2004 55 155 739 167 nfet_01v8 L=150000U W=140000U AS=21875000000P
+ AD=16800000000P PS=460000U PD=380000U
* device instance $2005 r0 *1 38.64,48.07 nfet_01v8
M$2005 2082 156 54 167 nfet_01v8 L=150000U W=140000U AS=16800000000P
+ AD=21875000000P PS=380000U PD=460000U
* device instance $2006 r0 *1 39.16,48.07 nfet_01v8
M$2006 613 156 55 167 nfet_01v8 L=150000U W=140000U AS=16800000000P
+ AD=21875000000P PS=380000U PD=460000U
* device instance $2007 r0 *1 38.605,48.47 nfet_01v8
M$2007 167 2162 2082 167 nfet_01v8 L=150000U W=210000U AS=21875000000P
+ AD=40400000000P PS=460000U PD=560000U
* device instance $2008 r0 *1 39.195,48.47 nfet_01v8
M$2008 167 748 613 167 nfet_01v8 L=150000U W=210000U AS=21875000000P
+ AD=40400000000P PS=460000U PD=560000U
* device instance $2009 r0 *1 38.605,48.86 nfet_01v8
M$2009 2162 2082 167 167 nfet_01v8 L=150000U W=210000U AS=40400000000P
+ AD=21875000000P PS=560000U PD=460000U
* device instance $2010 r0 *1 39.195,48.86 nfet_01v8
M$2010 748 613 167 167 nfet_01v8 L=150000U W=210000U AS=40400000000P
+ AD=21875000000P PS=560000U PD=460000U
* device instance $2011 r0 *1 38.64,49.26 nfet_01v8
M$2011 53 156 2162 167 nfet_01v8 L=150000U W=140000U AS=21875000000P
+ AD=16800000000P PS=460000U PD=380000U
* device instance $2012 r0 *1 39.16,49.26 nfet_01v8
M$2012 56 156 748 167 nfet_01v8 L=150000U W=140000U AS=21875000000P
+ AD=16800000000P PS=460000U PD=380000U
* device instance $2013 r0 *1 38.64,49.65 nfet_01v8
M$2013 2360 157 53 167 nfet_01v8 L=150000U W=140000U AS=16800000000P
+ AD=21875000000P PS=380000U PD=460000U
* device instance $2014 r0 *1 39.16,49.65 nfet_01v8
M$2014 1192 157 56 167 nfet_01v8 L=150000U W=140000U AS=16800000000P
+ AD=21875000000P PS=380000U PD=460000U
* device instance $2015 r0 *1 38.605,50.05 nfet_01v8
M$2015 167 2748 2360 167 nfet_01v8 L=150000U W=210000U AS=21875000000P
+ AD=40400000000P PS=460000U PD=560000U
* device instance $2016 r0 *1 39.195,50.05 nfet_01v8
M$2016 167 1758 1192 167 nfet_01v8 L=150000U W=210000U AS=21875000000P
+ AD=40400000000P PS=460000U PD=560000U
* device instance $2017 r0 *1 38.605,50.44 nfet_01v8
M$2017 2748 2360 167 167 nfet_01v8 L=150000U W=210000U AS=40400000000P
+ AD=21875000000P PS=560000U PD=460000U
* device instance $2018 r0 *1 39.195,50.44 nfet_01v8
M$2018 1758 1192 167 167 nfet_01v8 L=150000U W=210000U AS=40400000000P
+ AD=21875000000P PS=560000U PD=460000U
* device instance $2019 r0 *1 38.64,50.84 nfet_01v8
M$2019 54 157 2748 167 nfet_01v8 L=150000U W=140000U AS=21875000000P
+ AD=16800000000P PS=460000U PD=380000U
* device instance $2020 r0 *1 39.16,50.84 nfet_01v8
M$2020 55 157 1758 167 nfet_01v8 L=150000U W=140000U AS=21875000000P
+ AD=16800000000P PS=460000U PD=380000U
* device instance $2021 r0 *1 49.54,44.91 nfet_01v8
M$2021 2330 154 70 167 nfet_01v8 L=150000U W=140000U AS=16800000000P
+ AD=21875000000P PS=380000U PD=460000U
* device instance $2022 r0 *1 50.06,44.91 nfet_01v8
M$2022 1138 154 71 167 nfet_01v8 L=150000U W=140000U AS=16800000000P
+ AD=21875000000P PS=380000U PD=460000U
* device instance $2023 r0 *1 49.505,45.31 nfet_01v8
M$2023 167 2675 2330 167 nfet_01v8 L=150000U W=210000U AS=21875000000P
+ AD=40400000000P PS=460000U PD=560000U
* device instance $2024 r0 *1 50.095,45.31 nfet_01v8
M$2024 167 1695 1138 167 nfet_01v8 L=150000U W=210000U AS=21875000000P
+ AD=40400000000P PS=460000U PD=560000U
* device instance $2025 r0 *1 49.505,45.7 nfet_01v8
M$2025 2675 2330 167 167 nfet_01v8 L=150000U W=210000U AS=40400000000P
+ AD=21875000000P PS=560000U PD=460000U
* device instance $2026 r0 *1 50.095,45.7 nfet_01v8
M$2026 1695 1138 167 167 nfet_01v8 L=150000U W=210000U AS=40400000000P
+ AD=21875000000P PS=560000U PD=460000U
* device instance $2027 r0 *1 49.54,46.1 nfet_01v8
M$2027 69 154 2675 167 nfet_01v8 L=150000U W=140000U AS=21875000000P
+ AD=16800000000P PS=460000U PD=380000U
* device instance $2028 r0 *1 50.06,46.1 nfet_01v8
M$2028 72 154 1695 167 nfet_01v8 L=150000U W=140000U AS=21875000000P
+ AD=16800000000P PS=460000U PD=380000U
* device instance $2029 r0 *1 49.54,46.49 nfet_01v8
M$2029 3561 155 69 167 nfet_01v8 L=150000U W=140000U AS=16800000000P
+ AD=21875000000P PS=380000U PD=460000U
* device instance $2030 r0 *1 50.06,46.49 nfet_01v8
M$2030 4349 155 72 167 nfet_01v8 L=150000U W=140000U AS=16800000000P
+ AD=21875000000P PS=380000U PD=460000U
* device instance $2031 r0 *1 49.505,46.89 nfet_01v8
M$2031 167 1993 3561 167 nfet_01v8 L=150000U W=210000U AS=21875000000P
+ AD=40400000000P PS=460000U PD=560000U
* device instance $2032 r0 *1 50.095,46.89 nfet_01v8
M$2032 167 1509 4349 167 nfet_01v8 L=150000U W=210000U AS=21875000000P
+ AD=40400000000P PS=460000U PD=560000U
* device instance $2033 r0 *1 49.505,47.28 nfet_01v8
M$2033 1993 3561 167 167 nfet_01v8 L=150000U W=210000U AS=40400000000P
+ AD=21875000000P PS=560000U PD=460000U
* device instance $2034 r0 *1 50.095,47.28 nfet_01v8
M$2034 1509 4349 167 167 nfet_01v8 L=150000U W=210000U AS=40400000000P
+ AD=21875000000P PS=560000U PD=460000U
* device instance $2035 r0 *1 49.54,47.68 nfet_01v8
M$2035 70 155 1993 167 nfet_01v8 L=150000U W=140000U AS=21875000000P
+ AD=16800000000P PS=460000U PD=380000U
* device instance $2036 r0 *1 50.06,47.68 nfet_01v8
M$2036 71 155 1509 167 nfet_01v8 L=150000U W=140000U AS=21875000000P
+ AD=16800000000P PS=460000U PD=380000U
* device instance $2037 r0 *1 49.54,48.07 nfet_01v8
M$2037 2328 156 70 167 nfet_01v8 L=150000U W=140000U AS=16800000000P
+ AD=21875000000P PS=380000U PD=460000U
* device instance $2038 r0 *1 50.06,48.07 nfet_01v8
M$2038 1143 156 71 167 nfet_01v8 L=150000U W=140000U AS=16800000000P
+ AD=21875000000P PS=380000U PD=460000U
* device instance $2039 r0 *1 49.505,48.47 nfet_01v8
M$2039 167 2673 2328 167 nfet_01v8 L=150000U W=210000U AS=21875000000P
+ AD=40400000000P PS=460000U PD=560000U
* device instance $2040 r0 *1 50.095,48.47 nfet_01v8
M$2040 167 1700 1143 167 nfet_01v8 L=150000U W=210000U AS=21875000000P
+ AD=40400000000P PS=460000U PD=560000U
* device instance $2041 r0 *1 49.505,48.86 nfet_01v8
M$2041 2673 2328 167 167 nfet_01v8 L=150000U W=210000U AS=40400000000P
+ AD=21875000000P PS=560000U PD=460000U
* device instance $2042 r0 *1 50.095,48.86 nfet_01v8
M$2042 1700 1143 167 167 nfet_01v8 L=150000U W=210000U AS=40400000000P
+ AD=21875000000P PS=560000U PD=460000U
* device instance $2043 r0 *1 49.54,49.26 nfet_01v8
M$2043 69 156 2673 167 nfet_01v8 L=150000U W=140000U AS=21875000000P
+ AD=16800000000P PS=460000U PD=380000U
* device instance $2044 r0 *1 50.06,49.26 nfet_01v8
M$2044 72 156 1700 167 nfet_01v8 L=150000U W=140000U AS=21875000000P
+ AD=16800000000P PS=460000U PD=380000U
* device instance $2045 r0 *1 49.54,49.65 nfet_01v8
M$2045 2327 157 69 167 nfet_01v8 L=150000U W=140000U AS=16800000000P
+ AD=21875000000P PS=380000U PD=460000U
* device instance $2046 r0 *1 50.06,49.65 nfet_01v8
M$2046 1147 157 72 167 nfet_01v8 L=150000U W=140000U AS=16800000000P
+ AD=21875000000P PS=380000U PD=460000U
* device instance $2047 r0 *1 49.505,50.05 nfet_01v8
M$2047 167 2671 2327 167 nfet_01v8 L=150000U W=210000U AS=21875000000P
+ AD=40400000000P PS=460000U PD=560000U
* device instance $2048 r0 *1 50.095,50.05 nfet_01v8
M$2048 167 1704 1147 167 nfet_01v8 L=150000U W=210000U AS=21875000000P
+ AD=40400000000P PS=460000U PD=560000U
* device instance $2049 r0 *1 49.505,50.44 nfet_01v8
M$2049 2671 2327 167 167 nfet_01v8 L=150000U W=210000U AS=40400000000P
+ AD=21875000000P PS=560000U PD=460000U
* device instance $2050 r0 *1 50.095,50.44 nfet_01v8
M$2050 1704 1147 167 167 nfet_01v8 L=150000U W=210000U AS=40400000000P
+ AD=21875000000P PS=560000U PD=460000U
* device instance $2051 r0 *1 49.54,50.84 nfet_01v8
M$2051 70 157 2671 167 nfet_01v8 L=150000U W=140000U AS=21875000000P
+ AD=16800000000P PS=460000U PD=380000U
* device instance $2052 r0 *1 50.06,50.84 nfet_01v8
M$2052 71 157 1704 167 nfet_01v8 L=150000U W=140000U AS=21875000000P
+ AD=16800000000P PS=460000U PD=380000U
* device instance $2053 r0 *1 60.44,60.71 nfet_01v8
M$2053 2272 162 86 167 nfet_01v8 L=150000U W=140000U AS=16800000000P
+ AD=21875000000P PS=380000U PD=460000U
* device instance $2054 r0 *1 60.96,60.71 nfet_01v8
M$2054 1062 162 87 167 nfet_01v8 L=150000U W=140000U AS=16800000000P
+ AD=21875000000P PS=380000U PD=460000U
* device instance $2055 r0 *1 60.405,61.11 nfet_01v8
M$2055 167 2558 2272 167 nfet_01v8 L=150000U W=210000U AS=21875000000P
+ AD=40400000000P PS=460000U PD=560000U
* device instance $2056 r0 *1 60.995,61.11 nfet_01v8
M$2056 167 1606 1062 167 nfet_01v8 L=150000U W=210000U AS=21875000000P
+ AD=40400000000P PS=460000U PD=560000U
* device instance $2057 r0 *1 60.405,61.5 nfet_01v8
M$2057 2558 2272 167 167 nfet_01v8 L=150000U W=210000U AS=40400000000P
+ AD=21875000000P PS=560000U PD=460000U
* device instance $2058 r0 *1 60.995,61.5 nfet_01v8
M$2058 1606 1062 167 167 nfet_01v8 L=150000U W=210000U AS=40400000000P
+ AD=21875000000P PS=560000U PD=460000U
* device instance $2059 r0 *1 60.44,61.9 nfet_01v8
M$2059 85 162 2558 167 nfet_01v8 L=150000U W=140000U AS=21875000000P
+ AD=16800000000P PS=460000U PD=380000U
* device instance $2060 r0 *1 60.96,61.9 nfet_01v8
M$2060 88 162 1606 167 nfet_01v8 L=150000U W=140000U AS=21875000000P
+ AD=16800000000P PS=460000U PD=380000U
* device instance $2061 r0 *1 60.44,62.29 nfet_01v8
M$2061 3164 163 85 167 nfet_01v8 L=150000U W=140000U AS=16800000000P
+ AD=21875000000P PS=380000U PD=460000U
* device instance $2062 r0 *1 60.96,62.29 nfet_01v8
M$2062 4451 163 88 167 nfet_01v8 L=150000U W=140000U AS=16800000000P
+ AD=21875000000P PS=380000U PD=460000U
* device instance $2063 r0 *1 60.405,62.69 nfet_01v8
M$2063 167 2045 3164 167 nfet_01v8 L=150000U W=210000U AS=21875000000P
+ AD=40400000000P PS=460000U PD=560000U
* device instance $2064 r0 *1 60.995,62.69 nfet_01v8
M$2064 167 763 4451 167 nfet_01v8 L=150000U W=210000U AS=21875000000P
+ AD=40400000000P PS=460000U PD=560000U
* device instance $2065 r0 *1 60.405,63.08 nfet_01v8
M$2065 2045 3164 167 167 nfet_01v8 L=150000U W=210000U AS=40400000000P
+ AD=21875000000P PS=560000U PD=460000U
* device instance $2066 r0 *1 60.995,63.08 nfet_01v8
M$2066 763 4451 167 167 nfet_01v8 L=150000U W=210000U AS=40400000000P
+ AD=21875000000P PS=560000U PD=460000U
* device instance $2067 r0 *1 60.44,63.48 nfet_01v8
M$2067 86 163 2045 167 nfet_01v8 L=150000U W=140000U AS=21875000000P
+ AD=16800000000P PS=460000U PD=380000U
* device instance $2068 r0 *1 60.96,63.48 nfet_01v8
M$2068 87 163 763 167 nfet_01v8 L=150000U W=140000U AS=21875000000P
+ AD=16800000000P PS=460000U PD=380000U
* device instance $2069 r0 *1 60.44,63.87 nfet_01v8
M$2069 2069 164 86 167 nfet_01v8 L=150000U W=140000U AS=16800000000P
+ AD=21875000000P PS=380000U PD=460000U
* device instance $2070 r0 *1 60.96,63.87 nfet_01v8
M$2070 621 164 87 167 nfet_01v8 L=150000U W=140000U AS=16800000000P
+ AD=21875000000P PS=380000U PD=460000U
* device instance $2071 r0 *1 60.405,64.27 nfet_01v8
M$2071 167 2128 2069 167 nfet_01v8 L=150000U W=210000U AS=21875000000P
+ AD=40400000000P PS=460000U PD=560000U
* device instance $2072 r0 *1 60.995,64.27 nfet_01v8
M$2072 167 764 621 167 nfet_01v8 L=150000U W=210000U AS=21875000000P
+ AD=40400000000P PS=460000U PD=560000U
* device instance $2073 r0 *1 60.405,64.66 nfet_01v8
M$2073 2128 2069 167 167 nfet_01v8 L=150000U W=210000U AS=40400000000P
+ AD=21875000000P PS=560000U PD=460000U
* device instance $2074 r0 *1 60.995,64.66 nfet_01v8
M$2074 764 621 167 167 nfet_01v8 L=150000U W=210000U AS=40400000000P
+ AD=21875000000P PS=560000U PD=460000U
* device instance $2075 r0 *1 60.44,65.06 nfet_01v8
M$2075 85 164 2128 167 nfet_01v8 L=150000U W=140000U AS=21875000000P
+ AD=16800000000P PS=460000U PD=380000U
* device instance $2076 r0 *1 60.96,65.06 nfet_01v8
M$2076 88 164 764 167 nfet_01v8 L=150000U W=140000U AS=21875000000P
+ AD=16800000000P PS=460000U PD=380000U
* device instance $2077 r0 *1 60.44,65.45 nfet_01v8
M$2077 3154 165 85 167 nfet_01v8 L=150000U W=140000U AS=16800000000P
+ AD=21875000000P PS=380000U PD=460000U
* device instance $2078 r0 *1 60.96,65.45 nfet_01v8
M$2078 885 165 88 167 nfet_01v8 L=150000U W=140000U AS=16800000000P
+ AD=21875000000P PS=380000U PD=460000U
* device instance $2079 r0 *1 60.405,65.85 nfet_01v8
M$2079 167 3023 3154 167 nfet_01v8 L=150000U W=210000U AS=21875000000P
+ AD=40400000000P PS=460000U PD=560000U
* device instance $2080 r0 *1 60.995,65.85 nfet_01v8
M$2080 167 1396 885 167 nfet_01v8 L=150000U W=210000U AS=21875000000P
+ AD=40400000000P PS=460000U PD=560000U
* device instance $2081 r0 *1 60.405,66.24 nfet_01v8
M$2081 3023 3154 167 167 nfet_01v8 L=150000U W=210000U AS=40400000000P
+ AD=21875000000P PS=560000U PD=460000U
* device instance $2082 r0 *1 60.995,66.24 nfet_01v8
M$2082 1396 885 167 167 nfet_01v8 L=150000U W=210000U AS=40400000000P
+ AD=21875000000P PS=560000U PD=460000U
* device instance $2083 r0 *1 60.44,66.64 nfet_01v8
M$2083 86 165 3023 167 nfet_01v8 L=150000U W=140000U AS=21875000000P
+ AD=16800000000P PS=460000U PD=380000U
* device instance $2084 r0 *1 60.96,66.64 nfet_01v8
M$2084 87 165 1396 167 nfet_01v8 L=150000U W=140000U AS=21875000000P
+ AD=16800000000P PS=460000U PD=380000U
* device instance $2085 r0 *1 82.24,52.81 nfet_01v8
M$2085 2535 158 118 167 nfet_01v8 L=150000U W=140000U AS=16800000000P
+ AD=21875000000P PS=380000U PD=460000U
* device instance $2086 r0 *1 82.76,52.81 nfet_01v8
M$2086 1067 158 119 167 nfet_01v8 L=150000U W=140000U AS=16800000000P
+ AD=21875000000P PS=380000U PD=460000U
* device instance $2087 r0 *1 82.205,53.21 nfet_01v8
M$2087 167 3105 2535 167 nfet_01v8 L=150000U W=210000U AS=21875000000P
+ AD=40400000000P PS=460000U PD=560000U
* device instance $2088 r0 *1 82.795,53.21 nfet_01v8
M$2088 167 1611 1067 167 nfet_01v8 L=150000U W=210000U AS=21875000000P
+ AD=40400000000P PS=460000U PD=560000U
* device instance $2089 r0 *1 82.205,53.6 nfet_01v8
M$2089 3105 2535 167 167 nfet_01v8 L=150000U W=210000U AS=40400000000P
+ AD=21875000000P PS=560000U PD=460000U
* device instance $2090 r0 *1 82.795,53.6 nfet_01v8
M$2090 1611 1067 167 167 nfet_01v8 L=150000U W=210000U AS=40400000000P
+ AD=21875000000P PS=560000U PD=460000U
* device instance $2091 r0 *1 82.24,54 nfet_01v8
M$2091 117 158 3105 167 nfet_01v8 L=150000U W=140000U AS=21875000000P
+ AD=16800000000P PS=460000U PD=380000U
* device instance $2092 r0 *1 82.76,54 nfet_01v8
M$2092 120 158 1611 167 nfet_01v8 L=150000U W=140000U AS=21875000000P
+ AD=16800000000P PS=460000U PD=380000U
* device instance $2093 r0 *1 82.24,54.39 nfet_01v8
M$2093 3135 159 117 167 nfet_01v8 L=150000U W=140000U AS=16800000000P
+ AD=21875000000P PS=380000U PD=460000U
* device instance $2094 r0 *1 82.76,54.39 nfet_01v8
M$2094 4407 159 120 167 nfet_01v8 L=150000U W=140000U AS=16800000000P
+ AD=21875000000P PS=380000U PD=460000U
* device instance $2095 r0 *1 82.205,54.79 nfet_01v8
M$2095 167 2020 3135 167 nfet_01v8 L=150000U W=210000U AS=21875000000P
+ AD=40400000000P PS=460000U PD=560000U
* device instance $2096 r0 *1 82.795,54.79 nfet_01v8
M$2096 167 746 4407 167 nfet_01v8 L=150000U W=210000U AS=21875000000P
+ AD=40400000000P PS=460000U PD=560000U
* device instance $2097 r0 *1 82.205,55.18 nfet_01v8
M$2097 2020 3135 167 167 nfet_01v8 L=150000U W=210000U AS=40400000000P
+ AD=21875000000P PS=560000U PD=460000U
* device instance $2098 r0 *1 82.795,55.18 nfet_01v8
M$2098 746 4407 167 167 nfet_01v8 L=150000U W=210000U AS=40400000000P
+ AD=21875000000P PS=560000U PD=460000U
* device instance $2099 r0 *1 82.24,55.58 nfet_01v8
M$2099 118 159 2020 167 nfet_01v8 L=150000U W=140000U AS=21875000000P
+ AD=16800000000P PS=460000U PD=380000U
* device instance $2100 r0 *1 82.76,55.58 nfet_01v8
M$2100 119 159 746 167 nfet_01v8 L=150000U W=140000U AS=21875000000P
+ AD=16800000000P PS=460000U PD=380000U
* device instance $2101 r0 *1 82.24,55.97 nfet_01v8
M$2101 3128 160 118 167 nfet_01v8 L=150000U W=140000U AS=16800000000P
+ AD=21875000000P PS=380000U PD=460000U
* device instance $2102 r0 *1 82.76,55.97 nfet_01v8
M$2102 605 160 119 167 nfet_01v8 L=150000U W=140000U AS=16800000000P
+ AD=21875000000P PS=380000U PD=460000U
* device instance $2103 r0 *1 82.205,56.37 nfet_01v8
M$2103 167 2135 3128 167 nfet_01v8 L=150000U W=210000U AS=21875000000P
+ AD=40400000000P PS=460000U PD=560000U
* device instance $2104 r0 *1 82.795,56.37 nfet_01v8
M$2104 167 728 605 167 nfet_01v8 L=150000U W=210000U AS=21875000000P
+ AD=40400000000P PS=460000U PD=560000U
* device instance $2105 r0 *1 82.205,56.76 nfet_01v8
M$2105 2135 3128 167 167 nfet_01v8 L=150000U W=210000U AS=40400000000P
+ AD=21875000000P PS=560000U PD=460000U
* device instance $2106 r0 *1 82.795,56.76 nfet_01v8
M$2106 728 605 167 167 nfet_01v8 L=150000U W=210000U AS=40400000000P
+ AD=21875000000P PS=560000U PD=460000U
* device instance $2107 r0 *1 82.24,57.16 nfet_01v8
M$2107 117 160 2135 167 nfet_01v8 L=150000U W=140000U AS=21875000000P
+ AD=16800000000P PS=460000U PD=380000U
* device instance $2108 r0 *1 82.76,57.16 nfet_01v8
M$2108 120 160 728 167 nfet_01v8 L=150000U W=140000U AS=21875000000P
+ AD=16800000000P PS=460000U PD=380000U
* device instance $2109 r0 *1 82.24,57.55 nfet_01v8
M$2109 3174 161 117 167 nfet_01v8 L=150000U W=140000U AS=16800000000P
+ AD=21875000000P PS=380000U PD=460000U
* device instance $2110 r0 *1 82.76,57.55 nfet_01v8
M$2110 1241 161 120 167 nfet_01v8 L=150000U W=140000U AS=16800000000P
+ AD=21875000000P PS=380000U PD=460000U
* device instance $2111 r0 *1 82.205,57.95 nfet_01v8
M$2111 167 2773 3174 167 nfet_01v8 L=150000U W=210000U AS=21875000000P
+ AD=40400000000P PS=460000U PD=560000U
* device instance $2112 r0 *1 82.795,57.95 nfet_01v8
M$2112 167 1813 1241 167 nfet_01v8 L=150000U W=210000U AS=21875000000P
+ AD=40400000000P PS=460000U PD=560000U
* device instance $2113 r0 *1 82.205,58.34 nfet_01v8
M$2113 2773 3174 167 167 nfet_01v8 L=150000U W=210000U AS=40400000000P
+ AD=21875000000P PS=560000U PD=460000U
* device instance $2114 r0 *1 82.795,58.34 nfet_01v8
M$2114 1813 1241 167 167 nfet_01v8 L=150000U W=210000U AS=40400000000P
+ AD=21875000000P PS=560000U PD=460000U
* device instance $2115 r0 *1 82.24,58.74 nfet_01v8
M$2115 118 161 2773 167 nfet_01v8 L=150000U W=140000U AS=21875000000P
+ AD=16800000000P PS=460000U PD=380000U
* device instance $2116 r0 *1 82.76,58.74 nfet_01v8
M$2116 119 161 1813 167 nfet_01v8 L=150000U W=140000U AS=21875000000P
+ AD=16800000000P PS=460000U PD=380000U
* device instance $2117 r0 *1 82.24,60.71 nfet_01v8
M$2117 2387 162 118 167 nfet_01v8 L=150000U W=140000U AS=16800000000P
+ AD=21875000000P PS=380000U PD=460000U
* device instance $2118 r0 *1 82.76,60.71 nfet_01v8
M$2118 1287 162 119 167 nfet_01v8 L=150000U W=140000U AS=16800000000P
+ AD=21875000000P PS=380000U PD=460000U
* device instance $2119 r0 *1 82.205,61.11 nfet_01v8
M$2119 167 2793 2387 167 nfet_01v8 L=150000U W=210000U AS=21875000000P
+ AD=40400000000P PS=460000U PD=560000U
* device instance $2120 r0 *1 82.795,61.11 nfet_01v8
M$2120 167 1864 1287 167 nfet_01v8 L=150000U W=210000U AS=21875000000P
+ AD=40400000000P PS=460000U PD=560000U
* device instance $2121 r0 *1 82.205,61.5 nfet_01v8
M$2121 2793 2387 167 167 nfet_01v8 L=150000U W=210000U AS=40400000000P
+ AD=21875000000P PS=560000U PD=460000U
* device instance $2122 r0 *1 82.795,61.5 nfet_01v8
M$2122 1864 1287 167 167 nfet_01v8 L=150000U W=210000U AS=40400000000P
+ AD=21875000000P PS=560000U PD=460000U
* device instance $2123 r0 *1 82.24,61.9 nfet_01v8
M$2123 117 162 2793 167 nfet_01v8 L=150000U W=140000U AS=21875000000P
+ AD=16800000000P PS=460000U PD=380000U
* device instance $2124 r0 *1 82.76,61.9 nfet_01v8
M$2124 120 162 1864 167 nfet_01v8 L=150000U W=140000U AS=21875000000P
+ AD=16800000000P PS=460000U PD=380000U
* device instance $2125 r0 *1 82.24,62.29 nfet_01v8
M$2125 3125 163 117 167 nfet_01v8 L=150000U W=140000U AS=16800000000P
+ AD=21875000000P PS=380000U PD=460000U
* device instance $2126 r0 *1 82.76,62.29 nfet_01v8
M$2126 4309 163 120 167 nfet_01v8 L=150000U W=140000U AS=16800000000P
+ AD=21875000000P PS=380000U PD=460000U
* device instance $2127 r0 *1 82.205,62.69 nfet_01v8
M$2127 167 2143 3125 167 nfet_01v8 L=150000U W=210000U AS=21875000000P
+ AD=40400000000P PS=460000U PD=560000U
* device instance $2128 r0 *1 82.795,62.69 nfet_01v8
M$2128 167 822 4309 167 nfet_01v8 L=150000U W=210000U AS=21875000000P
+ AD=40400000000P PS=460000U PD=560000U
* device instance $2129 r0 *1 82.205,63.08 nfet_01v8
M$2129 2143 3125 167 167 nfet_01v8 L=150000U W=210000U AS=40400000000P
+ AD=21875000000P PS=560000U PD=460000U
* device instance $2130 r0 *1 82.795,63.08 nfet_01v8
M$2130 822 4309 167 167 nfet_01v8 L=150000U W=210000U AS=40400000000P
+ AD=21875000000P PS=560000U PD=460000U
* device instance $2131 r0 *1 82.24,63.48 nfet_01v8
M$2131 118 163 2143 167 nfet_01v8 L=150000U W=140000U AS=21875000000P
+ AD=16800000000P PS=460000U PD=380000U
* device instance $2132 r0 *1 82.76,63.48 nfet_01v8
M$2132 119 163 822 167 nfet_01v8 L=150000U W=140000U AS=21875000000P
+ AD=16800000000P PS=460000U PD=380000U
* device instance $2133 r0 *1 82.24,63.87 nfet_01v8
M$2133 2076 164 118 167 nfet_01v8 L=150000U W=140000U AS=16800000000P
+ AD=21875000000P PS=380000U PD=460000U
* device instance $2134 r0 *1 82.76,63.87 nfet_01v8
M$2134 662 164 119 167 nfet_01v8 L=150000U W=140000U AS=16800000000P
+ AD=21875000000P PS=380000U PD=460000U
* device instance $2135 r0 *1 82.205,64.27 nfet_01v8
M$2135 167 2152 2076 167 nfet_01v8 L=150000U W=210000U AS=21875000000P
+ AD=40400000000P PS=460000U PD=560000U
* device instance $2136 r0 *1 82.795,64.27 nfet_01v8
M$2136 167 847 662 167 nfet_01v8 L=150000U W=210000U AS=21875000000P
+ AD=40400000000P PS=460000U PD=560000U
* device instance $2137 r0 *1 82.205,64.66 nfet_01v8
M$2137 2152 2076 167 167 nfet_01v8 L=150000U W=210000U AS=40400000000P
+ AD=21875000000P PS=560000U PD=460000U
* device instance $2138 r0 *1 82.795,64.66 nfet_01v8
M$2138 847 662 167 167 nfet_01v8 L=150000U W=210000U AS=40400000000P
+ AD=21875000000P PS=560000U PD=460000U
* device instance $2139 r0 *1 82.24,65.06 nfet_01v8
M$2139 117 164 2152 167 nfet_01v8 L=150000U W=140000U AS=21875000000P
+ AD=16800000000P PS=460000U PD=380000U
* device instance $2140 r0 *1 82.76,65.06 nfet_01v8
M$2140 120 164 847 167 nfet_01v8 L=150000U W=140000U AS=21875000000P
+ AD=16800000000P PS=460000U PD=380000U
* device instance $2141 r0 *1 82.24,65.45 nfet_01v8
M$2141 2348 165 117 167 nfet_01v8 L=150000U W=140000U AS=16800000000P
+ AD=21875000000P PS=380000U PD=460000U
* device instance $2142 r0 *1 82.76,65.45 nfet_01v8
M$2142 1126 165 120 167 nfet_01v8 L=150000U W=140000U AS=16800000000P
+ AD=21875000000P PS=380000U PD=460000U
* device instance $2143 r0 *1 82.205,65.85 nfet_01v8
M$2143 167 2723 2348 167 nfet_01v8 L=150000U W=210000U AS=21875000000P
+ AD=40400000000P PS=460000U PD=560000U
* device instance $2144 r0 *1 82.795,65.85 nfet_01v8
M$2144 167 1681 1126 167 nfet_01v8 L=150000U W=210000U AS=21875000000P
+ AD=40400000000P PS=460000U PD=560000U
* device instance $2145 r0 *1 82.205,66.24 nfet_01v8
M$2145 2723 2348 167 167 nfet_01v8 L=150000U W=210000U AS=40400000000P
+ AD=21875000000P PS=560000U PD=460000U
* device instance $2146 r0 *1 82.795,66.24 nfet_01v8
M$2146 1681 1126 167 167 nfet_01v8 L=150000U W=210000U AS=40400000000P
+ AD=21875000000P PS=560000U PD=460000U
* device instance $2147 r0 *1 82.24,66.64 nfet_01v8
M$2147 118 165 2723 167 nfet_01v8 L=150000U W=140000U AS=21875000000P
+ AD=16800000000P PS=460000U PD=380000U
* device instance $2148 r0 *1 82.76,66.64 nfet_01v8
M$2148 119 165 1681 167 nfet_01v8 L=150000U W=140000U AS=21875000000P
+ AD=16800000000P PS=460000U PD=380000U
* device instance $2149 r0 *1 16.84,13.31 nfet_01v8
M$2149 3303 138 22 167 nfet_01v8 L=150000U W=140000U AS=16800000000P
+ AD=21875000000P PS=380000U PD=460000U
* device instance $2150 r0 *1 17.36,13.31 nfet_01v8
M$2150 1333 138 23 167 nfet_01v8 L=150000U W=140000U AS=16800000000P
+ AD=21875000000P PS=380000U PD=460000U
* device instance $2151 r0 *1 16.805,13.71 nfet_01v8
M$2151 167 2779 3303 167 nfet_01v8 L=150000U W=210000U AS=21875000000P
+ AD=40400000000P PS=460000U PD=560000U
* device instance $2152 r0 *1 17.395,13.71 nfet_01v8
M$2152 167 1915 1333 167 nfet_01v8 L=150000U W=210000U AS=21875000000P
+ AD=40400000000P PS=460000U PD=560000U
* device instance $2153 r0 *1 16.805,14.1 nfet_01v8
M$2153 2779 3303 167 167 nfet_01v8 L=150000U W=210000U AS=40400000000P
+ AD=21875000000P PS=560000U PD=460000U
* device instance $2154 r0 *1 17.395,14.1 nfet_01v8
M$2154 1915 1333 167 167 nfet_01v8 L=150000U W=210000U AS=40400000000P
+ AD=21875000000P PS=560000U PD=460000U
* device instance $2155 r0 *1 16.84,14.5 nfet_01v8
M$2155 21 138 2779 167 nfet_01v8 L=150000U W=140000U AS=21875000000P
+ AD=16800000000P PS=460000U PD=380000U
* device instance $2156 r0 *1 17.36,14.5 nfet_01v8
M$2156 24 138 1915 167 nfet_01v8 L=150000U W=140000U AS=21875000000P
+ AD=16800000000P PS=460000U PD=380000U
* device instance $2157 r0 *1 16.84,14.89 nfet_01v8
M$2157 3296 139 21 167 nfet_01v8 L=150000U W=140000U AS=16800000000P
+ AD=21875000000P PS=380000U PD=460000U
* device instance $2158 r0 *1 17.36,14.89 nfet_01v8
M$2158 4483 139 24 167 nfet_01v8 L=150000U W=140000U AS=16800000000P
+ AD=21875000000P PS=380000U PD=460000U
* device instance $2159 r0 *1 16.805,15.29 nfet_01v8
M$2159 167 1992 3296 167 nfet_01v8 L=150000U W=210000U AS=21875000000P
+ AD=40400000000P PS=460000U PD=560000U
* device instance $2160 r0 *1 17.395,15.29 nfet_01v8
M$2160 167 798 4483 167 nfet_01v8 L=150000U W=210000U AS=21875000000P
+ AD=40400000000P PS=460000U PD=560000U
* device instance $2161 r0 *1 16.805,15.68 nfet_01v8
M$2161 1992 3296 167 167 nfet_01v8 L=150000U W=210000U AS=40400000000P
+ AD=21875000000P PS=560000U PD=460000U
* device instance $2162 r0 *1 17.395,15.68 nfet_01v8
M$2162 798 4483 167 167 nfet_01v8 L=150000U W=210000U AS=40400000000P
+ AD=21875000000P PS=560000U PD=460000U
* device instance $2163 r0 *1 16.84,16.08 nfet_01v8
M$2163 22 139 1992 167 nfet_01v8 L=150000U W=140000U AS=21875000000P
+ AD=16800000000P PS=460000U PD=380000U
* device instance $2164 r0 *1 17.36,16.08 nfet_01v8
M$2164 23 139 798 167 nfet_01v8 L=150000U W=140000U AS=21875000000P
+ AD=16800000000P PS=460000U PD=380000U
* device instance $2165 r0 *1 16.84,16.47 nfet_01v8
M$2165 3302 140 22 167 nfet_01v8 L=150000U W=140000U AS=16800000000P
+ AD=21875000000P PS=380000U PD=460000U
* device instance $2166 r0 *1 17.36,16.47 nfet_01v8
M$2166 1338 140 23 167 nfet_01v8 L=150000U W=140000U AS=16800000000P
+ AD=21875000000P PS=380000U PD=460000U
* device instance $2167 r0 *1 16.805,16.87 nfet_01v8
M$2167 167 2701 3302 167 nfet_01v8 L=150000U W=210000U AS=21875000000P
+ AD=40400000000P PS=460000U PD=560000U
* device instance $2168 r0 *1 17.395,16.87 nfet_01v8
M$2168 167 1920 1338 167 nfet_01v8 L=150000U W=210000U AS=21875000000P
+ AD=40400000000P PS=460000U PD=560000U
* device instance $2169 r0 *1 16.805,17.26 nfet_01v8
M$2169 2701 3302 167 167 nfet_01v8 L=150000U W=210000U AS=40400000000P
+ AD=21875000000P PS=560000U PD=460000U
* device instance $2170 r0 *1 17.395,17.26 nfet_01v8
M$2170 1920 1338 167 167 nfet_01v8 L=150000U W=210000U AS=40400000000P
+ AD=21875000000P PS=560000U PD=460000U
* device instance $2171 r0 *1 16.84,17.66 nfet_01v8
M$2171 21 140 2701 167 nfet_01v8 L=150000U W=140000U AS=21875000000P
+ AD=16800000000P PS=460000U PD=380000U
* device instance $2172 r0 *1 17.36,17.66 nfet_01v8
M$2172 24 140 1920 167 nfet_01v8 L=150000U W=140000U AS=21875000000P
+ AD=16800000000P PS=460000U PD=380000U
* device instance $2173 r0 *1 16.84,18.05 nfet_01v8
M$2173 3301 141 21 167 nfet_01v8 L=150000U W=140000U AS=16800000000P
+ AD=21875000000P PS=380000U PD=460000U
* device instance $2174 r0 *1 17.36,18.05 nfet_01v8
M$2174 1336 141 24 167 nfet_01v8 L=150000U W=140000U AS=16800000000P
+ AD=21875000000P PS=380000U PD=460000U
* device instance $2175 r0 *1 16.805,18.45 nfet_01v8
M$2175 167 2704 3301 167 nfet_01v8 L=150000U W=210000U AS=21875000000P
+ AD=40400000000P PS=460000U PD=560000U
* device instance $2176 r0 *1 17.395,18.45 nfet_01v8
M$2176 167 1918 1336 167 nfet_01v8 L=150000U W=210000U AS=21875000000P
+ AD=40400000000P PS=460000U PD=560000U
* device instance $2177 r0 *1 16.805,18.84 nfet_01v8
M$2177 2704 3301 167 167 nfet_01v8 L=150000U W=210000U AS=40400000000P
+ AD=21875000000P PS=560000U PD=460000U
* device instance $2178 r0 *1 17.395,18.84 nfet_01v8
M$2178 1918 1336 167 167 nfet_01v8 L=150000U W=210000U AS=40400000000P
+ AD=21875000000P PS=560000U PD=460000U
* device instance $2179 r0 *1 16.84,19.24 nfet_01v8
M$2179 22 141 2704 167 nfet_01v8 L=150000U W=140000U AS=21875000000P
+ AD=16800000000P PS=460000U PD=380000U
* device instance $2180 r0 *1 17.36,19.24 nfet_01v8
M$2180 23 141 1918 167 nfet_01v8 L=150000U W=140000U AS=21875000000P
+ AD=16800000000P PS=460000U PD=380000U
* device instance $2181 r0 *1 27.74,13.31 nfet_01v8
M$2181 3253 138 38 167 nfet_01v8 L=150000U W=140000U AS=16800000000P
+ AD=21875000000P PS=380000U PD=460000U
* device instance $2182 r0 *1 28.26,13.31 nfet_01v8
M$2182 1026 138 39 167 nfet_01v8 L=150000U W=140000U AS=16800000000P
+ AD=21875000000P PS=380000U PD=460000U
* device instance $2183 r0 *1 27.705,13.71 nfet_01v8
M$2183 167 3021 3253 167 nfet_01v8 L=150000U W=210000U AS=21875000000P
+ AD=40400000000P PS=460000U PD=560000U
* device instance $2184 r0 *1 28.295,13.71 nfet_01v8
M$2184 167 1564 1026 167 nfet_01v8 L=150000U W=210000U AS=21875000000P
+ AD=40400000000P PS=460000U PD=560000U
* device instance $2185 r0 *1 27.705,14.1 nfet_01v8
M$2185 3021 3253 167 167 nfet_01v8 L=150000U W=210000U AS=40400000000P
+ AD=21875000000P PS=560000U PD=460000U
* device instance $2186 r0 *1 28.295,14.1 nfet_01v8
M$2186 1564 1026 167 167 nfet_01v8 L=150000U W=210000U AS=40400000000P
+ AD=21875000000P PS=560000U PD=460000U
* device instance $2187 r0 *1 27.74,14.5 nfet_01v8
M$2187 37 138 3021 167 nfet_01v8 L=150000U W=140000U AS=21875000000P
+ AD=16800000000P PS=460000U PD=380000U
* device instance $2188 r0 *1 28.26,14.5 nfet_01v8
M$2188 40 138 1564 167 nfet_01v8 L=150000U W=140000U AS=21875000000P
+ AD=16800000000P PS=460000U PD=380000U
* device instance $2189 r0 *1 27.74,14.89 nfet_01v8
M$2189 3249 139 37 167 nfet_01v8 L=150000U W=140000U AS=16800000000P
+ AD=21875000000P PS=380000U PD=460000U
* device instance $2190 r0 *1 28.26,14.89 nfet_01v8
M$2190 4279 139 40 167 nfet_01v8 L=150000U W=140000U AS=16800000000P
+ AD=21875000000P PS=380000U PD=460000U
* device instance $2191 r0 *1 27.705,15.29 nfet_01v8
M$2191 167 3031 3249 167 nfet_01v8 L=150000U W=210000U AS=21875000000P
+ AD=40400000000P PS=460000U PD=560000U
* device instance $2192 r0 *1 28.295,15.29 nfet_01v8
M$2192 167 794 4279 167 nfet_01v8 L=150000U W=210000U AS=21875000000P
+ AD=40400000000P PS=460000U PD=560000U
* device instance $2193 r0 *1 27.705,15.68 nfet_01v8
M$2193 3031 3249 167 167 nfet_01v8 L=150000U W=210000U AS=40400000000P
+ AD=21875000000P PS=560000U PD=460000U
* device instance $2194 r0 *1 28.295,15.68 nfet_01v8
M$2194 794 4279 167 167 nfet_01v8 L=150000U W=210000U AS=40400000000P
+ AD=21875000000P PS=560000U PD=460000U
* device instance $2195 r0 *1 27.74,16.08 nfet_01v8
M$2195 38 139 3031 167 nfet_01v8 L=150000U W=140000U AS=21875000000P
+ AD=16800000000P PS=460000U PD=380000U
* device instance $2196 r0 *1 28.26,16.08 nfet_01v8
M$2196 39 139 794 167 nfet_01v8 L=150000U W=140000U AS=21875000000P
+ AD=16800000000P PS=460000U PD=380000U
* device instance $2197 r0 *1 27.74,16.47 nfet_01v8
M$2197 3252 140 38 167 nfet_01v8 L=150000U W=140000U AS=16800000000P
+ AD=21875000000P PS=380000U PD=460000U
* device instance $2198 r0 *1 28.26,16.47 nfet_01v8
M$2198 1048 140 39 167 nfet_01v8 L=150000U W=140000U AS=16800000000P
+ AD=21875000000P PS=380000U PD=460000U
* device instance $2199 r0 *1 27.705,16.87 nfet_01v8
M$2199 167 3019 3252 167 nfet_01v8 L=150000U W=210000U AS=21875000000P
+ AD=40400000000P PS=460000U PD=560000U
* device instance $2200 r0 *1 28.295,16.87 nfet_01v8
M$2200 167 1591 1048 167 nfet_01v8 L=150000U W=210000U AS=21875000000P
+ AD=40400000000P PS=460000U PD=560000U
* device instance $2201 r0 *1 27.705,17.26 nfet_01v8
M$2201 3019 3252 167 167 nfet_01v8 L=150000U W=210000U AS=40400000000P
+ AD=21875000000P PS=560000U PD=460000U
* device instance $2202 r0 *1 28.295,17.26 nfet_01v8
M$2202 1591 1048 167 167 nfet_01v8 L=150000U W=210000U AS=40400000000P
+ AD=21875000000P PS=560000U PD=460000U
* device instance $2203 r0 *1 27.74,17.66 nfet_01v8
M$2203 37 140 3019 167 nfet_01v8 L=150000U W=140000U AS=21875000000P
+ AD=16800000000P PS=460000U PD=380000U
* device instance $2204 r0 *1 28.26,17.66 nfet_01v8
M$2204 40 140 1591 167 nfet_01v8 L=150000U W=140000U AS=21875000000P
+ AD=16800000000P PS=460000U PD=380000U
* device instance $2205 r0 *1 27.74,18.05 nfet_01v8
M$2205 2488 141 37 167 nfet_01v8 L=150000U W=140000U AS=16800000000P
+ AD=21875000000P PS=380000U PD=460000U
* device instance $2206 r0 *1 28.26,18.05 nfet_01v8
M$2206 1056 141 40 167 nfet_01v8 L=150000U W=140000U AS=16800000000P
+ AD=21875000000P PS=380000U PD=460000U
* device instance $2207 r0 *1 27.705,18.45 nfet_01v8
M$2207 167 2997 2488 167 nfet_01v8 L=150000U W=210000U AS=21875000000P
+ AD=40400000000P PS=460000U PD=560000U
* device instance $2208 r0 *1 28.295,18.45 nfet_01v8
M$2208 167 1600 1056 167 nfet_01v8 L=150000U W=210000U AS=21875000000P
+ AD=40400000000P PS=460000U PD=560000U
* device instance $2209 r0 *1 27.705,18.84 nfet_01v8
M$2209 2997 2488 167 167 nfet_01v8 L=150000U W=210000U AS=40400000000P
+ AD=21875000000P PS=560000U PD=460000U
* device instance $2210 r0 *1 28.295,18.84 nfet_01v8
M$2210 1600 1056 167 167 nfet_01v8 L=150000U W=210000U AS=40400000000P
+ AD=21875000000P PS=560000U PD=460000U
* device instance $2211 r0 *1 27.74,19.24 nfet_01v8
M$2211 38 141 2997 167 nfet_01v8 L=150000U W=140000U AS=21875000000P
+ AD=16800000000P PS=460000U PD=380000U
* device instance $2212 r0 *1 28.26,19.24 nfet_01v8
M$2212 39 141 1600 167 nfet_01v8 L=150000U W=140000U AS=21875000000P
+ AD=16800000000P PS=460000U PD=380000U
* device instance $2213 r0 *1 38.64,13.31 nfet_01v8
M$2213 2495 138 54 167 nfet_01v8 L=150000U W=140000U AS=16800000000P
+ AD=21875000000P PS=380000U PD=460000U
* device instance $2214 r0 *1 39.16,13.31 nfet_01v8
M$2214 1047 138 55 167 nfet_01v8 L=150000U W=140000U AS=16800000000P
+ AD=21875000000P PS=380000U PD=460000U
* device instance $2215 r0 *1 38.605,13.71 nfet_01v8
M$2215 167 3012 2495 167 nfet_01v8 L=150000U W=210000U AS=21875000000P
+ AD=40400000000P PS=460000U PD=560000U
* device instance $2216 r0 *1 39.195,13.71 nfet_01v8
M$2216 167 1590 1047 167 nfet_01v8 L=150000U W=210000U AS=21875000000P
+ AD=40400000000P PS=460000U PD=560000U
* device instance $2217 r0 *1 38.605,14.1 nfet_01v8
M$2217 3012 2495 167 167 nfet_01v8 L=150000U W=210000U AS=40400000000P
+ AD=21875000000P PS=560000U PD=460000U
* device instance $2218 r0 *1 39.195,14.1 nfet_01v8
M$2218 1590 1047 167 167 nfet_01v8 L=150000U W=210000U AS=40400000000P
+ AD=21875000000P PS=560000U PD=460000U
* device instance $2219 r0 *1 38.64,14.5 nfet_01v8
M$2219 53 138 3012 167 nfet_01v8 L=150000U W=140000U AS=21875000000P
+ AD=16800000000P PS=460000U PD=380000U
* device instance $2220 r0 *1 39.16,14.5 nfet_01v8
M$2220 56 138 1590 167 nfet_01v8 L=150000U W=140000U AS=21875000000P
+ AD=16800000000P PS=460000U PD=380000U
* device instance $2221 r0 *1 38.64,14.89 nfet_01v8
M$2221 3198 139 53 167 nfet_01v8 L=150000U W=140000U AS=16800000000P
+ AD=21875000000P PS=380000U PD=460000U
* device instance $2222 r0 *1 39.16,14.89 nfet_01v8
M$2222 4497 139 56 167 nfet_01v8 L=150000U W=140000U AS=16800000000P
+ AD=21875000000P PS=380000U PD=460000U
* device instance $2223 r0 *1 38.605,15.29 nfet_01v8
M$2223 167 2995 3198 167 nfet_01v8 L=150000U W=210000U AS=21875000000P
+ AD=40400000000P PS=460000U PD=560000U
* device instance $2224 r0 *1 39.195,15.29 nfet_01v8
M$2224 167 1586 4497 167 nfet_01v8 L=150000U W=210000U AS=21875000000P
+ AD=40400000000P PS=460000U PD=560000U
* device instance $2225 r0 *1 38.605,15.68 nfet_01v8
M$2225 2995 3198 167 167 nfet_01v8 L=150000U W=210000U AS=40400000000P
+ AD=21875000000P PS=560000U PD=460000U
* device instance $2226 r0 *1 39.195,15.68 nfet_01v8
M$2226 1586 4497 167 167 nfet_01v8 L=150000U W=210000U AS=40400000000P
+ AD=21875000000P PS=560000U PD=460000U
* device instance $2227 r0 *1 38.64,16.08 nfet_01v8
M$2227 54 139 2995 167 nfet_01v8 L=150000U W=140000U AS=21875000000P
+ AD=16800000000P PS=460000U PD=380000U
* device instance $2228 r0 *1 39.16,16.08 nfet_01v8
M$2228 55 139 1586 167 nfet_01v8 L=150000U W=140000U AS=21875000000P
+ AD=16800000000P PS=460000U PD=380000U
* device instance $2229 r0 *1 38.64,16.47 nfet_01v8
M$2229 2481 140 54 167 nfet_01v8 L=150000U W=140000U AS=16800000000P
+ AD=21875000000P PS=380000U PD=460000U
* device instance $2230 r0 *1 39.16,16.47 nfet_01v8
M$2230 625 140 55 167 nfet_01v8 L=150000U W=140000U AS=16800000000P
+ AD=21875000000P PS=380000U PD=460000U
* device instance $2231 r0 *1 38.605,16.87 nfet_01v8
M$2231 167 2985 2481 167 nfet_01v8 L=150000U W=210000U AS=21875000000P
+ AD=40400000000P PS=460000U PD=560000U
* device instance $2232 r0 *1 39.195,16.87 nfet_01v8
M$2232 167 769 625 167 nfet_01v8 L=150000U W=210000U AS=21875000000P
+ AD=40400000000P PS=460000U PD=560000U
* device instance $2233 r0 *1 38.605,17.26 nfet_01v8
M$2233 2985 2481 167 167 nfet_01v8 L=150000U W=210000U AS=40400000000P
+ AD=21875000000P PS=560000U PD=460000U
* device instance $2234 r0 *1 39.195,17.26 nfet_01v8
M$2234 769 625 167 167 nfet_01v8 L=150000U W=210000U AS=40400000000P
+ AD=21875000000P PS=560000U PD=460000U
* device instance $2235 r0 *1 38.64,17.66 nfet_01v8
M$2235 53 140 2985 167 nfet_01v8 L=150000U W=140000U AS=21875000000P
+ AD=16800000000P PS=460000U PD=380000U
* device instance $2236 r0 *1 39.16,17.66 nfet_01v8
M$2236 56 140 769 167 nfet_01v8 L=150000U W=140000U AS=21875000000P
+ AD=16800000000P PS=460000U PD=380000U
* device instance $2237 r0 *1 38.64,18.05 nfet_01v8
M$2237 3203 141 53 167 nfet_01v8 L=150000U W=140000U AS=16800000000P
+ AD=21875000000P PS=380000U PD=460000U
* device instance $2238 r0 *1 39.16,18.05 nfet_01v8
M$2238 1046 141 56 167 nfet_01v8 L=150000U W=140000U AS=16800000000P
+ AD=21875000000P PS=380000U PD=460000U
* device instance $2239 r0 *1 38.605,18.45 nfet_01v8
M$2239 167 2993 3203 167 nfet_01v8 L=150000U W=210000U AS=21875000000P
+ AD=40400000000P PS=460000U PD=560000U
* device instance $2240 r0 *1 39.195,18.45 nfet_01v8
M$2240 167 1588 1046 167 nfet_01v8 L=150000U W=210000U AS=21875000000P
+ AD=40400000000P PS=460000U PD=560000U
* device instance $2241 r0 *1 38.605,18.84 nfet_01v8
M$2241 2993 3203 167 167 nfet_01v8 L=150000U W=210000U AS=40400000000P
+ AD=21875000000P PS=560000U PD=460000U
* device instance $2242 r0 *1 39.195,18.84 nfet_01v8
M$2242 1588 1046 167 167 nfet_01v8 L=150000U W=210000U AS=40400000000P
+ AD=21875000000P PS=560000U PD=460000U
* device instance $2243 r0 *1 38.64,19.24 nfet_01v8
M$2243 54 141 2993 167 nfet_01v8 L=150000U W=140000U AS=21875000000P
+ AD=16800000000P PS=460000U PD=380000U
* device instance $2244 r0 *1 39.16,19.24 nfet_01v8
M$2244 55 141 1588 167 nfet_01v8 L=150000U W=140000U AS=21875000000P
+ AD=16800000000P PS=460000U PD=380000U
* device instance $2245 r0 *1 49.54,13.31 nfet_01v8
M$2245 2370 138 70 167 nfet_01v8 L=150000U W=140000U AS=16800000000P
+ AD=21875000000P PS=380000U PD=460000U
* device instance $2246 r0 *1 50.06,13.31 nfet_01v8
M$2246 1160 138 71 167 nfet_01v8 L=150000U W=140000U AS=16800000000P
+ AD=21875000000P PS=380000U PD=460000U
* device instance $2247 r0 *1 49.505,13.71 nfet_01v8
M$2247 167 2768 2370 167 nfet_01v8 L=150000U W=210000U AS=21875000000P
+ AD=40400000000P PS=460000U PD=560000U
* device instance $2248 r0 *1 50.095,13.71 nfet_01v8
M$2248 167 1720 1160 167 nfet_01v8 L=150000U W=210000U AS=21875000000P
+ AD=40400000000P PS=460000U PD=560000U
* device instance $2249 r0 *1 49.505,14.1 nfet_01v8
M$2249 2768 2370 167 167 nfet_01v8 L=150000U W=210000U AS=40400000000P
+ AD=21875000000P PS=560000U PD=460000U
* device instance $2250 r0 *1 50.095,14.1 nfet_01v8
M$2250 1720 1160 167 167 nfet_01v8 L=150000U W=210000U AS=40400000000P
+ AD=21875000000P PS=560000U PD=460000U
* device instance $2251 r0 *1 49.54,14.5 nfet_01v8
M$2251 69 138 2768 167 nfet_01v8 L=150000U W=140000U AS=21875000000P
+ AD=16800000000P PS=460000U PD=380000U
* device instance $2252 r0 *1 50.06,14.5 nfet_01v8
M$2252 72 138 1720 167 nfet_01v8 L=150000U W=140000U AS=21875000000P
+ AD=16800000000P PS=460000U PD=380000U
* device instance $2253 r0 *1 49.54,14.89 nfet_01v8
M$2253 3363 139 69 167 nfet_01v8 L=150000U W=140000U AS=16800000000P
+ AD=21875000000P PS=380000U PD=460000U
* device instance $2254 r0 *1 50.06,14.89 nfet_01v8
M$2254 4376 139 72 167 nfet_01v8 L=150000U W=140000U AS=16800000000P
+ AD=21875000000P PS=380000U PD=460000U
* device instance $2255 r0 *1 49.505,15.29 nfet_01v8
M$2255 167 2226 3363 167 nfet_01v8 L=150000U W=210000U AS=21875000000P
+ AD=40400000000P PS=460000U PD=560000U
* device instance $2256 r0 *1 50.095,15.29 nfet_01v8
M$2256 167 1728 4376 167 nfet_01v8 L=150000U W=210000U AS=21875000000P
+ AD=40400000000P PS=460000U PD=560000U
* device instance $2257 r0 *1 49.505,15.68 nfet_01v8
M$2257 2226 3363 167 167 nfet_01v8 L=150000U W=210000U AS=40400000000P
+ AD=21875000000P PS=560000U PD=460000U
* device instance $2258 r0 *1 50.095,15.68 nfet_01v8
M$2258 1728 4376 167 167 nfet_01v8 L=150000U W=210000U AS=40400000000P
+ AD=21875000000P PS=560000U PD=460000U
* device instance $2259 r0 *1 49.54,16.08 nfet_01v8
M$2259 70 139 2226 167 nfet_01v8 L=150000U W=140000U AS=21875000000P
+ AD=16800000000P PS=460000U PD=380000U
* device instance $2260 r0 *1 50.06,16.08 nfet_01v8
M$2260 71 139 1728 167 nfet_01v8 L=150000U W=140000U AS=21875000000P
+ AD=16800000000P PS=460000U PD=380000U
* device instance $2261 r0 *1 49.54,16.47 nfet_01v8
M$2261 3368 140 70 167 nfet_01v8 L=150000U W=140000U AS=16800000000P
+ AD=21875000000P PS=380000U PD=460000U
* device instance $2262 r0 *1 50.06,16.47 nfet_01v8
M$2262 583 140 71 167 nfet_01v8 L=150000U W=140000U AS=16800000000P
+ AD=21875000000P PS=380000U PD=460000U
* device instance $2263 r0 *1 49.505,16.87 nfet_01v8
M$2263 167 2765 3368 167 nfet_01v8 L=150000U W=210000U AS=21875000000P
+ AD=40400000000P PS=460000U PD=560000U
* device instance $2264 r0 *1 50.095,16.87 nfet_01v8
M$2264 167 682 583 167 nfet_01v8 L=150000U W=210000U AS=21875000000P
+ AD=40400000000P PS=460000U PD=560000U
* device instance $2265 r0 *1 49.505,17.26 nfet_01v8
M$2265 2765 3368 167 167 nfet_01v8 L=150000U W=210000U AS=40400000000P
+ AD=21875000000P PS=560000U PD=460000U
* device instance $2266 r0 *1 50.095,17.26 nfet_01v8
M$2266 682 583 167 167 nfet_01v8 L=150000U W=210000U AS=40400000000P
+ AD=21875000000P PS=560000U PD=460000U
* device instance $2267 r0 *1 49.54,17.66 nfet_01v8
M$2267 69 140 2765 167 nfet_01v8 L=150000U W=140000U AS=21875000000P
+ AD=16800000000P PS=460000U PD=380000U
* device instance $2268 r0 *1 50.06,17.66 nfet_01v8
M$2268 72 140 682 167 nfet_01v8 L=150000U W=140000U AS=21875000000P
+ AD=16800000000P PS=460000U PD=380000U
* device instance $2269 r0 *1 49.54,18.05 nfet_01v8
M$2269 3367 141 69 167 nfet_01v8 L=150000U W=140000U AS=16800000000P
+ AD=21875000000P PS=380000U PD=460000U
* device instance $2270 r0 *1 50.06,18.05 nfet_01v8
M$2270 1159 141 72 167 nfet_01v8 L=150000U W=140000U AS=16800000000P
+ AD=21875000000P PS=380000U PD=460000U
* device instance $2271 r0 *1 49.505,18.45 nfet_01v8
M$2271 167 2751 3367 167 nfet_01v8 L=150000U W=210000U AS=21875000000P
+ AD=40400000000P PS=460000U PD=560000U
* device instance $2272 r0 *1 50.095,18.45 nfet_01v8
M$2272 167 1719 1159 167 nfet_01v8 L=150000U W=210000U AS=21875000000P
+ AD=40400000000P PS=460000U PD=560000U
* device instance $2273 r0 *1 49.505,18.84 nfet_01v8
M$2273 2751 3367 167 167 nfet_01v8 L=150000U W=210000U AS=40400000000P
+ AD=21875000000P PS=560000U PD=460000U
* device instance $2274 r0 *1 50.095,18.84 nfet_01v8
M$2274 1719 1159 167 167 nfet_01v8 L=150000U W=210000U AS=40400000000P
+ AD=21875000000P PS=560000U PD=460000U
* device instance $2275 r0 *1 49.54,19.24 nfet_01v8
M$2275 70 141 2751 167 nfet_01v8 L=150000U W=140000U AS=21875000000P
+ AD=16800000000P PS=460000U PD=380000U
* device instance $2276 r0 *1 50.06,19.24 nfet_01v8
M$2276 71 141 1719 167 nfet_01v8 L=150000U W=140000U AS=21875000000P
+ AD=16800000000P PS=460000U PD=380000U
* device instance $2277 r0 *1 60.44,13.31 nfet_01v8
M$2277 2389 138 86 167 nfet_01v8 L=150000U W=140000U AS=16800000000P
+ AD=21875000000P PS=380000U PD=460000U
* device instance $2278 r0 *1 60.96,13.31 nfet_01v8
M$2278 1184 138 87 167 nfet_01v8 L=150000U W=140000U AS=16800000000P
+ AD=21875000000P PS=380000U PD=460000U
* device instance $2279 r0 *1 60.405,13.71 nfet_01v8
M$2279 167 2797 2389 167 nfet_01v8 L=150000U W=210000U AS=21875000000P
+ AD=40400000000P PS=460000U PD=560000U
* device instance $2280 r0 *1 60.995,13.71 nfet_01v8
M$2280 167 1748 1184 167 nfet_01v8 L=150000U W=210000U AS=21875000000P
+ AD=40400000000P PS=460000U PD=560000U
* device instance $2281 r0 *1 60.405,14.1 nfet_01v8
M$2281 2797 2389 167 167 nfet_01v8 L=150000U W=210000U AS=40400000000P
+ AD=21875000000P PS=560000U PD=460000U
* device instance $2282 r0 *1 60.995,14.1 nfet_01v8
M$2282 1748 1184 167 167 nfet_01v8 L=150000U W=210000U AS=40400000000P
+ AD=21875000000P PS=560000U PD=460000U
* device instance $2283 r0 *1 60.44,14.5 nfet_01v8
M$2283 85 138 2797 167 nfet_01v8 L=150000U W=140000U AS=21875000000P
+ AD=16800000000P PS=460000U PD=380000U
* device instance $2284 r0 *1 60.96,14.5 nfet_01v8
M$2284 88 138 1748 167 nfet_01v8 L=150000U W=140000U AS=21875000000P
+ AD=16800000000P PS=460000U PD=380000U
* device instance $2285 r0 *1 60.44,14.89 nfet_01v8
M$2285 3356 139 85 167 nfet_01v8 L=150000U W=140000U AS=16800000000P
+ AD=21875000000P PS=380000U PD=460000U
* device instance $2286 r0 *1 60.96,14.89 nfet_01v8
M$2286 4373 139 88 167 nfet_01v8 L=150000U W=140000U AS=16800000000P
+ AD=21875000000P PS=380000U PD=460000U
* device instance $2287 r0 *1 60.405,15.29 nfet_01v8
M$2287 167 2794 3356 167 nfet_01v8 L=150000U W=210000U AS=21875000000P
+ AD=40400000000P PS=460000U PD=560000U
* device instance $2288 r0 *1 60.995,15.29 nfet_01v8
M$2288 167 1746 4373 167 nfet_01v8 L=150000U W=210000U AS=21875000000P
+ AD=40400000000P PS=460000U PD=560000U
* device instance $2289 r0 *1 60.405,15.68 nfet_01v8
M$2289 2794 3356 167 167 nfet_01v8 L=150000U W=210000U AS=40400000000P
+ AD=21875000000P PS=560000U PD=460000U
* device instance $2290 r0 *1 60.995,15.68 nfet_01v8
M$2290 1746 4373 167 167 nfet_01v8 L=150000U W=210000U AS=40400000000P
+ AD=21875000000P PS=560000U PD=460000U
* device instance $2291 r0 *1 60.44,16.08 nfet_01v8
M$2291 86 139 2794 167 nfet_01v8 L=150000U W=140000U AS=21875000000P
+ AD=16800000000P PS=460000U PD=380000U
* device instance $2292 r0 *1 60.96,16.08 nfet_01v8
M$2292 87 139 1746 167 nfet_01v8 L=150000U W=140000U AS=21875000000P
+ AD=16800000000P PS=460000U PD=380000U
* device instance $2293 r0 *1 60.44,16.47 nfet_01v8
M$2293 2104 140 86 167 nfet_01v8 L=150000U W=140000U AS=16800000000P
+ AD=21875000000P PS=380000U PD=460000U
* device instance $2294 r0 *1 60.96,16.47 nfet_01v8
M$2294 1183 140 87 167 nfet_01v8 L=150000U W=140000U AS=16800000000P
+ AD=21875000000P PS=380000U PD=460000U
* device instance $2295 r0 *1 60.405,16.87 nfet_01v8
M$2295 167 2212 2104 167 nfet_01v8 L=150000U W=210000U AS=21875000000P
+ AD=40400000000P PS=460000U PD=560000U
* device instance $2296 r0 *1 60.995,16.87 nfet_01v8
M$2296 167 1747 1183 167 nfet_01v8 L=150000U W=210000U AS=21875000000P
+ AD=40400000000P PS=460000U PD=560000U
* device instance $2297 r0 *1 60.405,17.26 nfet_01v8
M$2297 2212 2104 167 167 nfet_01v8 L=150000U W=210000U AS=40400000000P
+ AD=21875000000P PS=560000U PD=460000U
* device instance $2298 r0 *1 60.995,17.26 nfet_01v8
M$2298 1747 1183 167 167 nfet_01v8 L=150000U W=210000U AS=40400000000P
+ AD=21875000000P PS=560000U PD=460000U
* device instance $2299 r0 *1 60.44,17.66 nfet_01v8
M$2299 85 140 2212 167 nfet_01v8 L=150000U W=140000U AS=21875000000P
+ AD=16800000000P PS=460000U PD=380000U
* device instance $2300 r0 *1 60.96,17.66 nfet_01v8
M$2300 88 140 1747 167 nfet_01v8 L=150000U W=140000U AS=21875000000P
+ AD=16800000000P PS=460000U PD=380000U
* device instance $2301 r0 *1 60.44,18.05 nfet_01v8
M$2301 2376 141 85 167 nfet_01v8 L=150000U W=140000U AS=16800000000P
+ AD=21875000000P PS=380000U PD=460000U
* device instance $2302 r0 *1 60.96,18.05 nfet_01v8
M$2302 1181 141 88 167 nfet_01v8 L=150000U W=140000U AS=16800000000P
+ AD=21875000000P PS=380000U PD=460000U
* device instance $2303 r0 *1 60.405,18.45 nfet_01v8
M$2303 167 2777 2376 167 nfet_01v8 L=150000U W=210000U AS=21875000000P
+ AD=40400000000P PS=460000U PD=560000U
* device instance $2304 r0 *1 60.995,18.45 nfet_01v8
M$2304 167 1744 1181 167 nfet_01v8 L=150000U W=210000U AS=21875000000P
+ AD=40400000000P PS=460000U PD=560000U
* device instance $2305 r0 *1 60.405,18.84 nfet_01v8
M$2305 2777 2376 167 167 nfet_01v8 L=150000U W=210000U AS=40400000000P
+ AD=21875000000P PS=560000U PD=460000U
* device instance $2306 r0 *1 60.995,18.84 nfet_01v8
M$2306 1744 1181 167 167 nfet_01v8 L=150000U W=210000U AS=40400000000P
+ AD=21875000000P PS=560000U PD=460000U
* device instance $2307 r0 *1 60.44,19.24 nfet_01v8
M$2307 86 141 2777 167 nfet_01v8 L=150000U W=140000U AS=21875000000P
+ AD=16800000000P PS=460000U PD=380000U
* device instance $2308 r0 *1 60.96,19.24 nfet_01v8
M$2308 87 141 1744 167 nfet_01v8 L=150000U W=140000U AS=21875000000P
+ AD=16800000000P PS=460000U PD=380000U
* device instance $2309 r0 *1 71.34,13.31 nfet_01v8
M$2309 3371 138 102 167 nfet_01v8 L=150000U W=140000U AS=16800000000P
+ AD=21875000000P PS=380000U PD=460000U
* device instance $2310 r0 *1 71.86,13.31 nfet_01v8
M$2310 1118 138 103 167 nfet_01v8 L=150000U W=140000U AS=16800000000P
+ AD=21875000000P PS=380000U PD=460000U
* device instance $2311 r0 *1 71.305,13.71 nfet_01v8
M$2311 167 3029 3371 167 nfet_01v8 L=150000U W=210000U AS=21875000000P
+ AD=40400000000P PS=460000U PD=560000U
* device instance $2312 r0 *1 71.895,13.71 nfet_01v8
M$2312 167 1673 1118 167 nfet_01v8 L=150000U W=210000U AS=21875000000P
+ AD=40400000000P PS=460000U PD=560000U
* device instance $2313 r0 *1 71.305,14.1 nfet_01v8
M$2313 3029 3371 167 167 nfet_01v8 L=150000U W=210000U AS=40400000000P
+ AD=21875000000P PS=560000U PD=460000U
* device instance $2314 r0 *1 71.895,14.1 nfet_01v8
M$2314 1673 1118 167 167 nfet_01v8 L=150000U W=210000U AS=40400000000P
+ AD=21875000000P PS=560000U PD=460000U
* device instance $2315 r0 *1 71.34,14.5 nfet_01v8
M$2315 101 138 3029 167 nfet_01v8 L=150000U W=140000U AS=21875000000P
+ AD=16800000000P PS=460000U PD=380000U
* device instance $2316 r0 *1 71.86,14.5 nfet_01v8
M$2316 104 138 1673 167 nfet_01v8 L=150000U W=140000U AS=21875000000P
+ AD=16800000000P PS=460000U PD=380000U
* device instance $2317 r0 *1 71.34,14.89 nfet_01v8
M$2317 3401 139 101 167 nfet_01v8 L=150000U W=140000U AS=16800000000P
+ AD=21875000000P PS=380000U PD=460000U
* device instance $2318 r0 *1 71.86,14.89 nfet_01v8
M$2318 4348 139 104 167 nfet_01v8 L=150000U W=140000U AS=16800000000P
+ AD=21875000000P PS=380000U PD=460000U
* device instance $2319 r0 *1 71.305,15.29 nfet_01v8
M$2319 167 2937 3401 167 nfet_01v8 L=150000U W=210000U AS=21875000000P
+ AD=40400000000P PS=460000U PD=560000U
* device instance $2320 r0 *1 71.895,15.29 nfet_01v8
M$2320 167 1671 4348 167 nfet_01v8 L=150000U W=210000U AS=21875000000P
+ AD=40400000000P PS=460000U PD=560000U
* device instance $2321 r0 *1 71.305,15.68 nfet_01v8
M$2321 2937 3401 167 167 nfet_01v8 L=150000U W=210000U AS=40400000000P
+ AD=21875000000P PS=560000U PD=460000U
* device instance $2322 r0 *1 71.895,15.68 nfet_01v8
M$2322 1671 4348 167 167 nfet_01v8 L=150000U W=210000U AS=40400000000P
+ AD=21875000000P PS=560000U PD=460000U
* device instance $2323 r0 *1 71.34,16.08 nfet_01v8
M$2323 102 139 2937 167 nfet_01v8 L=150000U W=140000U AS=21875000000P
+ AD=16800000000P PS=460000U PD=380000U
* device instance $2324 r0 *1 71.86,16.08 nfet_01v8
M$2324 103 139 1671 167 nfet_01v8 L=150000U W=140000U AS=21875000000P
+ AD=16800000000P PS=460000U PD=380000U
* device instance $2325 r0 *1 71.34,16.47 nfet_01v8
M$2325 3405 140 102 167 nfet_01v8 L=150000U W=140000U AS=16800000000P
+ AD=21875000000P PS=380000U PD=460000U
* device instance $2326 r0 *1 71.86,16.47 nfet_01v8
M$2326 1115 140 103 167 nfet_01v8 L=150000U W=140000U AS=16800000000P
+ AD=21875000000P PS=380000U PD=460000U
* device instance $2327 r0 *1 71.305,16.87 nfet_01v8
M$2327 167 2949 3405 167 nfet_01v8 L=150000U W=210000U AS=21875000000P
+ AD=40400000000P PS=460000U PD=560000U
* device instance $2328 r0 *1 71.895,16.87 nfet_01v8
M$2328 167 1669 1115 167 nfet_01v8 L=150000U W=210000U AS=21875000000P
+ AD=40400000000P PS=460000U PD=560000U
* device instance $2329 r0 *1 71.305,17.26 nfet_01v8
M$2329 2949 3405 167 167 nfet_01v8 L=150000U W=210000U AS=40400000000P
+ AD=21875000000P PS=560000U PD=460000U
* device instance $2330 r0 *1 71.895,17.26 nfet_01v8
M$2330 1669 1115 167 167 nfet_01v8 L=150000U W=210000U AS=40400000000P
+ AD=21875000000P PS=560000U PD=460000U
* device instance $2331 r0 *1 71.34,17.66 nfet_01v8
M$2331 101 140 2949 167 nfet_01v8 L=150000U W=140000U AS=21875000000P
+ AD=16800000000P PS=460000U PD=380000U
* device instance $2332 r0 *1 71.86,17.66 nfet_01v8
M$2332 104 140 1669 167 nfet_01v8 L=150000U W=140000U AS=21875000000P
+ AD=16800000000P PS=460000U PD=380000U
* device instance $2333 r0 *1 71.34,18.05 nfet_01v8
M$2333 2463 141 101 167 nfet_01v8 L=150000U W=140000U AS=16800000000P
+ AD=21875000000P PS=380000U PD=460000U
* device instance $2334 r0 *1 71.86,18.05 nfet_01v8
M$2334 1121 141 104 167 nfet_01v8 L=150000U W=140000U AS=16800000000P
+ AD=21875000000P PS=380000U PD=460000U
* device instance $2335 r0 *1 71.305,18.45 nfet_01v8
M$2335 167 2943 2463 167 nfet_01v8 L=150000U W=210000U AS=21875000000P
+ AD=40400000000P PS=460000U PD=560000U
* device instance $2336 r0 *1 71.895,18.45 nfet_01v8
M$2336 167 1676 1121 167 nfet_01v8 L=150000U W=210000U AS=21875000000P
+ AD=40400000000P PS=460000U PD=560000U
* device instance $2337 r0 *1 71.305,18.84 nfet_01v8
M$2337 2943 2463 167 167 nfet_01v8 L=150000U W=210000U AS=40400000000P
+ AD=21875000000P PS=560000U PD=460000U
* device instance $2338 r0 *1 71.895,18.84 nfet_01v8
M$2338 1676 1121 167 167 nfet_01v8 L=150000U W=210000U AS=40400000000P
+ AD=21875000000P PS=560000U PD=460000U
* device instance $2339 r0 *1 71.34,19.24 nfet_01v8
M$2339 102 141 2943 167 nfet_01v8 L=150000U W=140000U AS=21875000000P
+ AD=16800000000P PS=460000U PD=380000U
* device instance $2340 r0 *1 71.86,19.24 nfet_01v8
M$2340 103 141 1676 167 nfet_01v8 L=150000U W=140000U AS=21875000000P
+ AD=16800000000P PS=460000U PD=380000U
* device instance $2341 r0 *1 5.94,5.41 nfet_01v8
M$2341 3221 134 6 167 nfet_01v8 L=150000U W=140000U AS=16800000000P
+ AD=21875000000P PS=380000U PD=460000U
* device instance $2342 r0 *1 6.46,5.41 nfet_01v8
M$2342 1022 134 7 167 nfet_01v8 L=150000U W=140000U AS=16800000000P
+ AD=21875000000P PS=380000U PD=460000U
* device instance $2343 r0 *1 5.905,5.81 nfet_01v8
M$2343 167 3114 3221 167 nfet_01v8 L=150000U W=210000U AS=21875000000P
+ AD=40400000000P PS=460000U PD=560000U
* device instance $2344 r0 *1 6.495,5.81 nfet_01v8
M$2344 167 1559 1022 167 nfet_01v8 L=150000U W=210000U AS=21875000000P
+ AD=40400000000P PS=460000U PD=560000U
* device instance $2345 r0 *1 5.905,6.2 nfet_01v8
M$2345 3114 3221 167 167 nfet_01v8 L=150000U W=210000U AS=40400000000P
+ AD=21875000000P PS=560000U PD=460000U
* device instance $2346 r0 *1 6.495,6.2 nfet_01v8
M$2346 1559 1022 167 167 nfet_01v8 L=150000U W=210000U AS=40400000000P
+ AD=21875000000P PS=560000U PD=460000U
* device instance $2347 r0 *1 5.94,6.6 nfet_01v8
M$2347 5 134 3114 167 nfet_01v8 L=150000U W=140000U AS=21875000000P
+ AD=16800000000P PS=460000U PD=380000U
* device instance $2348 r0 *1 6.46,6.6 nfet_01v8
M$2348 8 134 1559 167 nfet_01v8 L=150000U W=140000U AS=21875000000P
+ AD=16800000000P PS=460000U PD=380000U
* device instance $2349 r0 *1 5.94,6.99 nfet_01v8
M$2349 3216 135 5 167 nfet_01v8 L=150000U W=140000U AS=16800000000P
+ AD=21875000000P PS=380000U PD=460000U
* device instance $2350 r0 *1 6.46,6.99 nfet_01v8
M$2350 4501 135 8 167 nfet_01v8 L=150000U W=140000U AS=16800000000P
+ AD=21875000000P PS=380000U PD=460000U
* device instance $2351 r0 *1 5.905,7.39 nfet_01v8
M$2351 167 3048 3216 167 nfet_01v8 L=150000U W=210000U AS=21875000000P
+ AD=40400000000P PS=460000U PD=560000U
* device instance $2352 r0 *1 6.495,7.39 nfet_01v8
M$2352 167 857 4501 167 nfet_01v8 L=150000U W=210000U AS=21875000000P
+ AD=40400000000P PS=460000U PD=560000U
* device instance $2353 r0 *1 5.905,7.78 nfet_01v8
M$2353 3048 3216 167 167 nfet_01v8 L=150000U W=210000U AS=40400000000P
+ AD=21875000000P PS=560000U PD=460000U
* device instance $2354 r0 *1 6.495,7.78 nfet_01v8
M$2354 857 4501 167 167 nfet_01v8 L=150000U W=210000U AS=40400000000P
+ AD=21875000000P PS=560000U PD=460000U
* device instance $2355 r0 *1 5.94,8.18 nfet_01v8
M$2355 6 135 3048 167 nfet_01v8 L=150000U W=140000U AS=21875000000P
+ AD=16800000000P PS=460000U PD=380000U
* device instance $2356 r0 *1 6.46,8.18 nfet_01v8
M$2356 7 135 857 167 nfet_01v8 L=150000U W=140000U AS=21875000000P
+ AD=16800000000P PS=460000U PD=380000U
* device instance $2357 r0 *1 5.94,8.57 nfet_01v8
M$2357 3217 136 6 167 nfet_01v8 L=150000U W=140000U AS=16800000000P
+ AD=21875000000P PS=380000U PD=460000U
* device instance $2358 r0 *1 6.46,8.57 nfet_01v8
M$2358 671 136 7 167 nfet_01v8 L=150000U W=140000U AS=16800000000P
+ AD=21875000000P PS=380000U PD=460000U
* device instance $2359 r0 *1 5.905,8.97 nfet_01v8
M$2359 167 3054 3217 167 nfet_01v8 L=150000U W=210000U AS=21875000000P
+ AD=40400000000P PS=460000U PD=560000U
* device instance $2360 r0 *1 6.495,8.97 nfet_01v8
M$2360 167 869 671 167 nfet_01v8 L=150000U W=210000U AS=21875000000P
+ AD=40400000000P PS=460000U PD=560000U
* device instance $2361 r0 *1 5.905,9.36 nfet_01v8
M$2361 3054 3217 167 167 nfet_01v8 L=150000U W=210000U AS=40400000000P
+ AD=21875000000P PS=560000U PD=460000U
* device instance $2362 r0 *1 6.495,9.36 nfet_01v8
M$2362 869 671 167 167 nfet_01v8 L=150000U W=210000U AS=40400000000P
+ AD=21875000000P PS=560000U PD=460000U
* device instance $2363 r0 *1 5.94,9.76 nfet_01v8
M$2363 5 136 3054 167 nfet_01v8 L=150000U W=140000U AS=21875000000P
+ AD=16800000000P PS=460000U PD=380000U
* device instance $2364 r0 *1 6.46,9.76 nfet_01v8
M$2364 8 136 869 167 nfet_01v8 L=150000U W=140000U AS=21875000000P
+ AD=16800000000P PS=460000U PD=380000U
* device instance $2365 r0 *1 5.94,10.15 nfet_01v8
M$2365 2434 137 5 167 nfet_01v8 L=150000U W=140000U AS=16800000000P
+ AD=21875000000P PS=380000U PD=460000U
* device instance $2366 r0 *1 6.46,10.15 nfet_01v8
M$2366 1294 137 8 167 nfet_01v8 L=150000U W=140000U AS=16800000000P
+ AD=21875000000P PS=380000U PD=460000U
* device instance $2367 r0 *1 5.905,10.55 nfet_01v8
M$2367 167 2887 2434 167 nfet_01v8 L=150000U W=210000U AS=21875000000P
+ AD=40400000000P PS=460000U PD=560000U
* device instance $2368 r0 *1 6.495,10.55 nfet_01v8
M$2368 167 1871 1294 167 nfet_01v8 L=150000U W=210000U AS=21875000000P
+ AD=40400000000P PS=460000U PD=560000U
* device instance $2369 r0 *1 5.905,10.94 nfet_01v8
M$2369 2887 2434 167 167 nfet_01v8 L=150000U W=210000U AS=40400000000P
+ AD=21875000000P PS=560000U PD=460000U
* device instance $2370 r0 *1 6.495,10.94 nfet_01v8
M$2370 1871 1294 167 167 nfet_01v8 L=150000U W=210000U AS=40400000000P
+ AD=21875000000P PS=560000U PD=460000U
* device instance $2371 r0 *1 5.94,11.34 nfet_01v8
M$2371 6 137 2887 167 nfet_01v8 L=150000U W=140000U AS=21875000000P
+ AD=16800000000P PS=460000U PD=380000U
* device instance $2372 r0 *1 6.46,11.34 nfet_01v8
M$2372 7 137 1871 167 nfet_01v8 L=150000U W=140000U AS=21875000000P
+ AD=16800000000P PS=460000U PD=380000U
* device instance $2373 r0 *1 16.84,5.41 nfet_01v8
M$2373 2470 134 22 167 nfet_01v8 L=150000U W=140000U AS=16800000000P
+ AD=21875000000P PS=380000U PD=460000U
* device instance $2374 r0 *1 17.36,5.41 nfet_01v8
M$2374 997 134 23 167 nfet_01v8 L=150000U W=140000U AS=16800000000P
+ AD=21875000000P PS=380000U PD=460000U
* device instance $2375 r0 *1 16.805,5.81 nfet_01v8
M$2375 167 2965 2470 167 nfet_01v8 L=150000U W=210000U AS=21875000000P
+ AD=40400000000P PS=460000U PD=560000U
* device instance $2376 r0 *1 17.395,5.81 nfet_01v8
M$2376 167 1532 997 167 nfet_01v8 L=150000U W=210000U AS=21875000000P
+ AD=40400000000P PS=460000U PD=560000U
* device instance $2377 r0 *1 16.805,6.2 nfet_01v8
M$2377 2965 2470 167 167 nfet_01v8 L=150000U W=210000U AS=40400000000P
+ AD=21875000000P PS=560000U PD=460000U
* device instance $2378 r0 *1 17.395,6.2 nfet_01v8
M$2378 1532 997 167 167 nfet_01v8 L=150000U W=210000U AS=40400000000P
+ AD=21875000000P PS=560000U PD=460000U
* device instance $2379 r0 *1 16.84,6.6 nfet_01v8
M$2379 21 134 2965 167 nfet_01v8 L=150000U W=140000U AS=21875000000P
+ AD=16800000000P PS=460000U PD=380000U
* device instance $2380 r0 *1 17.36,6.6 nfet_01v8
M$2380 24 134 1532 167 nfet_01v8 L=150000U W=140000U AS=21875000000P
+ AD=16800000000P PS=460000U PD=380000U
* device instance $2381 r0 *1 16.84,6.99 nfet_01v8
M$2381 3186 135 21 167 nfet_01v8 L=150000U W=140000U AS=16800000000P
+ AD=21875000000P PS=380000U PD=460000U
* device instance $2382 r0 *1 17.36,6.99 nfet_01v8
M$2382 4507 135 24 167 nfet_01v8 L=150000U W=140000U AS=16800000000P
+ AD=21875000000P PS=380000U PD=460000U
* device instance $2383 r0 *1 16.805,7.39 nfet_01v8
M$2383 167 2981 3186 167 nfet_01v8 L=150000U W=210000U AS=21875000000P
+ AD=40400000000P PS=460000U PD=560000U
* device instance $2384 r0 *1 17.395,7.39 nfet_01v8
M$2384 167 842 4507 167 nfet_01v8 L=150000U W=210000U AS=21875000000P
+ AD=40400000000P PS=460000U PD=560000U
* device instance $2385 r0 *1 16.805,7.78 nfet_01v8
M$2385 2981 3186 167 167 nfet_01v8 L=150000U W=210000U AS=40400000000P
+ AD=21875000000P PS=560000U PD=460000U
* device instance $2386 r0 *1 17.395,7.78 nfet_01v8
M$2386 842 4507 167 167 nfet_01v8 L=150000U W=210000U AS=40400000000P
+ AD=21875000000P PS=560000U PD=460000U
* device instance $2387 r0 *1 16.84,8.18 nfet_01v8
M$2387 22 135 2981 167 nfet_01v8 L=150000U W=140000U AS=21875000000P
+ AD=16800000000P PS=460000U PD=380000U
* device instance $2388 r0 *1 17.36,8.18 nfet_01v8
M$2388 23 135 842 167 nfet_01v8 L=150000U W=140000U AS=21875000000P
+ AD=16800000000P PS=460000U PD=380000U
* device instance $2389 r0 *1 16.84,8.57 nfet_01v8
M$2389 3187 136 22 167 nfet_01v8 L=150000U W=140000U AS=16800000000P
+ AD=21875000000P PS=380000U PD=460000U
* device instance $2390 r0 *1 17.36,8.57 nfet_01v8
M$2390 996 136 23 167 nfet_01v8 L=150000U W=140000U AS=16800000000P
+ AD=21875000000P PS=380000U PD=460000U
* device instance $2391 r0 *1 16.805,8.97 nfet_01v8
M$2391 167 2978 3187 167 nfet_01v8 L=150000U W=210000U AS=21875000000P
+ AD=40400000000P PS=460000U PD=560000U
* device instance $2392 r0 *1 17.395,8.97 nfet_01v8
M$2392 167 1531 996 167 nfet_01v8 L=150000U W=210000U AS=21875000000P
+ AD=40400000000P PS=460000U PD=560000U
* device instance $2393 r0 *1 16.805,9.36 nfet_01v8
M$2393 2978 3187 167 167 nfet_01v8 L=150000U W=210000U AS=40400000000P
+ AD=21875000000P PS=560000U PD=460000U
* device instance $2394 r0 *1 17.395,9.36 nfet_01v8
M$2394 1531 996 167 167 nfet_01v8 L=150000U W=210000U AS=40400000000P
+ AD=21875000000P PS=560000U PD=460000U
* device instance $2395 r0 *1 16.84,9.76 nfet_01v8
M$2395 21 136 2978 167 nfet_01v8 L=150000U W=140000U AS=21875000000P
+ AD=16800000000P PS=460000U PD=380000U
* device instance $2396 r0 *1 17.36,9.76 nfet_01v8
M$2396 24 136 1531 167 nfet_01v8 L=150000U W=140000U AS=21875000000P
+ AD=16800000000P PS=460000U PD=380000U
* device instance $2397 r0 *1 16.84,10.15 nfet_01v8
M$2397 3319 137 21 167 nfet_01v8 L=150000U W=140000U AS=16800000000P
+ AD=21875000000P PS=380000U PD=460000U
* device instance $2398 r0 *1 17.36,10.15 nfet_01v8
M$2398 1296 137 24 167 nfet_01v8 L=150000U W=140000U AS=16800000000P
+ AD=21875000000P PS=380000U PD=460000U
* device instance $2399 r0 *1 16.805,10.55 nfet_01v8
M$2399 167 2892 3319 167 nfet_01v8 L=150000U W=210000U AS=21875000000P
+ AD=40400000000P PS=460000U PD=560000U
* device instance $2400 r0 *1 17.395,10.55 nfet_01v8
M$2400 167 1873 1296 167 nfet_01v8 L=150000U W=210000U AS=21875000000P
+ AD=40400000000P PS=460000U PD=560000U
* device instance $2401 r0 *1 16.805,10.94 nfet_01v8
M$2401 2892 3319 167 167 nfet_01v8 L=150000U W=210000U AS=40400000000P
+ AD=21875000000P PS=560000U PD=460000U
* device instance $2402 r0 *1 17.395,10.94 nfet_01v8
M$2402 1873 1296 167 167 nfet_01v8 L=150000U W=210000U AS=40400000000P
+ AD=21875000000P PS=560000U PD=460000U
* device instance $2403 r0 *1 16.84,11.34 nfet_01v8
M$2403 22 137 2892 167 nfet_01v8 L=150000U W=140000U AS=21875000000P
+ AD=16800000000P PS=460000U PD=380000U
* device instance $2404 r0 *1 17.36,11.34 nfet_01v8
M$2404 23 137 1873 167 nfet_01v8 L=150000U W=140000U AS=21875000000P
+ AD=16800000000P PS=460000U PD=380000U
* device instance $2405 r0 *1 27.74,5.41 nfet_01v8
M$2405 2531 134 38 167 nfet_01v8 L=150000U W=140000U AS=16800000000P
+ AD=21875000000P PS=380000U PD=460000U
* device instance $2406 r0 *1 28.26,5.41 nfet_01v8
M$2406 1035 134 39 167 nfet_01v8 L=150000U W=140000U AS=16800000000P
+ AD=21875000000P PS=380000U PD=460000U
* device instance $2407 r0 *1 27.705,5.81 nfet_01v8
M$2407 167 3094 2531 167 nfet_01v8 L=150000U W=210000U AS=21875000000P
+ AD=40400000000P PS=460000U PD=560000U
* device instance $2408 r0 *1 28.295,5.81 nfet_01v8
M$2408 167 1574 1035 167 nfet_01v8 L=150000U W=210000U AS=21875000000P
+ AD=40400000000P PS=460000U PD=560000U
* device instance $2409 r0 *1 27.705,6.2 nfet_01v8
M$2409 3094 2531 167 167 nfet_01v8 L=150000U W=210000U AS=40400000000P
+ AD=21875000000P PS=560000U PD=460000U
* device instance $2410 r0 *1 28.295,6.2 nfet_01v8
M$2410 1574 1035 167 167 nfet_01v8 L=150000U W=210000U AS=40400000000P
+ AD=21875000000P PS=560000U PD=460000U
* device instance $2411 r0 *1 27.74,6.6 nfet_01v8
M$2411 37 134 3094 167 nfet_01v8 L=150000U W=140000U AS=21875000000P
+ AD=16800000000P PS=460000U PD=380000U
* device instance $2412 r0 *1 28.26,6.6 nfet_01v8
M$2412 40 134 1574 167 nfet_01v8 L=150000U W=140000U AS=21875000000P
+ AD=16800000000P PS=460000U PD=380000U
* device instance $2413 r0 *1 27.74,6.99 nfet_01v8
M$2413 3255 135 37 167 nfet_01v8 L=150000U W=140000U AS=16800000000P
+ AD=21875000000P PS=380000U PD=460000U
* device instance $2414 r0 *1 28.26,6.99 nfet_01v8
M$2414 4313 135 40 167 nfet_01v8 L=150000U W=140000U AS=16800000000P
+ AD=21875000000P PS=380000U PD=460000U
* device instance $2415 r0 *1 27.705,7.39 nfet_01v8
M$2415 167 2927 3255 167 nfet_01v8 L=150000U W=210000U AS=21875000000P
+ AD=40400000000P PS=460000U PD=560000U
* device instance $2416 r0 *1 28.295,7.39 nfet_01v8
M$2416 167 767 4313 167 nfet_01v8 L=150000U W=210000U AS=21875000000P
+ AD=40400000000P PS=460000U PD=560000U
* device instance $2417 r0 *1 27.705,7.78 nfet_01v8
M$2417 2927 3255 167 167 nfet_01v8 L=150000U W=210000U AS=40400000000P
+ AD=21875000000P PS=560000U PD=460000U
* device instance $2418 r0 *1 28.295,7.78 nfet_01v8
M$2418 767 4313 167 167 nfet_01v8 L=150000U W=210000U AS=40400000000P
+ AD=21875000000P PS=560000U PD=460000U
* device instance $2419 r0 *1 27.74,8.18 nfet_01v8
M$2419 38 135 2927 167 nfet_01v8 L=150000U W=140000U AS=21875000000P
+ AD=16800000000P PS=460000U PD=380000U
* device instance $2420 r0 *1 28.26,8.18 nfet_01v8
M$2420 39 135 767 167 nfet_01v8 L=150000U W=140000U AS=21875000000P
+ AD=16800000000P PS=460000U PD=380000U
* device instance $2421 r0 *1 27.74,8.57 nfet_01v8
M$2421 3254 136 38 167 nfet_01v8 L=150000U W=140000U AS=16800000000P
+ AD=21875000000P PS=380000U PD=460000U
* device instance $2422 r0 *1 28.26,8.57 nfet_01v8
M$2422 1031 136 39 167 nfet_01v8 L=150000U W=140000U AS=16800000000P
+ AD=21875000000P PS=380000U PD=460000U
* device instance $2423 r0 *1 27.705,8.97 nfet_01v8
M$2423 167 2165 3254 167 nfet_01v8 L=150000U W=210000U AS=21875000000P
+ AD=40400000000P PS=460000U PD=560000U
* device instance $2424 r0 *1 28.295,8.97 nfet_01v8
M$2424 167 1569 1031 167 nfet_01v8 L=150000U W=210000U AS=21875000000P
+ AD=40400000000P PS=460000U PD=560000U
* device instance $2425 r0 *1 27.705,9.36 nfet_01v8
M$2425 2165 3254 167 167 nfet_01v8 L=150000U W=210000U AS=40400000000P
+ AD=21875000000P PS=560000U PD=460000U
* device instance $2426 r0 *1 28.295,9.36 nfet_01v8
M$2426 1569 1031 167 167 nfet_01v8 L=150000U W=210000U AS=40400000000P
+ AD=21875000000P PS=560000U PD=460000U
* device instance $2427 r0 *1 27.74,9.76 nfet_01v8
M$2427 37 136 2165 167 nfet_01v8 L=150000U W=140000U AS=21875000000P
+ AD=16800000000P PS=460000U PD=380000U
* device instance $2428 r0 *1 28.26,9.76 nfet_01v8
M$2428 40 136 1569 167 nfet_01v8 L=150000U W=140000U AS=21875000000P
+ AD=16800000000P PS=460000U PD=380000U
* device instance $2429 r0 *1 27.74,10.15 nfet_01v8
M$2429 2455 137 37 167 nfet_01v8 L=150000U W=140000U AS=16800000000P
+ AD=21875000000P PS=380000U PD=460000U
* device instance $2430 r0 *1 28.26,10.15 nfet_01v8
M$2430 1003 137 40 167 nfet_01v8 L=150000U W=140000U AS=16800000000P
+ AD=21875000000P PS=380000U PD=460000U
* device instance $2431 r0 *1 27.705,10.55 nfet_01v8
M$2431 167 2930 2455 167 nfet_01v8 L=150000U W=210000U AS=21875000000P
+ AD=40400000000P PS=460000U PD=560000U
* device instance $2432 r0 *1 28.295,10.55 nfet_01v8
M$2432 167 1538 1003 167 nfet_01v8 L=150000U W=210000U AS=21875000000P
+ AD=40400000000P PS=460000U PD=560000U
* device instance $2433 r0 *1 27.705,10.94 nfet_01v8
M$2433 2930 2455 167 167 nfet_01v8 L=150000U W=210000U AS=40400000000P
+ AD=21875000000P PS=560000U PD=460000U
* device instance $2434 r0 *1 28.295,10.94 nfet_01v8
M$2434 1538 1003 167 167 nfet_01v8 L=150000U W=210000U AS=40400000000P
+ AD=21875000000P PS=560000U PD=460000U
* device instance $2435 r0 *1 27.74,11.34 nfet_01v8
M$2435 38 137 2930 167 nfet_01v8 L=150000U W=140000U AS=21875000000P
+ AD=16800000000P PS=460000U PD=380000U
* device instance $2436 r0 *1 28.26,11.34 nfet_01v8
M$2436 39 137 1538 167 nfet_01v8 L=150000U W=140000U AS=21875000000P
+ AD=16800000000P PS=460000U PD=380000U
* device instance $2437 r0 *1 38.64,5.41 nfet_01v8
M$2437 2539 134 54 167 nfet_01v8 L=150000U W=140000U AS=16800000000P
+ AD=21875000000P PS=380000U PD=460000U
* device instance $2438 r0 *1 39.16,5.41 nfet_01v8
M$2438 1036 134 55 167 nfet_01v8 L=150000U W=140000U AS=16800000000P
+ AD=21875000000P PS=380000U PD=460000U
* device instance $2439 r0 *1 38.605,5.81 nfet_01v8
M$2439 167 3113 2539 167 nfet_01v8 L=150000U W=210000U AS=21875000000P
+ AD=40400000000P PS=460000U PD=560000U
* device instance $2440 r0 *1 39.195,5.81 nfet_01v8
M$2440 167 1575 1036 167 nfet_01v8 L=150000U W=210000U AS=21875000000P
+ AD=40400000000P PS=460000U PD=560000U
* device instance $2441 r0 *1 38.605,6.2 nfet_01v8
M$2441 3113 2539 167 167 nfet_01v8 L=150000U W=210000U AS=40400000000P
+ AD=21875000000P PS=560000U PD=460000U
* device instance $2442 r0 *1 39.195,6.2 nfet_01v8
M$2442 1575 1036 167 167 nfet_01v8 L=150000U W=210000U AS=40400000000P
+ AD=21875000000P PS=560000U PD=460000U
* device instance $2443 r0 *1 38.64,6.6 nfet_01v8
M$2443 53 134 3113 167 nfet_01v8 L=150000U W=140000U AS=21875000000P
+ AD=16800000000P PS=460000U PD=380000U
* device instance $2444 r0 *1 39.16,6.6 nfet_01v8
M$2444 56 134 1575 167 nfet_01v8 L=150000U W=140000U AS=21875000000P
+ AD=16800000000P PS=460000U PD=380000U
* device instance $2445 r0 *1 38.64,6.99 nfet_01v8
M$2445 3228 135 53 167 nfet_01v8 L=150000U W=140000U AS=16800000000P
+ AD=21875000000P PS=380000U PD=460000U
* device instance $2446 r0 *1 39.16,6.99 nfet_01v8
M$2446 4294 135 56 167 nfet_01v8 L=150000U W=140000U AS=16800000000P
+ AD=21875000000P PS=380000U PD=460000U
* device instance $2447 r0 *1 38.605,7.39 nfet_01v8
M$2447 167 2177 3228 167 nfet_01v8 L=150000U W=210000U AS=21875000000P
+ AD=40400000000P PS=460000U PD=560000U
* device instance $2448 r0 *1 39.195,7.39 nfet_01v8
M$2448 167 1576 4294 167 nfet_01v8 L=150000U W=210000U AS=21875000000P
+ AD=40400000000P PS=460000U PD=560000U
* device instance $2449 r0 *1 38.605,7.78 nfet_01v8
M$2449 2177 3228 167 167 nfet_01v8 L=150000U W=210000U AS=40400000000P
+ AD=21875000000P PS=560000U PD=460000U
* device instance $2450 r0 *1 39.195,7.78 nfet_01v8
M$2450 1576 4294 167 167 nfet_01v8 L=150000U W=210000U AS=40400000000P
+ AD=21875000000P PS=560000U PD=460000U
* device instance $2451 r0 *1 38.64,8.18 nfet_01v8
M$2451 54 135 2177 167 nfet_01v8 L=150000U W=140000U AS=21875000000P
+ AD=16800000000P PS=460000U PD=380000U
* device instance $2452 r0 *1 39.16,8.18 nfet_01v8
M$2452 55 135 1576 167 nfet_01v8 L=150000U W=140000U AS=21875000000P
+ AD=16800000000P PS=460000U PD=380000U
* device instance $2453 r0 *1 38.64,8.57 nfet_01v8
M$2453 3230 136 54 167 nfet_01v8 L=150000U W=140000U AS=16800000000P
+ AD=21875000000P PS=380000U PD=460000U
* device instance $2454 r0 *1 39.16,8.57 nfet_01v8
M$2454 1037 136 55 167 nfet_01v8 L=150000U W=140000U AS=16800000000P
+ AD=21875000000P PS=380000U PD=460000U
* device instance $2455 r0 *1 38.605,8.97 nfet_01v8
M$2455 167 3057 3230 167 nfet_01v8 L=150000U W=210000U AS=21875000000P
+ AD=40400000000P PS=460000U PD=560000U
* device instance $2456 r0 *1 39.195,8.97 nfet_01v8
M$2456 167 1578 1037 167 nfet_01v8 L=150000U W=210000U AS=21875000000P
+ AD=40400000000P PS=460000U PD=560000U
* device instance $2457 r0 *1 38.605,9.36 nfet_01v8
M$2457 3057 3230 167 167 nfet_01v8 L=150000U W=210000U AS=40400000000P
+ AD=21875000000P PS=560000U PD=460000U
* device instance $2458 r0 *1 39.195,9.36 nfet_01v8
M$2458 1578 1037 167 167 nfet_01v8 L=150000U W=210000U AS=40400000000P
+ AD=21875000000P PS=560000U PD=460000U
* device instance $2459 r0 *1 38.64,9.76 nfet_01v8
M$2459 53 136 3057 167 nfet_01v8 L=150000U W=140000U AS=21875000000P
+ AD=16800000000P PS=460000U PD=380000U
* device instance $2460 r0 *1 39.16,9.76 nfet_01v8
M$2460 56 136 1578 167 nfet_01v8 L=150000U W=140000U AS=21875000000P
+ AD=16800000000P PS=460000U PD=380000U
* device instance $2461 r0 *1 38.64,10.15 nfet_01v8
M$2461 3190 137 53 167 nfet_01v8 L=150000U W=140000U AS=16800000000P
+ AD=21875000000P PS=380000U PD=460000U
* device instance $2462 r0 *1 39.16,10.15 nfet_01v8
M$2462 1004 137 56 167 nfet_01v8 L=150000U W=140000U AS=16800000000P
+ AD=21875000000P PS=380000U PD=460000U
* device instance $2463 r0 *1 38.605,10.55 nfet_01v8
M$2463 167 2924 3190 167 nfet_01v8 L=150000U W=210000U AS=21875000000P
+ AD=40400000000P PS=460000U PD=560000U
* device instance $2464 r0 *1 39.195,10.55 nfet_01v8
M$2464 167 1539 1004 167 nfet_01v8 L=150000U W=210000U AS=21875000000P
+ AD=40400000000P PS=460000U PD=560000U
* device instance $2465 r0 *1 38.605,10.94 nfet_01v8
M$2465 2924 3190 167 167 nfet_01v8 L=150000U W=210000U AS=40400000000P
+ AD=21875000000P PS=560000U PD=460000U
* device instance $2466 r0 *1 39.195,10.94 nfet_01v8
M$2466 1539 1004 167 167 nfet_01v8 L=150000U W=210000U AS=40400000000P
+ AD=21875000000P PS=560000U PD=460000U
* device instance $2467 r0 *1 38.64,11.34 nfet_01v8
M$2467 54 137 2924 167 nfet_01v8 L=150000U W=140000U AS=21875000000P
+ AD=16800000000P PS=460000U PD=380000U
* device instance $2468 r0 *1 39.16,11.34 nfet_01v8
M$2468 55 137 1539 167 nfet_01v8 L=150000U W=140000U AS=21875000000P
+ AD=16800000000P PS=460000U PD=380000U
* device instance $2469 r0 *1 49.54,5.41 nfet_01v8
M$2469 3335 134 70 167 nfet_01v8 L=150000U W=140000U AS=16800000000P
+ AD=21875000000P PS=380000U PD=460000U
* device instance $2470 r0 *1 50.06,5.41 nfet_01v8
M$2470 1165 134 71 167 nfet_01v8 L=150000U W=140000U AS=16800000000P
+ AD=21875000000P PS=380000U PD=460000U
* device instance $2471 r0 *1 49.505,5.81 nfet_01v8
M$2471 167 3099 3335 167 nfet_01v8 L=150000U W=210000U AS=21875000000P
+ AD=40400000000P PS=460000U PD=560000U
* device instance $2472 r0 *1 50.095,5.81 nfet_01v8
M$2472 167 1726 1165 167 nfet_01v8 L=150000U W=210000U AS=21875000000P
+ AD=40400000000P PS=460000U PD=560000U
* device instance $2473 r0 *1 49.505,6.2 nfet_01v8
M$2473 3099 3335 167 167 nfet_01v8 L=150000U W=210000U AS=40400000000P
+ AD=21875000000P PS=560000U PD=460000U
* device instance $2474 r0 *1 50.095,6.2 nfet_01v8
M$2474 1726 1165 167 167 nfet_01v8 L=150000U W=210000U AS=40400000000P
+ AD=21875000000P PS=560000U PD=460000U
* device instance $2475 r0 *1 49.54,6.6 nfet_01v8
M$2475 69 134 3099 167 nfet_01v8 L=150000U W=140000U AS=21875000000P
+ AD=16800000000P PS=460000U PD=380000U
* device instance $2476 r0 *1 50.06,6.6 nfet_01v8
M$2476 72 134 1726 167 nfet_01v8 L=150000U W=140000U AS=21875000000P
+ AD=16800000000P PS=460000U PD=380000U
* device instance $2477 r0 *1 49.54,6.99 nfet_01v8
M$2477 3336 135 69 167 nfet_01v8 L=150000U W=140000U AS=16800000000P
+ AD=21875000000P PS=380000U PD=460000U
* device instance $2478 r0 *1 50.06,6.99 nfet_01v8
M$2478 4323 135 72 167 nfet_01v8 L=150000U W=140000U AS=16800000000P
+ AD=21875000000P PS=380000U PD=460000U
* device instance $2479 r0 *1 49.505,7.39 nfet_01v8
M$2479 167 2206 3336 167 nfet_01v8 L=150000U W=210000U AS=21875000000P
+ AD=40400000000P PS=460000U PD=560000U
* device instance $2480 r0 *1 50.095,7.39 nfet_01v8
M$2480 167 698 4323 167 nfet_01v8 L=150000U W=210000U AS=21875000000P
+ AD=40400000000P PS=460000U PD=560000U
* device instance $2481 r0 *1 49.505,7.78 nfet_01v8
M$2481 2206 3336 167 167 nfet_01v8 L=150000U W=210000U AS=40400000000P
+ AD=21875000000P PS=560000U PD=460000U
* device instance $2482 r0 *1 50.095,7.78 nfet_01v8
M$2482 698 4323 167 167 nfet_01v8 L=150000U W=210000U AS=40400000000P
+ AD=21875000000P PS=560000U PD=460000U
* device instance $2483 r0 *1 49.54,8.18 nfet_01v8
M$2483 70 135 2206 167 nfet_01v8 L=150000U W=140000U AS=21875000000P
+ AD=16800000000P PS=460000U PD=380000U
* device instance $2484 r0 *1 50.06,8.18 nfet_01v8
M$2484 71 135 698 167 nfet_01v8 L=150000U W=140000U AS=21875000000P
+ AD=16800000000P PS=460000U PD=380000U
* device instance $2485 r0 *1 49.54,8.57 nfet_01v8
M$2485 3337 136 70 167 nfet_01v8 L=150000U W=140000U AS=16800000000P
+ AD=21875000000P PS=380000U PD=460000U
* device instance $2486 r0 *1 50.06,8.57 nfet_01v8
M$2486 1080 136 71 167 nfet_01v8 L=150000U W=140000U AS=16800000000P
+ AD=21875000000P PS=380000U PD=460000U
* device instance $2487 r0 *1 49.505,8.97 nfet_01v8
M$2487 167 2208 3337 167 nfet_01v8 L=150000U W=210000U AS=21875000000P
+ AD=40400000000P PS=460000U PD=560000U
* device instance $2488 r0 *1 50.095,8.97 nfet_01v8
M$2488 167 1625 1080 167 nfet_01v8 L=150000U W=210000U AS=21875000000P
+ AD=40400000000P PS=460000U PD=560000U
* device instance $2489 r0 *1 49.505,9.36 nfet_01v8
M$2489 2208 3337 167 167 nfet_01v8 L=150000U W=210000U AS=40400000000P
+ AD=21875000000P PS=560000U PD=460000U
* device instance $2490 r0 *1 50.095,9.36 nfet_01v8
M$2490 1625 1080 167 167 nfet_01v8 L=150000U W=210000U AS=40400000000P
+ AD=21875000000P PS=560000U PD=460000U
* device instance $2491 r0 *1 49.54,9.76 nfet_01v8
M$2491 69 136 2208 167 nfet_01v8 L=150000U W=140000U AS=21875000000P
+ AD=16800000000P PS=460000U PD=380000U
* device instance $2492 r0 *1 50.06,9.76 nfet_01v8
M$2492 72 136 1625 167 nfet_01v8 L=150000U W=140000U AS=21875000000P
+ AD=16800000000P PS=460000U PD=380000U
* device instance $2493 r0 *1 49.54,10.15 nfet_01v8
M$2493 2334 137 69 167 nfet_01v8 L=150000U W=140000U AS=16800000000P
+ AD=21875000000P PS=380000U PD=460000U
* device instance $2494 r0 *1 50.06,10.15 nfet_01v8
M$2494 1172 137 72 167 nfet_01v8 L=150000U W=140000U AS=16800000000P
+ AD=21875000000P PS=380000U PD=460000U
* device instance $2495 r0 *1 49.505,10.55 nfet_01v8
M$2495 167 2686 2334 167 nfet_01v8 L=150000U W=210000U AS=21875000000P
+ AD=40400000000P PS=460000U PD=560000U
* device instance $2496 r0 *1 50.095,10.55 nfet_01v8
M$2496 167 1734 1172 167 nfet_01v8 L=150000U W=210000U AS=21875000000P
+ AD=40400000000P PS=460000U PD=560000U
* device instance $2497 r0 *1 49.505,10.94 nfet_01v8
M$2497 2686 2334 167 167 nfet_01v8 L=150000U W=210000U AS=40400000000P
+ AD=21875000000P PS=560000U PD=460000U
* device instance $2498 r0 *1 50.095,10.94 nfet_01v8
M$2498 1734 1172 167 167 nfet_01v8 L=150000U W=210000U AS=40400000000P
+ AD=21875000000P PS=560000U PD=460000U
* device instance $2499 r0 *1 49.54,11.34 nfet_01v8
M$2499 70 137 2686 167 nfet_01v8 L=150000U W=140000U AS=21875000000P
+ AD=16800000000P PS=460000U PD=380000U
* device instance $2500 r0 *1 50.06,11.34 nfet_01v8
M$2500 71 137 1734 167 nfet_01v8 L=150000U W=140000U AS=21875000000P
+ AD=16800000000P PS=460000U PD=380000U
* device instance $2501 r0 *1 60.44,5.41 nfet_01v8
M$2501 3351 134 86 167 nfet_01v8 L=150000U W=140000U AS=16800000000P
+ AD=21875000000P PS=380000U PD=460000U
* device instance $2502 r0 *1 60.96,5.41 nfet_01v8
M$2502 1090 134 87 167 nfet_01v8 L=150000U W=140000U AS=16800000000P
+ AD=21875000000P PS=380000U PD=460000U
* device instance $2503 r0 *1 60.405,5.81 nfet_01v8
M$2503 167 3087 3351 167 nfet_01v8 L=150000U W=210000U AS=21875000000P
+ AD=40400000000P PS=460000U PD=560000U
* device instance $2504 r0 *1 60.995,5.81 nfet_01v8
M$2504 167 1636 1090 167 nfet_01v8 L=150000U W=210000U AS=21875000000P
+ AD=40400000000P PS=460000U PD=560000U
* device instance $2505 r0 *1 60.405,6.2 nfet_01v8
M$2505 3087 3351 167 167 nfet_01v8 L=150000U W=210000U AS=40400000000P
+ AD=21875000000P PS=560000U PD=460000U
* device instance $2506 r0 *1 60.995,6.2 nfet_01v8
M$2506 1636 1090 167 167 nfet_01v8 L=150000U W=210000U AS=40400000000P
+ AD=21875000000P PS=560000U PD=460000U
* device instance $2507 r0 *1 60.44,6.6 nfet_01v8
M$2507 85 134 3087 167 nfet_01v8 L=150000U W=140000U AS=21875000000P
+ AD=16800000000P PS=460000U PD=380000U
* device instance $2508 r0 *1 60.96,6.6 nfet_01v8
M$2508 88 134 1636 167 nfet_01v8 L=150000U W=140000U AS=21875000000P
+ AD=16800000000P PS=460000U PD=380000U
* device instance $2509 r0 *1 60.44,6.99 nfet_01v8
M$2509 3342 135 85 167 nfet_01v8 L=150000U W=140000U AS=16800000000P
+ AD=21875000000P PS=380000U PD=460000U
* device instance $2510 r0 *1 60.96,6.99 nfet_01v8
M$2510 4330 135 88 167 nfet_01v8 L=150000U W=140000U AS=16800000000P
+ AD=21875000000P PS=380000U PD=460000U
* device instance $2511 r0 *1 60.405,7.39 nfet_01v8
M$2511 167 2267 3342 167 nfet_01v8 L=150000U W=210000U AS=21875000000P
+ AD=40400000000P PS=460000U PD=560000U
* device instance $2512 r0 *1 60.995,7.39 nfet_01v8
M$2512 167 706 4330 167 nfet_01v8 L=150000U W=210000U AS=21875000000P
+ AD=40400000000P PS=460000U PD=560000U
* device instance $2513 r0 *1 60.405,7.78 nfet_01v8
M$2513 2267 3342 167 167 nfet_01v8 L=150000U W=210000U AS=40400000000P
+ AD=21875000000P PS=560000U PD=460000U
* device instance $2514 r0 *1 60.995,7.78 nfet_01v8
M$2514 706 4330 167 167 nfet_01v8 L=150000U W=210000U AS=40400000000P
+ AD=21875000000P PS=560000U PD=460000U
* device instance $2515 r0 *1 60.44,8.18 nfet_01v8
M$2515 86 135 2267 167 nfet_01v8 L=150000U W=140000U AS=21875000000P
+ AD=16800000000P PS=460000U PD=380000U
* device instance $2516 r0 *1 60.96,8.18 nfet_01v8
M$2516 87 135 706 167 nfet_01v8 L=150000U W=140000U AS=21875000000P
+ AD=16800000000P PS=460000U PD=380000U
* device instance $2517 r0 *1 60.44,8.57 nfet_01v8
M$2517 3345 136 86 167 nfet_01v8 L=150000U W=140000U AS=16800000000P
+ AD=21875000000P PS=380000U PD=460000U
* device instance $2518 r0 *1 60.96,8.57 nfet_01v8
M$2518 1087 136 87 167 nfet_01v8 L=150000U W=140000U AS=16800000000P
+ AD=21875000000P PS=380000U PD=460000U
* device instance $2519 r0 *1 60.405,8.97 nfet_01v8
M$2519 167 3073 3345 167 nfet_01v8 L=150000U W=210000U AS=21875000000P
+ AD=40400000000P PS=460000U PD=560000U
* device instance $2520 r0 *1 60.995,8.97 nfet_01v8
M$2520 167 1633 1087 167 nfet_01v8 L=150000U W=210000U AS=21875000000P
+ AD=40400000000P PS=460000U PD=560000U
* device instance $2521 r0 *1 60.405,9.36 nfet_01v8
M$2521 3073 3345 167 167 nfet_01v8 L=150000U W=210000U AS=40400000000P
+ AD=21875000000P PS=560000U PD=460000U
* device instance $2522 r0 *1 60.995,9.36 nfet_01v8
M$2522 1633 1087 167 167 nfet_01v8 L=150000U W=210000U AS=40400000000P
+ AD=21875000000P PS=560000U PD=460000U
* device instance $2523 r0 *1 60.44,9.76 nfet_01v8
M$2523 85 136 3073 167 nfet_01v8 L=150000U W=140000U AS=21875000000P
+ AD=16800000000P PS=460000U PD=380000U
* device instance $2524 r0 *1 60.96,9.76 nfet_01v8
M$2524 88 136 1633 167 nfet_01v8 L=150000U W=140000U AS=21875000000P
+ AD=16800000000P PS=460000U PD=380000U
* device instance $2525 r0 *1 60.44,10.15 nfet_01v8
M$2525 3461 137 85 167 nfet_01v8 L=150000U W=140000U AS=16800000000P
+ AD=21875000000P PS=380000U PD=460000U
* device instance $2526 r0 *1 60.96,10.15 nfet_01v8
M$2526 1173 137 88 167 nfet_01v8 L=150000U W=140000U AS=16800000000P
+ AD=21875000000P PS=380000U PD=460000U
* device instance $2527 r0 *1 60.405,10.55 nfet_01v8
M$2527 167 2683 3461 167 nfet_01v8 L=150000U W=210000U AS=21875000000P
+ AD=40400000000P PS=460000U PD=560000U
* device instance $2528 r0 *1 60.995,10.55 nfet_01v8
M$2528 167 1735 1173 167 nfet_01v8 L=150000U W=210000U AS=21875000000P
+ AD=40400000000P PS=460000U PD=560000U
* device instance $2529 r0 *1 60.405,10.94 nfet_01v8
M$2529 2683 3461 167 167 nfet_01v8 L=150000U W=210000U AS=40400000000P
+ AD=21875000000P PS=560000U PD=460000U
* device instance $2530 r0 *1 60.995,10.94 nfet_01v8
M$2530 1735 1173 167 167 nfet_01v8 L=150000U W=210000U AS=40400000000P
+ AD=21875000000P PS=560000U PD=460000U
* device instance $2531 r0 *1 60.44,11.34 nfet_01v8
M$2531 86 137 2683 167 nfet_01v8 L=150000U W=140000U AS=21875000000P
+ AD=16800000000P PS=460000U PD=380000U
* device instance $2532 r0 *1 60.96,11.34 nfet_01v8
M$2532 87 137 1735 167 nfet_01v8 L=150000U W=140000U AS=21875000000P
+ AD=16800000000P PS=460000U PD=380000U
* device instance $2533 r0 *1 71.34,5.41 nfet_01v8
M$2533 2499 134 102 167 nfet_01v8 L=150000U W=140000U AS=16800000000P
+ AD=21875000000P PS=380000U PD=460000U
* device instance $2534 r0 *1 71.86,5.41 nfet_01v8
M$2534 1095 134 103 167 nfet_01v8 L=150000U W=140000U AS=16800000000P
+ AD=21875000000P PS=380000U PD=460000U
* device instance $2535 r0 *1 71.305,5.81 nfet_01v8
M$2535 167 3020 2499 167 nfet_01v8 L=150000U W=210000U AS=21875000000P
+ AD=40400000000P PS=460000U PD=560000U
* device instance $2536 r0 *1 71.895,5.81 nfet_01v8
M$2536 167 1642 1095 167 nfet_01v8 L=150000U W=210000U AS=21875000000P
+ AD=40400000000P PS=460000U PD=560000U
* device instance $2537 r0 *1 71.305,6.2 nfet_01v8
M$2537 3020 2499 167 167 nfet_01v8 L=150000U W=210000U AS=40400000000P
+ AD=21875000000P PS=560000U PD=460000U
* device instance $2538 r0 *1 71.895,6.2 nfet_01v8
M$2538 1642 1095 167 167 nfet_01v8 L=150000U W=210000U AS=40400000000P
+ AD=21875000000P PS=560000U PD=460000U
* device instance $2539 r0 *1 71.34,6.6 nfet_01v8
M$2539 101 134 3020 167 nfet_01v8 L=150000U W=140000U AS=21875000000P
+ AD=16800000000P PS=460000U PD=380000U
* device instance $2540 r0 *1 71.86,6.6 nfet_01v8
M$2540 104 134 1642 167 nfet_01v8 L=150000U W=140000U AS=21875000000P
+ AD=16800000000P PS=460000U PD=380000U
* device instance $2541 r0 *1 71.34,6.99 nfet_01v8
M$2541 3381 135 101 167 nfet_01v8 L=150000U W=140000U AS=16800000000P
+ AD=21875000000P PS=380000U PD=460000U
* device instance $2542 r0 *1 71.86,6.99 nfet_01v8
M$2542 4335 135 104 167 nfet_01v8 L=150000U W=140000U AS=16800000000P
+ AD=21875000000P PS=380000U PD=460000U
* device instance $2543 r0 *1 71.305,7.39 nfet_01v8
M$2543 167 2182 3381 167 nfet_01v8 L=150000U W=210000U AS=21875000000P
+ AD=40400000000P PS=460000U PD=560000U
* device instance $2544 r0 *1 71.895,7.39 nfet_01v8
M$2544 167 1643 4335 167 nfet_01v8 L=150000U W=210000U AS=21875000000P
+ AD=40400000000P PS=460000U PD=560000U
* device instance $2545 r0 *1 71.305,7.78 nfet_01v8
M$2545 2182 3381 167 167 nfet_01v8 L=150000U W=210000U AS=40400000000P
+ AD=21875000000P PS=560000U PD=460000U
* device instance $2546 r0 *1 71.895,7.78 nfet_01v8
M$2546 1643 4335 167 167 nfet_01v8 L=150000U W=210000U AS=40400000000P
+ AD=21875000000P PS=560000U PD=460000U
* device instance $2547 r0 *1 71.34,8.18 nfet_01v8
M$2547 102 135 2182 167 nfet_01v8 L=150000U W=140000U AS=21875000000P
+ AD=16800000000P PS=460000U PD=380000U
* device instance $2548 r0 *1 71.86,8.18 nfet_01v8
M$2548 103 135 1643 167 nfet_01v8 L=150000U W=140000U AS=21875000000P
+ AD=16800000000P PS=460000U PD=380000U
* device instance $2549 r0 *1 71.34,8.57 nfet_01v8
M$2549 3377 136 102 167 nfet_01v8 L=150000U W=140000U AS=16800000000P
+ AD=21875000000P PS=380000U PD=460000U
* device instance $2550 r0 *1 71.86,8.57 nfet_01v8
M$2550 1096 136 103 167 nfet_01v8 L=150000U W=140000U AS=16800000000P
+ AD=21875000000P PS=380000U PD=460000U
* device instance $2551 r0 *1 71.305,8.97 nfet_01v8
M$2551 167 3016 3377 167 nfet_01v8 L=150000U W=210000U AS=21875000000P
+ AD=40400000000P PS=460000U PD=560000U
* device instance $2552 r0 *1 71.895,8.97 nfet_01v8
M$2552 167 1644 1096 167 nfet_01v8 L=150000U W=210000U AS=21875000000P
+ AD=40400000000P PS=460000U PD=560000U
* device instance $2553 r0 *1 71.305,9.36 nfet_01v8
M$2553 3016 3377 167 167 nfet_01v8 L=150000U W=210000U AS=40400000000P
+ AD=21875000000P PS=560000U PD=460000U
* device instance $2554 r0 *1 71.895,9.36 nfet_01v8
M$2554 1644 1096 167 167 nfet_01v8 L=150000U W=210000U AS=40400000000P
+ AD=21875000000P PS=560000U PD=460000U
* device instance $2555 r0 *1 71.34,9.76 nfet_01v8
M$2555 101 136 3016 167 nfet_01v8 L=150000U W=140000U AS=21875000000P
+ AD=16800000000P PS=460000U PD=380000U
* device instance $2556 r0 *1 71.86,9.76 nfet_01v8
M$2556 104 136 1644 167 nfet_01v8 L=150000U W=140000U AS=21875000000P
+ AD=16800000000P PS=460000U PD=380000U
* device instance $2557 r0 *1 71.34,10.15 nfet_01v8
M$2557 2514 137 101 167 nfet_01v8 L=150000U W=140000U AS=16800000000P
+ AD=21875000000P PS=380000U PD=460000U
* device instance $2558 r0 *1 71.86,10.15 nfet_01v8
M$2558 1063 137 104 167 nfet_01v8 L=150000U W=140000U AS=16800000000P
+ AD=21875000000P PS=380000U PD=460000U
* device instance $2559 r0 *1 71.305,10.55 nfet_01v8
M$2559 167 3065 2514 167 nfet_01v8 L=150000U W=210000U AS=21875000000P
+ AD=40400000000P PS=460000U PD=560000U
* device instance $2560 r0 *1 71.895,10.55 nfet_01v8
M$2560 167 1607 1063 167 nfet_01v8 L=150000U W=210000U AS=21875000000P
+ AD=40400000000P PS=460000U PD=560000U
* device instance $2561 r0 *1 71.305,10.94 nfet_01v8
M$2561 3065 2514 167 167 nfet_01v8 L=150000U W=210000U AS=40400000000P
+ AD=21875000000P PS=560000U PD=460000U
* device instance $2562 r0 *1 71.895,10.94 nfet_01v8
M$2562 1607 1063 167 167 nfet_01v8 L=150000U W=210000U AS=40400000000P
+ AD=21875000000P PS=560000U PD=460000U
* device instance $2563 r0 *1 71.34,11.34 nfet_01v8
M$2563 102 137 3065 167 nfet_01v8 L=150000U W=140000U AS=21875000000P
+ AD=16800000000P PS=460000U PD=380000U
* device instance $2564 r0 *1 71.86,11.34 nfet_01v8
M$2564 103 137 1607 167 nfet_01v8 L=150000U W=140000U AS=21875000000P
+ AD=16800000000P PS=460000U PD=380000U
* device instance $2565 r0 *1 82.24,5.41 nfet_01v8
M$2565 3386 134 118 167 nfet_01v8 L=150000U W=140000U AS=16800000000P
+ AD=21875000000P PS=380000U PD=460000U
* device instance $2566 r0 *1 82.76,5.41 nfet_01v8
M$2566 1105 134 119 167 nfet_01v8 L=150000U W=140000U AS=16800000000P
+ AD=21875000000P PS=380000U PD=460000U
* device instance $2567 r0 *1 82.205,5.81 nfet_01v8
M$2567 167 3008 3386 167 nfet_01v8 L=150000U W=210000U AS=21875000000P
+ AD=40400000000P PS=460000U PD=560000U
* device instance $2568 r0 *1 82.795,5.81 nfet_01v8
M$2568 167 1657 1105 167 nfet_01v8 L=150000U W=210000U AS=21875000000P
+ AD=40400000000P PS=460000U PD=560000U
* device instance $2569 r0 *1 82.205,6.2 nfet_01v8
M$2569 3008 3386 167 167 nfet_01v8 L=150000U W=210000U AS=40400000000P
+ AD=21875000000P PS=560000U PD=460000U
* device instance $2570 r0 *1 82.795,6.2 nfet_01v8
M$2570 1657 1105 167 167 nfet_01v8 L=150000U W=210000U AS=40400000000P
+ AD=21875000000P PS=560000U PD=460000U
* device instance $2571 r0 *1 82.24,6.6 nfet_01v8
M$2571 117 134 3008 167 nfet_01v8 L=150000U W=140000U AS=21875000000P
+ AD=16800000000P PS=460000U PD=380000U
* device instance $2572 r0 *1 82.76,6.6 nfet_01v8
M$2572 120 134 1657 167 nfet_01v8 L=150000U W=140000U AS=21875000000P
+ AD=16800000000P PS=460000U PD=380000U
* device instance $2573 r0 *1 82.24,6.99 nfet_01v8
M$2573 3385 135 117 167 nfet_01v8 L=150000U W=140000U AS=16800000000P
+ AD=21875000000P PS=380000U PD=460000U
* device instance $2574 r0 *1 82.76,6.99 nfet_01v8
M$2574 4339 135 120 167 nfet_01v8 L=150000U W=140000U AS=16800000000P
+ AD=21875000000P PS=380000U PD=460000U
* device instance $2575 r0 *1 82.205,7.39 nfet_01v8
M$2575 167 2028 3385 167 nfet_01v8 L=150000U W=210000U AS=21875000000P
+ AD=40400000000P PS=460000U PD=560000U
* device instance $2576 r0 *1 82.795,7.39 nfet_01v8
M$2576 167 1651 4339 167 nfet_01v8 L=150000U W=210000U AS=21875000000P
+ AD=40400000000P PS=460000U PD=560000U
* device instance $2577 r0 *1 82.205,7.78 nfet_01v8
M$2577 2028 3385 167 167 nfet_01v8 L=150000U W=210000U AS=40400000000P
+ AD=21875000000P PS=560000U PD=460000U
* device instance $2578 r0 *1 82.795,7.78 nfet_01v8
M$2578 1651 4339 167 167 nfet_01v8 L=150000U W=210000U AS=40400000000P
+ AD=21875000000P PS=560000U PD=460000U
* device instance $2579 r0 *1 82.24,8.18 nfet_01v8
M$2579 118 135 2028 167 nfet_01v8 L=150000U W=140000U AS=21875000000P
+ AD=16800000000P PS=460000U PD=380000U
* device instance $2580 r0 *1 82.76,8.18 nfet_01v8
M$2580 119 135 1651 167 nfet_01v8 L=150000U W=140000U AS=21875000000P
+ AD=16800000000P PS=460000U PD=380000U
* device instance $2581 r0 *1 82.24,8.57 nfet_01v8
M$2581 2496 136 118 167 nfet_01v8 L=150000U W=140000U AS=16800000000P
+ AD=21875000000P PS=380000U PD=460000U
* device instance $2582 r0 *1 82.76,8.57 nfet_01v8
M$2582 1101 136 119 167 nfet_01v8 L=150000U W=140000U AS=16800000000P
+ AD=21875000000P PS=380000U PD=460000U
* device instance $2583 r0 *1 82.205,8.97 nfet_01v8
M$2583 167 3014 2496 167 nfet_01v8 L=150000U W=210000U AS=21875000000P
+ AD=40400000000P PS=460000U PD=560000U
* device instance $2584 r0 *1 82.795,8.97 nfet_01v8
M$2584 167 1652 1101 167 nfet_01v8 L=150000U W=210000U AS=21875000000P
+ AD=40400000000P PS=460000U PD=560000U
* device instance $2585 r0 *1 82.205,9.36 nfet_01v8
M$2585 3014 2496 167 167 nfet_01v8 L=150000U W=210000U AS=40400000000P
+ AD=21875000000P PS=560000U PD=460000U
* device instance $2586 r0 *1 82.795,9.36 nfet_01v8
M$2586 1652 1101 167 167 nfet_01v8 L=150000U W=210000U AS=40400000000P
+ AD=21875000000P PS=560000U PD=460000U
* device instance $2587 r0 *1 82.24,9.76 nfet_01v8
M$2587 117 136 3014 167 nfet_01v8 L=150000U W=140000U AS=21875000000P
+ AD=16800000000P PS=460000U PD=380000U
* device instance $2588 r0 *1 82.76,9.76 nfet_01v8
M$2588 120 136 1652 167 nfet_01v8 L=150000U W=140000U AS=21875000000P
+ AD=16800000000P PS=460000U PD=380000U
* device instance $2589 r0 *1 82.24,10.15 nfet_01v8
M$2589 2512 137 117 167 nfet_01v8 L=150000U W=140000U AS=16800000000P
+ AD=21875000000P PS=380000U PD=460000U
* device instance $2590 r0 *1 82.76,10.15 nfet_01v8
M$2590 1088 137 120 167 nfet_01v8 L=150000U W=140000U AS=16800000000P
+ AD=21875000000P PS=380000U PD=460000U
* device instance $2591 r0 *1 82.205,10.55 nfet_01v8
M$2591 167 3058 2512 167 nfet_01v8 L=150000U W=210000U AS=21875000000P
+ AD=40400000000P PS=460000U PD=560000U
* device instance $2592 r0 *1 82.795,10.55 nfet_01v8
M$2592 167 1634 1088 167 nfet_01v8 L=150000U W=210000U AS=21875000000P
+ AD=40400000000P PS=460000U PD=560000U
* device instance $2593 r0 *1 82.205,10.94 nfet_01v8
M$2593 3058 2512 167 167 nfet_01v8 L=150000U W=210000U AS=40400000000P
+ AD=21875000000P PS=560000U PD=460000U
* device instance $2594 r0 *1 82.795,10.94 nfet_01v8
M$2594 1634 1088 167 167 nfet_01v8 L=150000U W=210000U AS=40400000000P
+ AD=21875000000P PS=560000U PD=460000U
* device instance $2595 r0 *1 82.24,11.34 nfet_01v8
M$2595 118 137 3058 167 nfet_01v8 L=150000U W=140000U AS=21875000000P
+ AD=16800000000P PS=460000U PD=380000U
* device instance $2596 r0 *1 82.76,11.34 nfet_01v8
M$2596 119 137 1634 167 nfet_01v8 L=150000U W=140000U AS=21875000000P
+ AD=16800000000P PS=460000U PD=380000U
* device instance $2597 r0 *1 82.24,13.31 nfet_01v8
M$2597 2474 138 118 167 nfet_01v8 L=150000U W=140000U AS=16800000000P
+ AD=21875000000P PS=380000U PD=460000U
* device instance $2598 r0 *1 82.76,13.31 nfet_01v8
M$2598 1110 138 119 167 nfet_01v8 L=150000U W=140000U AS=16800000000P
+ AD=21875000000P PS=380000U PD=460000U
* device instance $2599 r0 *1 82.205,13.71 nfet_01v8
M$2599 167 2972 2474 167 nfet_01v8 L=150000U W=210000U AS=21875000000P
+ AD=40400000000P PS=460000U PD=560000U
* device instance $2600 r0 *1 82.795,13.71 nfet_01v8
M$2600 167 1663 1110 167 nfet_01v8 L=150000U W=210000U AS=21875000000P
+ AD=40400000000P PS=460000U PD=560000U
* device instance $2601 r0 *1 82.205,14.1 nfet_01v8
M$2601 2972 2474 167 167 nfet_01v8 L=150000U W=210000U AS=40400000000P
+ AD=21875000000P PS=560000U PD=460000U
* device instance $2602 r0 *1 82.795,14.1 nfet_01v8
M$2602 1663 1110 167 167 nfet_01v8 L=150000U W=210000U AS=40400000000P
+ AD=21875000000P PS=560000U PD=460000U
* device instance $2603 r0 *1 82.24,14.5 nfet_01v8
M$2603 117 138 2972 167 nfet_01v8 L=150000U W=140000U AS=21875000000P
+ AD=16800000000P PS=460000U PD=380000U
* device instance $2604 r0 *1 82.76,14.5 nfet_01v8
M$2604 120 138 1663 167 nfet_01v8 L=150000U W=140000U AS=21875000000P
+ AD=16800000000P PS=460000U PD=380000U
* device instance $2605 r0 *1 82.24,14.89 nfet_01v8
M$2605 3391 139 117 167 nfet_01v8 L=150000U W=140000U AS=16800000000P
+ AD=21875000000P PS=380000U PD=460000U
* device instance $2606 r0 *1 82.76,14.89 nfet_01v8
M$2606 4321 139 120 167 nfet_01v8 L=150000U W=140000U AS=16800000000P
+ AD=21875000000P PS=380000U PD=460000U
* device instance $2607 r0 *1 82.205,15.29 nfet_01v8
M$2607 167 2056 3391 167 nfet_01v8 L=150000U W=210000U AS=21875000000P
+ AD=40400000000P PS=460000U PD=560000U
* device instance $2608 r0 *1 82.795,15.29 nfet_01v8
M$2608 167 714 4321 167 nfet_01v8 L=150000U W=210000U AS=21875000000P
+ AD=40400000000P PS=460000U PD=560000U
* device instance $2609 r0 *1 82.205,15.68 nfet_01v8
M$2609 2056 3391 167 167 nfet_01v8 L=150000U W=210000U AS=40400000000P
+ AD=21875000000P PS=560000U PD=460000U
* device instance $2610 r0 *1 82.795,15.68 nfet_01v8
M$2610 714 4321 167 167 nfet_01v8 L=150000U W=210000U AS=40400000000P
+ AD=21875000000P PS=560000U PD=460000U
* device instance $2611 r0 *1 82.24,16.08 nfet_01v8
M$2611 118 139 2056 167 nfet_01v8 L=150000U W=140000U AS=21875000000P
+ AD=16800000000P PS=460000U PD=380000U
* device instance $2612 r0 *1 82.76,16.08 nfet_01v8
M$2612 119 139 714 167 nfet_01v8 L=150000U W=140000U AS=21875000000P
+ AD=16800000000P PS=460000U PD=380000U
* device instance $2613 r0 *1 82.24,16.47 nfet_01v8
M$2613 2478 140 118 167 nfet_01v8 L=150000U W=140000U AS=16800000000P
+ AD=21875000000P PS=380000U PD=460000U
* device instance $2614 r0 *1 82.76,16.47 nfet_01v8
M$2614 595 140 119 167 nfet_01v8 L=150000U W=140000U AS=16800000000P
+ AD=21875000000P PS=380000U PD=460000U
* device instance $2615 r0 *1 82.205,16.87 nfet_01v8
M$2615 167 2979 2478 167 nfet_01v8 L=150000U W=210000U AS=21875000000P
+ AD=40400000000P PS=460000U PD=560000U
* device instance $2616 r0 *1 82.795,16.87 nfet_01v8
M$2616 167 712 595 167 nfet_01v8 L=150000U W=210000U AS=21875000000P
+ AD=40400000000P PS=460000U PD=560000U
* device instance $2617 r0 *1 82.205,17.26 nfet_01v8
M$2617 2979 2478 167 167 nfet_01v8 L=150000U W=210000U AS=40400000000P
+ AD=21875000000P PS=560000U PD=460000U
* device instance $2618 r0 *1 82.795,17.26 nfet_01v8
M$2618 712 595 167 167 nfet_01v8 L=150000U W=210000U AS=40400000000P
+ AD=21875000000P PS=560000U PD=460000U
* device instance $2619 r0 *1 82.24,17.66 nfet_01v8
M$2619 117 140 2979 167 nfet_01v8 L=150000U W=140000U AS=21875000000P
+ AD=16800000000P PS=460000U PD=380000U
* device instance $2620 r0 *1 82.76,17.66 nfet_01v8
M$2620 120 140 712 167 nfet_01v8 L=150000U W=140000U AS=21875000000P
+ AD=16800000000P PS=460000U PD=380000U
* device instance $2621 r0 *1 82.24,18.05 nfet_01v8
M$2621 3396 141 117 167 nfet_01v8 L=150000U W=140000U AS=16800000000P
+ AD=21875000000P PS=380000U PD=460000U
* device instance $2622 r0 *1 82.76,18.05 nfet_01v8
M$2622 1075 141 120 167 nfet_01v8 L=150000U W=140000U AS=16800000000P
+ AD=21875000000P PS=380000U PD=460000U
* device instance $2623 r0 *1 82.205,18.45 nfet_01v8
M$2623 167 2955 3396 167 nfet_01v8 L=150000U W=210000U AS=21875000000P
+ AD=40400000000P PS=460000U PD=560000U
* device instance $2624 r0 *1 82.795,18.45 nfet_01v8
M$2624 167 1620 1075 167 nfet_01v8 L=150000U W=210000U AS=21875000000P
+ AD=40400000000P PS=460000U PD=560000U
* device instance $2625 r0 *1 82.205,18.84 nfet_01v8
M$2625 2955 3396 167 167 nfet_01v8 L=150000U W=210000U AS=40400000000P
+ AD=21875000000P PS=560000U PD=460000U
* device instance $2626 r0 *1 82.795,18.84 nfet_01v8
M$2626 1620 1075 167 167 nfet_01v8 L=150000U W=210000U AS=40400000000P
+ AD=21875000000P PS=560000U PD=460000U
* device instance $2627 r0 *1 82.24,19.24 nfet_01v8
M$2627 118 141 2955 167 nfet_01v8 L=150000U W=140000U AS=21875000000P
+ AD=16800000000P PS=460000U PD=380000U
* device instance $2628 r0 *1 82.76,19.24 nfet_01v8
M$2628 119 141 1620 167 nfet_01v8 L=150000U W=140000U AS=21875000000P
+ AD=16800000000P PS=460000U PD=380000U
* device instance $2629 r0 *1 16.84,29.11 nfet_01v8
M$2629 3289 146 22 167 nfet_01v8 L=150000U W=140000U AS=16800000000P
+ AD=21875000000P PS=380000U PD=460000U
* device instance $2630 r0 *1 17.36,29.11 nfet_01v8
M$2630 1373 146 23 167 nfet_01v8 L=150000U W=140000U AS=16800000000P
+ AD=21875000000P PS=380000U PD=460000U
* device instance $2631 r0 *1 16.805,29.51 nfet_01v8
M$2631 167 2811 3289 167 nfet_01v8 L=150000U W=210000U AS=21875000000P
+ AD=40400000000P PS=460000U PD=560000U
* device instance $2632 r0 *1 17.395,29.51 nfet_01v8
M$2632 167 1965 1373 167 nfet_01v8 L=150000U W=210000U AS=21875000000P
+ AD=40400000000P PS=460000U PD=560000U
* device instance $2633 r0 *1 16.805,29.9 nfet_01v8
M$2633 2811 3289 167 167 nfet_01v8 L=150000U W=210000U AS=40400000000P
+ AD=21875000000P PS=560000U PD=460000U
* device instance $2634 r0 *1 17.395,29.9 nfet_01v8
M$2634 1965 1373 167 167 nfet_01v8 L=150000U W=210000U AS=40400000000P
+ AD=21875000000P PS=560000U PD=460000U
* device instance $2635 r0 *1 16.84,30.3 nfet_01v8
M$2635 21 146 2811 167 nfet_01v8 L=150000U W=140000U AS=21875000000P
+ AD=16800000000P PS=460000U PD=380000U
* device instance $2636 r0 *1 17.36,30.3 nfet_01v8
M$2636 24 146 1965 167 nfet_01v8 L=150000U W=140000U AS=21875000000P
+ AD=16800000000P PS=460000U PD=380000U
* device instance $2637 r0 *1 16.84,30.69 nfet_01v8
M$2637 3288 147 21 167 nfet_01v8 L=150000U W=140000U AS=16800000000P
+ AD=21875000000P PS=380000U PD=460000U
* device instance $2638 r0 *1 17.36,30.69 nfet_01v8
M$2638 4511 147 24 167 nfet_01v8 L=150000U W=140000U AS=16800000000P
+ AD=21875000000P PS=380000U PD=460000U
* device instance $2639 r0 *1 16.805,31.09 nfet_01v8
M$2639 167 2216 3288 167 nfet_01v8 L=150000U W=210000U AS=21875000000P
+ AD=40400000000P PS=460000U PD=560000U
* device instance $2640 r0 *1 17.395,31.09 nfet_01v8
M$2640 167 829 4511 167 nfet_01v8 L=150000U W=210000U AS=21875000000P
+ AD=40400000000P PS=460000U PD=560000U
* device instance $2641 r0 *1 16.805,31.48 nfet_01v8
M$2641 2216 3288 167 167 nfet_01v8 L=150000U W=210000U AS=40400000000P
+ AD=21875000000P PS=560000U PD=460000U
* device instance $2642 r0 *1 17.395,31.48 nfet_01v8
M$2642 829 4511 167 167 nfet_01v8 L=150000U W=210000U AS=40400000000P
+ AD=21875000000P PS=560000U PD=460000U
* device instance $2643 r0 *1 16.84,31.88 nfet_01v8
M$2643 22 147 2216 167 nfet_01v8 L=150000U W=140000U AS=21875000000P
+ AD=16800000000P PS=460000U PD=380000U
* device instance $2644 r0 *1 17.36,31.88 nfet_01v8
M$2644 23 147 829 167 nfet_01v8 L=150000U W=140000U AS=21875000000P
+ AD=16800000000P PS=460000U PD=380000U
* device instance $2645 r0 *1 16.84,32.27 nfet_01v8
M$2645 3287 148 22 167 nfet_01v8 L=150000U W=140000U AS=16800000000P
+ AD=21875000000P PS=380000U PD=460000U
* device instance $2646 r0 *1 17.36,32.27 nfet_01v8
M$2646 658 148 23 167 nfet_01v8 L=150000U W=140000U AS=16800000000P
+ AD=21875000000P PS=380000U PD=460000U
* device instance $2647 r0 *1 16.805,32.67 nfet_01v8
M$2647 167 2231 3287 167 nfet_01v8 L=150000U W=210000U AS=21875000000P
+ AD=40400000000P PS=460000U PD=560000U
* device instance $2648 r0 *1 17.395,32.67 nfet_01v8
M$2648 167 838 658 167 nfet_01v8 L=150000U W=210000U AS=21875000000P
+ AD=40400000000P PS=460000U PD=560000U
* device instance $2649 r0 *1 16.805,33.06 nfet_01v8
M$2649 2231 3287 167 167 nfet_01v8 L=150000U W=210000U AS=40400000000P
+ AD=21875000000P PS=560000U PD=460000U
* device instance $2650 r0 *1 17.395,33.06 nfet_01v8
M$2650 838 658 167 167 nfet_01v8 L=150000U W=210000U AS=40400000000P
+ AD=21875000000P PS=560000U PD=460000U
* device instance $2651 r0 *1 16.84,33.46 nfet_01v8
M$2651 21 148 2231 167 nfet_01v8 L=150000U W=140000U AS=21875000000P
+ AD=16800000000P PS=460000U PD=380000U
* device instance $2652 r0 *1 17.36,33.46 nfet_01v8
M$2652 24 148 838 167 nfet_01v8 L=150000U W=140000U AS=21875000000P
+ AD=16800000000P PS=460000U PD=380000U
* device instance $2653 r0 *1 16.84,33.85 nfet_01v8
M$2653 2393 149 21 167 nfet_01v8 L=150000U W=140000U AS=16800000000P
+ AD=21875000000P PS=380000U PD=460000U
* device instance $2654 r0 *1 17.36,33.85 nfet_01v8
M$2654 1215 149 24 167 nfet_01v8 L=150000U W=140000U AS=16800000000P
+ AD=21875000000P PS=380000U PD=460000U
* device instance $2655 r0 *1 16.805,34.25 nfet_01v8
M$2655 167 2806 2393 167 nfet_01v8 L=150000U W=210000U AS=21875000000P
+ AD=40400000000P PS=460000U PD=560000U
* device instance $2656 r0 *1 17.395,34.25 nfet_01v8
M$2656 167 1786 1215 167 nfet_01v8 L=150000U W=210000U AS=21875000000P
+ AD=40400000000P PS=460000U PD=560000U
* device instance $2657 r0 *1 16.805,34.64 nfet_01v8
M$2657 2806 2393 167 167 nfet_01v8 L=150000U W=210000U AS=40400000000P
+ AD=21875000000P PS=560000U PD=460000U
* device instance $2658 r0 *1 17.395,34.64 nfet_01v8
M$2658 1786 1215 167 167 nfet_01v8 L=150000U W=210000U AS=40400000000P
+ AD=21875000000P PS=560000U PD=460000U
* device instance $2659 r0 *1 16.84,35.04 nfet_01v8
M$2659 22 149 2806 167 nfet_01v8 L=150000U W=140000U AS=21875000000P
+ AD=16800000000P PS=460000U PD=380000U
* device instance $2660 r0 *1 17.36,35.04 nfet_01v8
M$2660 23 149 1786 167 nfet_01v8 L=150000U W=140000U AS=21875000000P
+ AD=16800000000P PS=460000U PD=380000U
* device instance $2661 r0 *1 27.74,29.11 nfet_01v8
M$2661 2429 146 38 167 nfet_01v8 L=150000U W=140000U AS=16800000000P
+ AD=21875000000P PS=380000U PD=460000U
* device instance $2662 r0 *1 28.26,29.11 nfet_01v8
M$2662 1198 146 39 167 nfet_01v8 L=150000U W=140000U AS=16800000000P
+ AD=21875000000P PS=380000U PD=460000U
* device instance $2663 r0 *1 27.705,29.51 nfet_01v8
M$2663 167 2868 2429 167 nfet_01v8 L=150000U W=210000U AS=21875000000P
+ AD=40400000000P PS=460000U PD=560000U
* device instance $2664 r0 *1 28.295,29.51 nfet_01v8
M$2664 167 1767 1198 167 nfet_01v8 L=150000U W=210000U AS=21875000000P
+ AD=40400000000P PS=460000U PD=560000U
* device instance $2665 r0 *1 27.705,29.9 nfet_01v8
M$2665 2868 2429 167 167 nfet_01v8 L=150000U W=210000U AS=40400000000P
+ AD=21875000000P PS=560000U PD=460000U
* device instance $2666 r0 *1 28.295,29.9 nfet_01v8
M$2666 1767 1198 167 167 nfet_01v8 L=150000U W=210000U AS=40400000000P
+ AD=21875000000P PS=560000U PD=460000U
* device instance $2667 r0 *1 27.74,30.3 nfet_01v8
M$2667 37 146 2868 167 nfet_01v8 L=150000U W=140000U AS=21875000000P
+ AD=16800000000P PS=460000U PD=380000U
* device instance $2668 r0 *1 28.26,30.3 nfet_01v8
M$2668 40 146 1767 167 nfet_01v8 L=150000U W=140000U AS=21875000000P
+ AD=16800000000P PS=460000U PD=380000U
* device instance $2669 r0 *1 27.74,30.69 nfet_01v8
M$2669 3657 147 37 167 nfet_01v8 L=150000U W=140000U AS=16800000000P
+ AD=21875000000P PS=380000U PD=460000U
* device instance $2670 r0 *1 28.26,30.69 nfet_01v8
M$2670 4417 147 40 167 nfet_01v8 L=150000U W=140000U AS=16800000000P
+ AD=21875000000P PS=380000U PD=460000U
* device instance $2671 r0 *1 27.705,31.09 nfet_01v8
M$2671 167 2188 3657 167 nfet_01v8 L=150000U W=210000U AS=21875000000P
+ AD=40400000000P PS=460000U PD=560000U
* device instance $2672 r0 *1 28.295,31.09 nfet_01v8
M$2672 167 732 4417 167 nfet_01v8 L=150000U W=210000U AS=21875000000P
+ AD=40400000000P PS=460000U PD=560000U
* device instance $2673 r0 *1 27.705,31.48 nfet_01v8
M$2673 2188 3657 167 167 nfet_01v8 L=150000U W=210000U AS=40400000000P
+ AD=21875000000P PS=560000U PD=460000U
* device instance $2674 r0 *1 28.295,31.48 nfet_01v8
M$2674 732 4417 167 167 nfet_01v8 L=150000U W=210000U AS=40400000000P
+ AD=21875000000P PS=560000U PD=460000U
* device instance $2675 r0 *1 27.74,31.88 nfet_01v8
M$2675 38 147 2188 167 nfet_01v8 L=150000U W=140000U AS=21875000000P
+ AD=16800000000P PS=460000U PD=380000U
* device instance $2676 r0 *1 28.26,31.88 nfet_01v8
M$2676 39 147 732 167 nfet_01v8 L=150000U W=140000U AS=21875000000P
+ AD=16800000000P PS=460000U PD=380000U
* device instance $2677 r0 *1 27.74,32.27 nfet_01v8
M$2677 2435 148 38 167 nfet_01v8 L=150000U W=140000U AS=16800000000P
+ AD=21875000000P PS=380000U PD=460000U
* device instance $2678 r0 *1 28.26,32.27 nfet_01v8
M$2678 608 148 39 167 nfet_01v8 L=150000U W=140000U AS=16800000000P
+ AD=21875000000P PS=380000U PD=460000U
* device instance $2679 r0 *1 27.705,32.67 nfet_01v8
M$2679 167 2888 2435 167 nfet_01v8 L=150000U W=210000U AS=21875000000P
+ AD=40400000000P PS=460000U PD=560000U
* device instance $2680 r0 *1 28.295,32.67 nfet_01v8
M$2680 167 735 608 167 nfet_01v8 L=150000U W=210000U AS=21875000000P
+ AD=40400000000P PS=460000U PD=560000U
* device instance $2681 r0 *1 27.705,33.06 nfet_01v8
M$2681 2888 2435 167 167 nfet_01v8 L=150000U W=210000U AS=40400000000P
+ AD=21875000000P PS=560000U PD=460000U
* device instance $2682 r0 *1 28.295,33.06 nfet_01v8
M$2682 735 608 167 167 nfet_01v8 L=150000U W=210000U AS=40400000000P
+ AD=21875000000P PS=560000U PD=460000U
* device instance $2683 r0 *1 27.74,33.46 nfet_01v8
M$2683 37 148 2888 167 nfet_01v8 L=150000U W=140000U AS=21875000000P
+ AD=16800000000P PS=460000U PD=380000U
* device instance $2684 r0 *1 28.26,33.46 nfet_01v8
M$2684 40 148 735 167 nfet_01v8 L=150000U W=140000U AS=21875000000P
+ AD=16800000000P PS=460000U PD=380000U
* device instance $2685 r0 *1 27.74,33.85 nfet_01v8
M$2685 2436 149 37 167 nfet_01v8 L=150000U W=140000U AS=16800000000P
+ AD=21875000000P PS=380000U PD=460000U
* device instance $2686 r0 *1 28.26,33.85 nfet_01v8
M$2686 1196 149 40 167 nfet_01v8 L=150000U W=140000U AS=16800000000P
+ AD=21875000000P PS=380000U PD=460000U
* device instance $2687 r0 *1 27.705,34.25 nfet_01v8
M$2687 167 2890 2436 167 nfet_01v8 L=150000U W=210000U AS=21875000000P
+ AD=40400000000P PS=460000U PD=560000U
* device instance $2688 r0 *1 28.295,34.25 nfet_01v8
M$2688 167 1764 1196 167 nfet_01v8 L=150000U W=210000U AS=21875000000P
+ AD=40400000000P PS=460000U PD=560000U
* device instance $2689 r0 *1 27.705,34.64 nfet_01v8
M$2689 2890 2436 167 167 nfet_01v8 L=150000U W=210000U AS=40400000000P
+ AD=21875000000P PS=560000U PD=460000U
* device instance $2690 r0 *1 28.295,34.64 nfet_01v8
M$2690 1764 1196 167 167 nfet_01v8 L=150000U W=210000U AS=40400000000P
+ AD=21875000000P PS=560000U PD=460000U
* device instance $2691 r0 *1 27.74,35.04 nfet_01v8
M$2691 38 149 2890 167 nfet_01v8 L=150000U W=140000U AS=21875000000P
+ AD=16800000000P PS=460000U PD=380000U
* device instance $2692 r0 *1 28.26,35.04 nfet_01v8
M$2692 39 149 1764 167 nfet_01v8 L=150000U W=140000U AS=21875000000P
+ AD=16800000000P PS=460000U PD=380000U
* device instance $2693 r0 *1 38.64,29.11 nfet_01v8
M$2693 2349 146 54 167 nfet_01v8 L=150000U W=140000U AS=16800000000P
+ AD=21875000000P PS=380000U PD=460000U
* device instance $2694 r0 *1 39.16,29.11 nfet_01v8
M$2694 1280 146 55 167 nfet_01v8 L=150000U W=140000U AS=16800000000P
+ AD=21875000000P PS=380000U PD=460000U
* device instance $2695 r0 *1 38.605,29.51 nfet_01v8
M$2695 167 2724 2349 167 nfet_01v8 L=150000U W=210000U AS=21875000000P
+ AD=40400000000P PS=460000U PD=560000U
* device instance $2696 r0 *1 39.195,29.51 nfet_01v8
M$2696 167 1857 1280 167 nfet_01v8 L=150000U W=210000U AS=21875000000P
+ AD=40400000000P PS=460000U PD=560000U
* device instance $2697 r0 *1 38.605,29.9 nfet_01v8
M$2697 2724 2349 167 167 nfet_01v8 L=150000U W=210000U AS=40400000000P
+ AD=21875000000P PS=560000U PD=460000U
* device instance $2698 r0 *1 39.195,29.9 nfet_01v8
M$2698 1857 1280 167 167 nfet_01v8 L=150000U W=210000U AS=40400000000P
+ AD=21875000000P PS=560000U PD=460000U
* device instance $2699 r0 *1 38.64,30.3 nfet_01v8
M$2699 53 146 2724 167 nfet_01v8 L=150000U W=140000U AS=21875000000P
+ AD=16800000000P PS=460000U PD=380000U
* device instance $2700 r0 *1 39.16,30.3 nfet_01v8
M$2700 56 146 1857 167 nfet_01v8 L=150000U W=140000U AS=21875000000P
+ AD=16800000000P PS=460000U PD=380000U
* device instance $2701 r0 *1 38.64,30.69 nfet_01v8
M$2701 3683 147 53 167 nfet_01v8 L=150000U W=140000U AS=16800000000P
+ AD=21875000000P PS=380000U PD=460000U
* device instance $2702 r0 *1 39.16,30.69 nfet_01v8
M$2702 4413 147 56 167 nfet_01v8 L=150000U W=140000U AS=16800000000P
+ AD=21875000000P PS=380000U PD=460000U
* device instance $2703 r0 *1 38.605,31.09 nfet_01v8
M$2703 167 2205 3683 167 nfet_01v8 L=150000U W=210000U AS=21875000000P
+ AD=40400000000P PS=460000U PD=560000U
* device instance $2704 r0 *1 39.195,31.09 nfet_01v8
M$2704 167 740 4413 167 nfet_01v8 L=150000U W=210000U AS=21875000000P
+ AD=40400000000P PS=460000U PD=560000U
* device instance $2705 r0 *1 38.605,31.48 nfet_01v8
M$2705 2205 3683 167 167 nfet_01v8 L=150000U W=210000U AS=40400000000P
+ AD=21875000000P PS=560000U PD=460000U
* device instance $2706 r0 *1 39.195,31.48 nfet_01v8
M$2706 740 4413 167 167 nfet_01v8 L=150000U W=210000U AS=40400000000P
+ AD=21875000000P PS=560000U PD=460000U
* device instance $2707 r0 *1 38.64,31.88 nfet_01v8
M$2707 54 147 2205 167 nfet_01v8 L=150000U W=140000U AS=21875000000P
+ AD=16800000000P PS=460000U PD=380000U
* device instance $2708 r0 *1 39.16,31.88 nfet_01v8
M$2708 55 147 740 167 nfet_01v8 L=150000U W=140000U AS=21875000000P
+ AD=16800000000P PS=460000U PD=380000U
* device instance $2709 r0 *1 38.64,32.27 nfet_01v8
M$2709 2103 148 54 167 nfet_01v8 L=150000U W=140000U AS=16800000000P
+ AD=21875000000P PS=380000U PD=460000U
* device instance $2710 r0 *1 39.16,32.27 nfet_01v8
M$2710 1282 148 55 167 nfet_01v8 L=150000U W=140000U AS=16800000000P
+ AD=21875000000P PS=380000U PD=460000U
* device instance $2711 r0 *1 38.605,32.67 nfet_01v8
M$2711 167 2211 2103 167 nfet_01v8 L=150000U W=210000U AS=21875000000P
+ AD=40400000000P PS=460000U PD=560000U
* device instance $2712 r0 *1 39.195,32.67 nfet_01v8
M$2712 167 1859 1282 167 nfet_01v8 L=150000U W=210000U AS=21875000000P
+ AD=40400000000P PS=460000U PD=560000U
* device instance $2713 r0 *1 38.605,33.06 nfet_01v8
M$2713 2211 2103 167 167 nfet_01v8 L=150000U W=210000U AS=40400000000P
+ AD=21875000000P PS=560000U PD=460000U
* device instance $2714 r0 *1 39.195,33.06 nfet_01v8
M$2714 1859 1282 167 167 nfet_01v8 L=150000U W=210000U AS=40400000000P
+ AD=21875000000P PS=560000U PD=460000U
* device instance $2715 r0 *1 38.64,33.46 nfet_01v8
M$2715 53 148 2211 167 nfet_01v8 L=150000U W=140000U AS=21875000000P
+ AD=16800000000P PS=460000U PD=380000U
* device instance $2716 r0 *1 39.16,33.46 nfet_01v8
M$2716 56 148 1859 167 nfet_01v8 L=150000U W=140000U AS=21875000000P
+ AD=16800000000P PS=460000U PD=380000U
* device instance $2717 r0 *1 38.64,33.85 nfet_01v8
M$2717 2344 149 53 167 nfet_01v8 L=150000U W=140000U AS=16800000000P
+ AD=21875000000P PS=380000U PD=460000U
* device instance $2718 r0 *1 39.16,33.85 nfet_01v8
M$2718 1283 149 56 167 nfet_01v8 L=150000U W=140000U AS=16800000000P
+ AD=21875000000P PS=380000U PD=460000U
* device instance $2719 r0 *1 38.605,34.25 nfet_01v8
M$2719 167 2715 2344 167 nfet_01v8 L=150000U W=210000U AS=21875000000P
+ AD=40400000000P PS=460000U PD=560000U
* device instance $2720 r0 *1 39.195,34.25 nfet_01v8
M$2720 167 1860 1283 167 nfet_01v8 L=150000U W=210000U AS=21875000000P
+ AD=40400000000P PS=460000U PD=560000U
* device instance $2721 r0 *1 38.605,34.64 nfet_01v8
M$2721 2715 2344 167 167 nfet_01v8 L=150000U W=210000U AS=40400000000P
+ AD=21875000000P PS=560000U PD=460000U
* device instance $2722 r0 *1 39.195,34.64 nfet_01v8
M$2722 1860 1283 167 167 nfet_01v8 L=150000U W=210000U AS=40400000000P
+ AD=21875000000P PS=560000U PD=460000U
* device instance $2723 r0 *1 38.64,35.04 nfet_01v8
M$2723 54 149 2715 167 nfet_01v8 L=150000U W=140000U AS=21875000000P
+ AD=16800000000P PS=460000U PD=380000U
* device instance $2724 r0 *1 39.16,35.04 nfet_01v8
M$2724 55 149 1860 167 nfet_01v8 L=150000U W=140000U AS=21875000000P
+ AD=16800000000P PS=460000U PD=380000U
* device instance $2725 r0 *1 49.54,29.11 nfet_01v8
M$2725 2446 146 70 167 nfet_01v8 L=150000U W=140000U AS=16800000000P
+ AD=21875000000P PS=380000U PD=460000U
* device instance $2726 r0 *1 50.06,29.11 nfet_01v8
M$2726 1144 146 71 167 nfet_01v8 L=150000U W=140000U AS=16800000000P
+ AD=21875000000P PS=380000U PD=460000U
* device instance $2727 r0 *1 49.505,29.51 nfet_01v8
M$2727 167 2912 2446 167 nfet_01v8 L=150000U W=210000U AS=21875000000P
+ AD=40400000000P PS=460000U PD=560000U
* device instance $2728 r0 *1 50.095,29.51 nfet_01v8
M$2728 167 1701 1144 167 nfet_01v8 L=150000U W=210000U AS=21875000000P
+ AD=40400000000P PS=460000U PD=560000U
* device instance $2729 r0 *1 49.505,29.9 nfet_01v8
M$2729 2912 2446 167 167 nfet_01v8 L=150000U W=210000U AS=40400000000P
+ AD=21875000000P PS=560000U PD=460000U
* device instance $2730 r0 *1 50.095,29.9 nfet_01v8
M$2730 1701 1144 167 167 nfet_01v8 L=150000U W=210000U AS=40400000000P
+ AD=21875000000P PS=560000U PD=460000U
* device instance $2731 r0 *1 49.54,30.3 nfet_01v8
M$2731 69 146 2912 167 nfet_01v8 L=150000U W=140000U AS=21875000000P
+ AD=16800000000P PS=460000U PD=380000U
* device instance $2732 r0 *1 50.06,30.3 nfet_01v8
M$2732 72 146 1701 167 nfet_01v8 L=150000U W=140000U AS=21875000000P
+ AD=16800000000P PS=460000U PD=380000U
* device instance $2733 r0 *1 49.54,30.69 nfet_01v8
M$2733 3471 147 69 167 nfet_01v8 L=150000U W=140000U AS=16800000000P
+ AD=21875000000P PS=380000U PD=460000U
* device instance $2734 r0 *1 50.06,30.69 nfet_01v8
M$2734 4357 147 72 167 nfet_01v8 L=150000U W=140000U AS=16800000000P
+ AD=21875000000P PS=380000U PD=460000U
* device instance $2735 r0 *1 49.505,31.09 nfet_01v8
M$2735 167 2911 3471 167 nfet_01v8 L=150000U W=210000U AS=21875000000P
+ AD=40400000000P PS=460000U PD=560000U
* device instance $2736 r0 *1 50.095,31.09 nfet_01v8
M$2736 167 755 4357 167 nfet_01v8 L=150000U W=210000U AS=21875000000P
+ AD=40400000000P PS=460000U PD=560000U
* device instance $2737 r0 *1 49.505,31.48 nfet_01v8
M$2737 2911 3471 167 167 nfet_01v8 L=150000U W=210000U AS=40400000000P
+ AD=21875000000P PS=560000U PD=460000U
* device instance $2738 r0 *1 50.095,31.48 nfet_01v8
M$2738 755 4357 167 167 nfet_01v8 L=150000U W=210000U AS=40400000000P
+ AD=21875000000P PS=560000U PD=460000U
* device instance $2739 r0 *1 49.54,31.88 nfet_01v8
M$2739 70 147 2911 167 nfet_01v8 L=150000U W=140000U AS=21875000000P
+ AD=16800000000P PS=460000U PD=380000U
* device instance $2740 r0 *1 50.06,31.88 nfet_01v8
M$2740 71 147 755 167 nfet_01v8 L=150000U W=140000U AS=21875000000P
+ AD=16800000000P PS=460000U PD=380000U
* device instance $2741 r0 *1 49.54,32.27 nfet_01v8
M$2741 2449 148 70 167 nfet_01v8 L=150000U W=140000U AS=16800000000P
+ AD=21875000000P PS=380000U PD=460000U
* device instance $2742 r0 *1 50.06,32.27 nfet_01v8
M$2742 1141 148 71 167 nfet_01v8 L=150000U W=140000U AS=16800000000P
+ AD=21875000000P PS=380000U PD=460000U
* device instance $2743 r0 *1 49.505,32.67 nfet_01v8
M$2743 167 2918 2449 167 nfet_01v8 L=150000U W=210000U AS=21875000000P
+ AD=40400000000P PS=460000U PD=560000U
* device instance $2744 r0 *1 50.095,32.67 nfet_01v8
M$2744 167 1698 1141 167 nfet_01v8 L=150000U W=210000U AS=21875000000P
+ AD=40400000000P PS=460000U PD=560000U
* device instance $2745 r0 *1 49.505,33.06 nfet_01v8
M$2745 2918 2449 167 167 nfet_01v8 L=150000U W=210000U AS=40400000000P
+ AD=21875000000P PS=560000U PD=460000U
* device instance $2746 r0 *1 50.095,33.06 nfet_01v8
M$2746 1698 1141 167 167 nfet_01v8 L=150000U W=210000U AS=40400000000P
+ AD=21875000000P PS=560000U PD=460000U
* device instance $2747 r0 *1 49.54,33.46 nfet_01v8
M$2747 69 148 2918 167 nfet_01v8 L=150000U W=140000U AS=21875000000P
+ AD=16800000000P PS=460000U PD=380000U
* device instance $2748 r0 *1 50.06,33.46 nfet_01v8
M$2748 72 148 1698 167 nfet_01v8 L=150000U W=140000U AS=21875000000P
+ AD=16800000000P PS=460000U PD=380000U
* device instance $2749 r0 *1 49.54,33.85 nfet_01v8
M$2749 2448 149 69 167 nfet_01v8 L=150000U W=140000U AS=16800000000P
+ AD=21875000000P PS=380000U PD=460000U
* device instance $2750 r0 *1 50.06,33.85 nfet_01v8
M$2750 1142 149 72 167 nfet_01v8 L=150000U W=140000U AS=16800000000P
+ AD=21875000000P PS=380000U PD=460000U
* device instance $2751 r0 *1 49.505,34.25 nfet_01v8
M$2751 167 2914 2448 167 nfet_01v8 L=150000U W=210000U AS=21875000000P
+ AD=40400000000P PS=460000U PD=560000U
* device instance $2752 r0 *1 50.095,34.25 nfet_01v8
M$2752 167 1699 1142 167 nfet_01v8 L=150000U W=210000U AS=21875000000P
+ AD=40400000000P PS=460000U PD=560000U
* device instance $2753 r0 *1 49.505,34.64 nfet_01v8
M$2753 2914 2448 167 167 nfet_01v8 L=150000U W=210000U AS=40400000000P
+ AD=21875000000P PS=560000U PD=460000U
* device instance $2754 r0 *1 50.095,34.64 nfet_01v8
M$2754 1699 1142 167 167 nfet_01v8 L=150000U W=210000U AS=40400000000P
+ AD=21875000000P PS=560000U PD=460000U
* device instance $2755 r0 *1 49.54,35.04 nfet_01v8
M$2755 70 149 2914 167 nfet_01v8 L=150000U W=140000U AS=21875000000P
+ AD=16800000000P PS=460000U PD=380000U
* device instance $2756 r0 *1 50.06,35.04 nfet_01v8
M$2756 71 149 1699 167 nfet_01v8 L=150000U W=140000U AS=21875000000P
+ AD=16800000000P PS=460000U PD=380000U
* device instance $2757 r0 *1 60.44,29.11 nfet_01v8
M$2757 3454 146 86 167 nfet_01v8 L=150000U W=140000U AS=16800000000P
+ AD=21875000000P PS=380000U PD=460000U
* device instance $2758 r0 *1 60.96,29.11 nfet_01v8
M$2758 977 146 87 167 nfet_01v8 L=150000U W=140000U AS=16800000000P
+ AD=21875000000P PS=380000U PD=460000U
* device instance $2759 r0 *1 60.405,29.51 nfet_01v8
M$2759 167 2821 3454 167 nfet_01v8 L=150000U W=210000U AS=21875000000P
+ AD=40400000000P PS=460000U PD=560000U
* device instance $2760 r0 *1 60.995,29.51 nfet_01v8
M$2760 167 1508 977 167 nfet_01v8 L=150000U W=210000U AS=21875000000P
+ AD=40400000000P PS=460000U PD=560000U
* device instance $2761 r0 *1 60.405,29.9 nfet_01v8
M$2761 2821 3454 167 167 nfet_01v8 L=150000U W=210000U AS=40400000000P
+ AD=21875000000P PS=560000U PD=460000U
* device instance $2762 r0 *1 60.995,29.9 nfet_01v8
M$2762 1508 977 167 167 nfet_01v8 L=150000U W=210000U AS=40400000000P
+ AD=21875000000P PS=560000U PD=460000U
* device instance $2763 r0 *1 60.44,30.3 nfet_01v8
M$2763 85 146 2821 167 nfet_01v8 L=150000U W=140000U AS=21875000000P
+ AD=16800000000P PS=460000U PD=380000U
* device instance $2764 r0 *1 60.96,30.3 nfet_01v8
M$2764 88 146 1508 167 nfet_01v8 L=150000U W=140000U AS=21875000000P
+ AD=16800000000P PS=460000U PD=380000U
* device instance $2765 r0 *1 60.44,30.69 nfet_01v8
M$2765 3423 147 85 167 nfet_01v8 L=150000U W=140000U AS=16800000000P
+ AD=21875000000P PS=380000U PD=460000U
* device instance $2766 r0 *1 60.96,30.69 nfet_01v8
M$2766 4352 147 88 167 nfet_01v8 L=150000U W=140000U AS=16800000000P
+ AD=21875000000P PS=380000U PD=460000U
* device instance $2767 r0 *1 60.405,31.09 nfet_01v8
M$2767 167 2027 3423 167 nfet_01v8 L=150000U W=210000U AS=21875000000P
+ AD=40400000000P PS=460000U PD=560000U
* device instance $2768 r0 *1 60.995,31.09 nfet_01v8
M$2768 167 1507 4352 167 nfet_01v8 L=150000U W=210000U AS=21875000000P
+ AD=40400000000P PS=460000U PD=560000U
* device instance $2769 r0 *1 60.405,31.48 nfet_01v8
M$2769 2027 3423 167 167 nfet_01v8 L=150000U W=210000U AS=40400000000P
+ AD=21875000000P PS=560000U PD=460000U
* device instance $2770 r0 *1 60.995,31.48 nfet_01v8
M$2770 1507 4352 167 167 nfet_01v8 L=150000U W=210000U AS=40400000000P
+ AD=21875000000P PS=560000U PD=460000U
* device instance $2771 r0 *1 60.44,31.88 nfet_01v8
M$2771 86 147 2027 167 nfet_01v8 L=150000U W=140000U AS=21875000000P
+ AD=16800000000P PS=460000U PD=380000U
* device instance $2772 r0 *1 60.96,31.88 nfet_01v8
M$2772 87 147 1507 167 nfet_01v8 L=150000U W=140000U AS=21875000000P
+ AD=16800000000P PS=460000U PD=380000U
* device instance $2773 r0 *1 60.44,32.27 nfet_01v8
M$2773 3421 148 86 167 nfet_01v8 L=150000U W=140000U AS=16800000000P
+ AD=21875000000P PS=380000U PD=460000U
* device instance $2774 r0 *1 60.96,32.27 nfet_01v8
M$2774 652 148 87 167 nfet_01v8 L=150000U W=140000U AS=16800000000P
+ AD=21875000000P PS=380000U PD=460000U
* device instance $2775 r0 *1 60.405,32.67 nfet_01v8
M$2775 167 2248 3421 167 nfet_01v8 L=150000U W=210000U AS=21875000000P
+ AD=40400000000P PS=460000U PD=560000U
* device instance $2776 r0 *1 60.995,32.67 nfet_01v8
M$2776 167 823 652 167 nfet_01v8 L=150000U W=210000U AS=21875000000P
+ AD=40400000000P PS=460000U PD=560000U
* device instance $2777 r0 *1 60.405,33.06 nfet_01v8
M$2777 2248 3421 167 167 nfet_01v8 L=150000U W=210000U AS=40400000000P
+ AD=21875000000P PS=560000U PD=460000U
* device instance $2778 r0 *1 60.995,33.06 nfet_01v8
M$2778 823 652 167 167 nfet_01v8 L=150000U W=210000U AS=40400000000P
+ AD=21875000000P PS=560000U PD=460000U
* device instance $2779 r0 *1 60.44,33.46 nfet_01v8
M$2779 85 148 2248 167 nfet_01v8 L=150000U W=140000U AS=21875000000P
+ AD=16800000000P PS=460000U PD=380000U
* device instance $2780 r0 *1 60.96,33.46 nfet_01v8
M$2780 88 148 823 167 nfet_01v8 L=150000U W=140000U AS=21875000000P
+ AD=16800000000P PS=460000U PD=380000U
* device instance $2781 r0 *1 60.44,33.85 nfet_01v8
M$2781 3422 149 85 167 nfet_01v8 L=150000U W=140000U AS=16800000000P
+ AD=21875000000P PS=380000U PD=460000U
* device instance $2782 r0 *1 60.96,33.85 nfet_01v8
M$2782 980 149 88 167 nfet_01v8 L=150000U W=140000U AS=16800000000P
+ AD=21875000000P PS=380000U PD=460000U
* device instance $2783 r0 *1 60.405,34.25 nfet_01v8
M$2783 167 2829 3422 167 nfet_01v8 L=150000U W=210000U AS=21875000000P
+ AD=40400000000P PS=460000U PD=560000U
* device instance $2784 r0 *1 60.995,34.25 nfet_01v8
M$2784 167 1513 980 167 nfet_01v8 L=150000U W=210000U AS=21875000000P
+ AD=40400000000P PS=460000U PD=560000U
* device instance $2785 r0 *1 60.405,34.64 nfet_01v8
M$2785 2829 3422 167 167 nfet_01v8 L=150000U W=210000U AS=40400000000P
+ AD=21875000000P PS=560000U PD=460000U
* device instance $2786 r0 *1 60.995,34.64 nfet_01v8
M$2786 1513 980 167 167 nfet_01v8 L=150000U W=210000U AS=40400000000P
+ AD=21875000000P PS=560000U PD=460000U
* device instance $2787 r0 *1 60.44,35.04 nfet_01v8
M$2787 86 149 2829 167 nfet_01v8 L=150000U W=140000U AS=21875000000P
+ AD=16800000000P PS=460000U PD=380000U
* device instance $2788 r0 *1 60.96,35.04 nfet_01v8
M$2788 87 149 1513 167 nfet_01v8 L=150000U W=140000U AS=21875000000P
+ AD=16800000000P PS=460000U PD=380000U
* device instance $2789 r0 *1 71.34,29.11 nfet_01v8
M$2789 3432 146 102 167 nfet_01v8 L=150000U W=140000U AS=16800000000P
+ AD=21875000000P PS=380000U PD=460000U
* device instance $2790 r0 *1 71.86,29.11 nfet_01v8
M$2790 945 146 103 167 nfet_01v8 L=150000U W=140000U AS=16800000000P
+ AD=21875000000P PS=380000U PD=460000U
* device instance $2791 r0 *1 71.305,29.51 nfet_01v8
M$2791 167 2721 3432 167 nfet_01v8 L=150000U W=210000U AS=21875000000P
+ AD=40400000000P PS=460000U PD=560000U
* device instance $2792 r0 *1 71.895,29.51 nfet_01v8
M$2792 167 1469 945 167 nfet_01v8 L=150000U W=210000U AS=21875000000P
+ AD=40400000000P PS=460000U PD=560000U
* device instance $2793 r0 *1 71.305,29.9 nfet_01v8
M$2793 2721 3432 167 167 nfet_01v8 L=150000U W=210000U AS=40400000000P
+ AD=21875000000P PS=560000U PD=460000U
* device instance $2794 r0 *1 71.895,29.9 nfet_01v8
M$2794 1469 945 167 167 nfet_01v8 L=150000U W=210000U AS=40400000000P
+ AD=21875000000P PS=560000U PD=460000U
* device instance $2795 r0 *1 71.34,30.3 nfet_01v8
M$2795 101 146 2721 167 nfet_01v8 L=150000U W=140000U AS=21875000000P
+ AD=16800000000P PS=460000U PD=380000U
* device instance $2796 r0 *1 71.86,30.3 nfet_01v8
M$2796 104 146 1469 167 nfet_01v8 L=150000U W=140000U AS=21875000000P
+ AD=16800000000P PS=460000U PD=380000U
* device instance $2797 r0 *1 71.34,30.69 nfet_01v8
M$2797 3431 147 101 167 nfet_01v8 L=150000U W=140000U AS=16800000000P
+ AD=21875000000P PS=380000U PD=460000U
* device instance $2798 r0 *1 71.86,30.69 nfet_01v8
M$2798 4288 147 104 167 nfet_01v8 L=150000U W=140000U AS=16800000000P
+ AD=21875000000P PS=380000U PD=460000U
* device instance $2799 r0 *1 71.305,31.09 nfet_01v8
M$2799 167 2051 3431 167 nfet_01v8 L=150000U W=210000U AS=21875000000P
+ AD=40400000000P PS=460000U PD=560000U
* device instance $2800 r0 *1 71.895,31.09 nfet_01v8
M$2800 167 844 4288 167 nfet_01v8 L=150000U W=210000U AS=21875000000P
+ AD=40400000000P PS=460000U PD=560000U
* device instance $2801 r0 *1 71.305,31.48 nfet_01v8
M$2801 2051 3431 167 167 nfet_01v8 L=150000U W=210000U AS=40400000000P
+ AD=21875000000P PS=560000U PD=460000U
* device instance $2802 r0 *1 71.895,31.48 nfet_01v8
M$2802 844 4288 167 167 nfet_01v8 L=150000U W=210000U AS=40400000000P
+ AD=21875000000P PS=560000U PD=460000U
* device instance $2803 r0 *1 71.34,31.88 nfet_01v8
M$2803 102 147 2051 167 nfet_01v8 L=150000U W=140000U AS=21875000000P
+ AD=16800000000P PS=460000U PD=380000U
* device instance $2804 r0 *1 71.86,31.88 nfet_01v8
M$2804 103 147 844 167 nfet_01v8 L=150000U W=140000U AS=21875000000P
+ AD=16800000000P PS=460000U PD=380000U
* device instance $2805 r0 *1 71.34,32.27 nfet_01v8
M$2805 2352 148 102 167 nfet_01v8 L=150000U W=140000U AS=16800000000P
+ AD=21875000000P PS=380000U PD=460000U
* device instance $2806 r0 *1 71.86,32.27 nfet_01v8
M$2806 942 148 103 167 nfet_01v8 L=150000U W=140000U AS=16800000000P
+ AD=21875000000P PS=380000U PD=460000U
* device instance $2807 r0 *1 71.305,32.67 nfet_01v8
M$2807 167 2732 2352 167 nfet_01v8 L=150000U W=210000U AS=21875000000P
+ AD=40400000000P PS=460000U PD=560000U
* device instance $2808 r0 *1 71.895,32.67 nfet_01v8
M$2808 167 1465 942 167 nfet_01v8 L=150000U W=210000U AS=21875000000P
+ AD=40400000000P PS=460000U PD=560000U
* device instance $2809 r0 *1 71.305,33.06 nfet_01v8
M$2809 2732 2352 167 167 nfet_01v8 L=150000U W=210000U AS=40400000000P
+ AD=21875000000P PS=560000U PD=460000U
* device instance $2810 r0 *1 71.895,33.06 nfet_01v8
M$2810 1465 942 167 167 nfet_01v8 L=150000U W=210000U AS=40400000000P
+ AD=21875000000P PS=560000U PD=460000U
* device instance $2811 r0 *1 71.34,33.46 nfet_01v8
M$2811 101 148 2732 167 nfet_01v8 L=150000U W=140000U AS=21875000000P
+ AD=16800000000P PS=460000U PD=380000U
* device instance $2812 r0 *1 71.86,33.46 nfet_01v8
M$2812 104 148 1465 167 nfet_01v8 L=150000U W=140000U AS=21875000000P
+ AD=16800000000P PS=460000U PD=380000U
* device instance $2813 r0 *1 71.34,33.85 nfet_01v8
M$2813 3430 149 101 167 nfet_01v8 L=150000U W=140000U AS=16800000000P
+ AD=21875000000P PS=380000U PD=460000U
* device instance $2814 r0 *1 71.86,33.85 nfet_01v8
M$2814 943 149 104 167 nfet_01v8 L=150000U W=140000U AS=16800000000P
+ AD=21875000000P PS=380000U PD=460000U
* device instance $2815 r0 *1 71.305,34.25 nfet_01v8
M$2815 167 2735 3430 167 nfet_01v8 L=150000U W=210000U AS=21875000000P
+ AD=40400000000P PS=460000U PD=560000U
* device instance $2816 r0 *1 71.895,34.25 nfet_01v8
M$2816 167 1466 943 167 nfet_01v8 L=150000U W=210000U AS=21875000000P
+ AD=40400000000P PS=460000U PD=560000U
* device instance $2817 r0 *1 71.305,34.64 nfet_01v8
M$2817 2735 3430 167 167 nfet_01v8 L=150000U W=210000U AS=40400000000P
+ AD=21875000000P PS=560000U PD=460000U
* device instance $2818 r0 *1 71.895,34.64 nfet_01v8
M$2818 1466 943 167 167 nfet_01v8 L=150000U W=210000U AS=40400000000P
+ AD=21875000000P PS=560000U PD=460000U
* device instance $2819 r0 *1 71.34,35.04 nfet_01v8
M$2819 102 149 2735 167 nfet_01v8 L=150000U W=140000U AS=21875000000P
+ AD=16800000000P PS=460000U PD=380000U
* device instance $2820 r0 *1 71.86,35.04 nfet_01v8
M$2820 103 149 1466 167 nfet_01v8 L=150000U W=140000U AS=21875000000P
+ AD=16800000000P PS=460000U PD=380000U
* device instance $2821 r0 *1 82.24,29.11 nfet_01v8
M$2821 2381 146 118 167 nfet_01v8 L=150000U W=140000U AS=16800000000P
+ AD=21875000000P PS=380000U PD=460000U
* device instance $2822 r0 *1 82.76,29.11 nfet_01v8
M$2822 964 146 119 167 nfet_01v8 L=150000U W=140000U AS=16800000000P
+ AD=21875000000P PS=380000U PD=460000U
* device instance $2823 r0 *1 82.205,29.51 nfet_01v8
M$2823 167 2783 2381 167 nfet_01v8 L=150000U W=210000U AS=21875000000P
+ AD=40400000000P PS=460000U PD=560000U
* device instance $2824 r0 *1 82.795,29.51 nfet_01v8
M$2824 167 1493 964 167 nfet_01v8 L=150000U W=210000U AS=21875000000P
+ AD=40400000000P PS=460000U PD=560000U
* device instance $2825 r0 *1 82.205,29.9 nfet_01v8
M$2825 2783 2381 167 167 nfet_01v8 L=150000U W=210000U AS=40400000000P
+ AD=21875000000P PS=560000U PD=460000U
* device instance $2826 r0 *1 82.795,29.9 nfet_01v8
M$2826 1493 964 167 167 nfet_01v8 L=150000U W=210000U AS=40400000000P
+ AD=21875000000P PS=560000U PD=460000U
* device instance $2827 r0 *1 82.24,30.3 nfet_01v8
M$2827 117 146 2783 167 nfet_01v8 L=150000U W=140000U AS=21875000000P
+ AD=16800000000P PS=460000U PD=380000U
* device instance $2828 r0 *1 82.76,30.3 nfet_01v8
M$2828 120 146 1493 167 nfet_01v8 L=150000U W=140000U AS=21875000000P
+ AD=16800000000P PS=460000U PD=380000U
* device instance $2829 r0 *1 82.24,30.69 nfet_01v8
M$2829 3239 147 117 167 nfet_01v8 L=150000U W=140000U AS=16800000000P
+ AD=21875000000P PS=380000U PD=460000U
* device instance $2830 r0 *1 82.76,30.69 nfet_01v8
M$2830 4287 147 120 167 nfet_01v8 L=150000U W=140000U AS=16800000000P
+ AD=21875000000P PS=380000U PD=460000U
* device instance $2831 r0 *1 82.205,31.09 nfet_01v8
M$2831 167 2153 3239 167 nfet_01v8 L=150000U W=210000U AS=21875000000P
+ AD=40400000000P PS=460000U PD=560000U
* device instance $2832 r0 *1 82.795,31.09 nfet_01v8
M$2832 167 1487 4287 167 nfet_01v8 L=150000U W=210000U AS=21875000000P
+ AD=40400000000P PS=460000U PD=560000U
* device instance $2833 r0 *1 82.205,31.48 nfet_01v8
M$2833 2153 3239 167 167 nfet_01v8 L=150000U W=210000U AS=40400000000P
+ AD=21875000000P PS=560000U PD=460000U
* device instance $2834 r0 *1 82.795,31.48 nfet_01v8
M$2834 1487 4287 167 167 nfet_01v8 L=150000U W=210000U AS=40400000000P
+ AD=21875000000P PS=560000U PD=460000U
* device instance $2835 r0 *1 82.24,31.88 nfet_01v8
M$2835 118 147 2153 167 nfet_01v8 L=150000U W=140000U AS=21875000000P
+ AD=16800000000P PS=460000U PD=380000U
* device instance $2836 r0 *1 82.76,31.88 nfet_01v8
M$2836 119 147 1487 167 nfet_01v8 L=150000U W=140000U AS=21875000000P
+ AD=16800000000P PS=460000U PD=380000U
* device instance $2837 r0 *1 82.24,32.27 nfet_01v8
M$2837 2078 148 118 167 nfet_01v8 L=150000U W=140000U AS=16800000000P
+ AD=21875000000P PS=380000U PD=460000U
* device instance $2838 r0 *1 82.76,32.27 nfet_01v8
M$2838 956 148 119 167 nfet_01v8 L=150000U W=140000U AS=16800000000P
+ AD=21875000000P PS=380000U PD=460000U
* device instance $2839 r0 *1 82.205,32.67 nfet_01v8
M$2839 167 2158 2078 167 nfet_01v8 L=150000U W=210000U AS=21875000000P
+ AD=40400000000P PS=460000U PD=560000U
* device instance $2840 r0 *1 82.795,32.67 nfet_01v8
M$2840 167 1482 956 167 nfet_01v8 L=150000U W=210000U AS=21875000000P
+ AD=40400000000P PS=460000U PD=560000U
* device instance $2841 r0 *1 82.205,33.06 nfet_01v8
M$2841 2158 2078 167 167 nfet_01v8 L=150000U W=210000U AS=40400000000P
+ AD=21875000000P PS=560000U PD=460000U
* device instance $2842 r0 *1 82.795,33.06 nfet_01v8
M$2842 1482 956 167 167 nfet_01v8 L=150000U W=210000U AS=40400000000P
+ AD=21875000000P PS=560000U PD=460000U
* device instance $2843 r0 *1 82.24,33.46 nfet_01v8
M$2843 117 148 2158 167 nfet_01v8 L=150000U W=140000U AS=21875000000P
+ AD=16800000000P PS=460000U PD=380000U
* device instance $2844 r0 *1 82.76,33.46 nfet_01v8
M$2844 120 148 1482 167 nfet_01v8 L=150000U W=140000U AS=21875000000P
+ AD=16800000000P PS=460000U PD=380000U
* device instance $2845 r0 *1 82.24,33.85 nfet_01v8
M$2845 2369 149 117 167 nfet_01v8 L=150000U W=140000U AS=16800000000P
+ AD=21875000000P PS=380000U PD=460000U
* device instance $2846 r0 *1 82.76,33.85 nfet_01v8
M$2846 957 149 120 167 nfet_01v8 L=150000U W=140000U AS=16800000000P
+ AD=21875000000P PS=380000U PD=460000U
* device instance $2847 r0 *1 82.205,34.25 nfet_01v8
M$2847 167 2764 2369 167 nfet_01v8 L=150000U W=210000U AS=21875000000P
+ AD=40400000000P PS=460000U PD=560000U
* device instance $2848 r0 *1 82.795,34.25 nfet_01v8
M$2848 167 1483 957 167 nfet_01v8 L=150000U W=210000U AS=21875000000P
+ AD=40400000000P PS=460000U PD=560000U
* device instance $2849 r0 *1 82.205,34.64 nfet_01v8
M$2849 2764 2369 167 167 nfet_01v8 L=150000U W=210000U AS=40400000000P
+ AD=21875000000P PS=560000U PD=460000U
* device instance $2850 r0 *1 82.795,34.64 nfet_01v8
M$2850 1483 957 167 167 nfet_01v8 L=150000U W=210000U AS=40400000000P
+ AD=21875000000P PS=560000U PD=460000U
* device instance $2851 r0 *1 82.24,35.04 nfet_01v8
M$2851 118 149 2764 167 nfet_01v8 L=150000U W=140000U AS=21875000000P
+ AD=16800000000P PS=460000U PD=380000U
* device instance $2852 r0 *1 82.76,35.04 nfet_01v8
M$2852 119 149 1483 167 nfet_01v8 L=150000U W=140000U AS=21875000000P
+ AD=16800000000P PS=460000U PD=380000U
* device instance $2853 r0 *1 16.84,60.71 nfet_01v8
M$2853 2476 162 22 167 nfet_01v8 L=150000U W=140000U AS=16800000000P
+ AD=21875000000P PS=380000U PD=460000U
* device instance $2854 r0 *1 17.36,60.71 nfet_01v8
M$2854 901 162 23 167 nfet_01v8 L=150000U W=140000U AS=16800000000P
+ AD=21875000000P PS=380000U PD=460000U
* device instance $2855 r0 *1 16.805,61.11 nfet_01v8
M$2855 167 2976 2476 167 nfet_01v8 L=150000U W=210000U AS=21875000000P
+ AD=40400000000P PS=460000U PD=560000U
* device instance $2856 r0 *1 17.395,61.11 nfet_01v8
M$2856 167 1418 901 167 nfet_01v8 L=150000U W=210000U AS=21875000000P
+ AD=40400000000P PS=460000U PD=560000U
* device instance $2857 r0 *1 16.805,61.5 nfet_01v8
M$2857 2976 2476 167 167 nfet_01v8 L=150000U W=210000U AS=40400000000P
+ AD=21875000000P PS=560000U PD=460000U
* device instance $2858 r0 *1 17.395,61.5 nfet_01v8
M$2858 1418 901 167 167 nfet_01v8 L=150000U W=210000U AS=40400000000P
+ AD=21875000000P PS=560000U PD=460000U
* device instance $2859 r0 *1 16.84,61.9 nfet_01v8
M$2859 21 162 2976 167 nfet_01v8 L=150000U W=140000U AS=21875000000P
+ AD=16800000000P PS=460000U PD=380000U
* device instance $2860 r0 *1 17.36,61.9 nfet_01v8
M$2860 24 162 1418 167 nfet_01v8 L=150000U W=140000U AS=21875000000P
+ AD=16800000000P PS=460000U PD=380000U
* device instance $2861 r0 *1 16.84,62.29 nfet_01v8
M$2861 3529 163 21 167 nfet_01v8 L=150000U W=140000U AS=16800000000P
+ AD=21875000000P PS=380000U PD=460000U
* device instance $2862 r0 *1 17.36,62.29 nfet_01v8
M$2862 4447 163 24 167 nfet_01v8 L=150000U W=140000U AS=16800000000P
+ AD=21875000000P PS=380000U PD=460000U
* device instance $2863 r0 *1 16.805,62.69 nfet_01v8
M$2863 167 2207 3529 167 nfet_01v8 L=150000U W=210000U AS=21875000000P
+ AD=40400000000P PS=460000U PD=560000U
* device instance $2864 r0 *1 17.395,62.69 nfet_01v8
M$2864 167 754 4447 167 nfet_01v8 L=150000U W=210000U AS=21875000000P
+ AD=40400000000P PS=460000U PD=560000U
* device instance $2865 r0 *1 16.805,63.08 nfet_01v8
M$2865 2207 3529 167 167 nfet_01v8 L=150000U W=210000U AS=40400000000P
+ AD=21875000000P PS=560000U PD=460000U
* device instance $2866 r0 *1 17.395,63.08 nfet_01v8
M$2866 754 4447 167 167 nfet_01v8 L=150000U W=210000U AS=40400000000P
+ AD=21875000000P PS=560000U PD=460000U
* device instance $2867 r0 *1 16.84,63.48 nfet_01v8
M$2867 22 163 2207 167 nfet_01v8 L=150000U W=140000U AS=21875000000P
+ AD=16800000000P PS=460000U PD=380000U
* device instance $2868 r0 *1 17.36,63.48 nfet_01v8
M$2868 23 163 754 167 nfet_01v8 L=150000U W=140000U AS=21875000000P
+ AD=16800000000P PS=460000U PD=380000U
* device instance $2869 r0 *1 16.84,63.87 nfet_01v8
M$2869 3531 164 22 167 nfet_01v8 L=150000U W=140000U AS=16800000000P
+ AD=21875000000P PS=380000U PD=460000U
* device instance $2870 r0 *1 17.36,63.87 nfet_01v8
M$2870 884 164 23 167 nfet_01v8 L=150000U W=140000U AS=16800000000P
+ AD=21875000000P PS=380000U PD=460000U
* device instance $2871 r0 *1 16.805,64.27 nfet_01v8
M$2871 167 2994 3531 167 nfet_01v8 L=150000U W=210000U AS=21875000000P
+ AD=40400000000P PS=460000U PD=560000U
* device instance $2872 r0 *1 17.395,64.27 nfet_01v8
M$2872 167 1395 884 167 nfet_01v8 L=150000U W=210000U AS=21875000000P
+ AD=40400000000P PS=460000U PD=560000U
* device instance $2873 r0 *1 16.805,64.66 nfet_01v8
M$2873 2994 3531 167 167 nfet_01v8 L=150000U W=210000U AS=40400000000P
+ AD=21875000000P PS=560000U PD=460000U
* device instance $2874 r0 *1 17.395,64.66 nfet_01v8
M$2874 1395 884 167 167 nfet_01v8 L=150000U W=210000U AS=40400000000P
+ AD=21875000000P PS=560000U PD=460000U
* device instance $2875 r0 *1 16.84,65.06 nfet_01v8
M$2875 21 164 2994 167 nfet_01v8 L=150000U W=140000U AS=21875000000P
+ AD=16800000000P PS=460000U PD=380000U
* device instance $2876 r0 *1 17.36,65.06 nfet_01v8
M$2876 24 164 1395 167 nfet_01v8 L=150000U W=140000U AS=21875000000P
+ AD=16800000000P PS=460000U PD=380000U
* device instance $2877 r0 *1 16.84,65.45 nfet_01v8
M$2877 3530 165 21 167 nfet_01v8 L=150000U W=140000U AS=16800000000P
+ AD=21875000000P PS=380000U PD=460000U
* device instance $2878 r0 *1 17.36,65.45 nfet_01v8
M$2878 882 165 24 167 nfet_01v8 L=150000U W=140000U AS=16800000000P
+ AD=21875000000P PS=380000U PD=460000U
* device instance $2879 r0 *1 16.805,65.85 nfet_01v8
M$2879 167 2984 3530 167 nfet_01v8 L=150000U W=210000U AS=21875000000P
+ AD=40400000000P PS=460000U PD=560000U
* device instance $2880 r0 *1 17.395,65.85 nfet_01v8
M$2880 167 1392 882 167 nfet_01v8 L=150000U W=210000U AS=21875000000P
+ AD=40400000000P PS=460000U PD=560000U
* device instance $2881 r0 *1 16.805,66.24 nfet_01v8
M$2881 2984 3530 167 167 nfet_01v8 L=150000U W=210000U AS=40400000000P
+ AD=21875000000P PS=560000U PD=460000U
* device instance $2882 r0 *1 17.395,66.24 nfet_01v8
M$2882 1392 882 167 167 nfet_01v8 L=150000U W=210000U AS=40400000000P
+ AD=21875000000P PS=560000U PD=460000U
* device instance $2883 r0 *1 16.84,66.64 nfet_01v8
M$2883 22 165 2984 167 nfet_01v8 L=150000U W=140000U AS=21875000000P
+ AD=16800000000P PS=460000U PD=380000U
* device instance $2884 r0 *1 17.36,66.64 nfet_01v8
M$2884 23 165 1392 167 nfet_01v8 L=150000U W=140000U AS=21875000000P
+ AD=16800000000P PS=460000U PD=380000U
* device instance $2885 r0 *1 5.94,21.21 nfet_01v8
M$2885 2400 142 6 167 nfet_01v8 L=150000U W=140000U AS=16800000000P
+ AD=21875000000P PS=380000U PD=460000U
* device instance $2886 r0 *1 6.46,21.21 nfet_01v8
M$2886 1362 142 7 167 nfet_01v8 L=150000U W=140000U AS=16800000000P
+ AD=21875000000P PS=380000U PD=460000U
* device instance $2887 r0 *1 5.905,21.61 nfet_01v8
M$2887 167 2815 2400 167 nfet_01v8 L=150000U W=210000U AS=21875000000P
+ AD=40400000000P PS=460000U PD=560000U
* device instance $2888 r0 *1 6.495,21.61 nfet_01v8
M$2888 167 1953 1362 167 nfet_01v8 L=150000U W=210000U AS=21875000000P
+ AD=40400000000P PS=460000U PD=560000U
* device instance $2889 r0 *1 5.905,22 nfet_01v8
M$2889 2815 2400 167 167 nfet_01v8 L=150000U W=210000U AS=40400000000P
+ AD=21875000000P PS=560000U PD=460000U
* device instance $2890 r0 *1 6.495,22 nfet_01v8
M$2890 1953 1362 167 167 nfet_01v8 L=150000U W=210000U AS=40400000000P
+ AD=21875000000P PS=560000U PD=460000U
* device instance $2891 r0 *1 5.94,22.4 nfet_01v8
M$2891 5 142 2815 167 nfet_01v8 L=150000U W=140000U AS=21875000000P
+ AD=16800000000P PS=460000U PD=380000U
* device instance $2892 r0 *1 6.46,22.4 nfet_01v8
M$2892 8 142 1953 167 nfet_01v8 L=150000U W=140000U AS=21875000000P
+ AD=16800000000P PS=460000U PD=380000U
* device instance $2893 r0 *1 5.94,22.79 nfet_01v8
M$2893 3315 143 5 167 nfet_01v8 L=150000U W=140000U AS=16800000000P
+ AD=21875000000P PS=380000U PD=460000U
* device instance $2894 r0 *1 6.46,22.79 nfet_01v8
M$2894 4534 143 8 167 nfet_01v8 L=150000U W=140000U AS=16800000000P
+ AD=21875000000P PS=380000U PD=460000U
* device instance $2895 r0 *1 5.905,23.19 nfet_01v8
M$2895 167 2847 3315 167 nfet_01v8 L=150000U W=210000U AS=21875000000P
+ AD=40400000000P PS=460000U PD=560000U
* device instance $2896 r0 *1 6.495,23.19 nfet_01v8
M$2896 167 757 4534 167 nfet_01v8 L=150000U W=210000U AS=21875000000P
+ AD=40400000000P PS=460000U PD=560000U
* device instance $2897 r0 *1 5.905,23.58 nfet_01v8
M$2897 2847 3315 167 167 nfet_01v8 L=150000U W=210000U AS=40400000000P
+ AD=21875000000P PS=560000U PD=460000U
* device instance $2898 r0 *1 6.495,23.58 nfet_01v8
M$2898 757 4534 167 167 nfet_01v8 L=150000U W=210000U AS=40400000000P
+ AD=21875000000P PS=560000U PD=460000U
* device instance $2899 r0 *1 5.94,23.98 nfet_01v8
M$2899 6 143 2847 167 nfet_01v8 L=150000U W=140000U AS=21875000000P
+ AD=16800000000P PS=460000U PD=380000U
* device instance $2900 r0 *1 6.46,23.98 nfet_01v8
M$2900 7 143 757 167 nfet_01v8 L=150000U W=140000U AS=21875000000P
+ AD=16800000000P PS=460000U PD=380000U
* device instance $2901 r0 *1 5.94,24.37 nfet_01v8
M$2901 2095 144 6 167 nfet_01v8 L=150000U W=140000U AS=16800000000P
+ AD=21875000000P PS=380000U PD=460000U
* device instance $2902 r0 *1 6.46,24.37 nfet_01v8
M$2902 631 144 7 167 nfet_01v8 L=150000U W=140000U AS=16800000000P
+ AD=21875000000P PS=380000U PD=460000U
* device instance $2903 r0 *1 5.905,24.77 nfet_01v8
M$2903 167 2190 2095 167 nfet_01v8 L=150000U W=210000U AS=21875000000P
+ AD=40400000000P PS=460000U PD=560000U
* device instance $2904 r0 *1 6.495,24.77 nfet_01v8
M$2904 167 782 631 167 nfet_01v8 L=150000U W=210000U AS=21875000000P
+ AD=40400000000P PS=460000U PD=560000U
* device instance $2905 r0 *1 5.905,25.16 nfet_01v8
M$2905 2190 2095 167 167 nfet_01v8 L=150000U W=210000U AS=40400000000P
+ AD=21875000000P PS=560000U PD=460000U
* device instance $2906 r0 *1 6.495,25.16 nfet_01v8
M$2906 782 631 167 167 nfet_01v8 L=150000U W=210000U AS=40400000000P
+ AD=21875000000P PS=560000U PD=460000U
* device instance $2907 r0 *1 5.94,25.56 nfet_01v8
M$2907 5 144 2190 167 nfet_01v8 L=150000U W=140000U AS=21875000000P
+ AD=16800000000P PS=460000U PD=380000U
* device instance $2908 r0 *1 6.46,25.56 nfet_01v8
M$2908 8 144 782 167 nfet_01v8 L=150000U W=140000U AS=21875000000P
+ AD=16800000000P PS=460000U PD=380000U
* device instance $2909 r0 *1 5.94,25.95 nfet_01v8
M$2909 2421 145 5 167 nfet_01v8 L=150000U W=140000U AS=16800000000P
+ AD=21875000000P PS=380000U PD=460000U
* device instance $2910 r0 *1 6.46,25.95 nfet_01v8
M$2910 1363 145 8 167 nfet_01v8 L=150000U W=140000U AS=16800000000P
+ AD=21875000000P PS=380000U PD=460000U
* device instance $2911 r0 *1 5.905,26.35 nfet_01v8
M$2911 167 2854 2421 167 nfet_01v8 L=150000U W=210000U AS=21875000000P
+ AD=40400000000P PS=460000U PD=560000U
* device instance $2912 r0 *1 6.495,26.35 nfet_01v8
M$2912 167 1954 1363 167 nfet_01v8 L=150000U W=210000U AS=21875000000P
+ AD=40400000000P PS=460000U PD=560000U
* device instance $2913 r0 *1 5.905,26.74 nfet_01v8
M$2913 2854 2421 167 167 nfet_01v8 L=150000U W=210000U AS=40400000000P
+ AD=21875000000P PS=560000U PD=460000U
* device instance $2914 r0 *1 6.495,26.74 nfet_01v8
M$2914 1954 1363 167 167 nfet_01v8 L=150000U W=210000U AS=40400000000P
+ AD=21875000000P PS=560000U PD=460000U
* device instance $2915 r0 *1 5.94,27.14 nfet_01v8
M$2915 6 145 2854 167 nfet_01v8 L=150000U W=140000U AS=21875000000P
+ AD=16800000000P PS=460000U PD=380000U
* device instance $2916 r0 *1 6.46,27.14 nfet_01v8
M$2916 7 145 1954 167 nfet_01v8 L=150000U W=140000U AS=21875000000P
+ AD=16800000000P PS=460000U PD=380000U
* device instance $2917 r0 *1 16.84,21.21 nfet_01v8
M$2917 2442 142 22 167 nfet_01v8 L=150000U W=140000U AS=16800000000P
+ AD=21875000000P PS=380000U PD=460000U
* device instance $2918 r0 *1 17.36,21.21 nfet_01v8
M$2918 1309 142 23 167 nfet_01v8 L=150000U W=140000U AS=16800000000P
+ AD=21875000000P PS=380000U PD=460000U
* device instance $2919 r0 *1 16.805,21.61 nfet_01v8
M$2919 167 2906 2442 167 nfet_01v8 L=150000U W=210000U AS=21875000000P
+ AD=40400000000P PS=460000U PD=560000U
* device instance $2920 r0 *1 17.395,21.61 nfet_01v8
M$2920 167 1889 1309 167 nfet_01v8 L=150000U W=210000U AS=21875000000P
+ AD=40400000000P PS=460000U PD=560000U
* device instance $2921 r0 *1 16.805,22 nfet_01v8
M$2921 2906 2442 167 167 nfet_01v8 L=150000U W=210000U AS=40400000000P
+ AD=21875000000P PS=560000U PD=460000U
* device instance $2922 r0 *1 17.395,22 nfet_01v8
M$2922 1889 1309 167 167 nfet_01v8 L=150000U W=210000U AS=40400000000P
+ AD=21875000000P PS=560000U PD=460000U
* device instance $2923 r0 *1 16.84,22.4 nfet_01v8
M$2923 21 142 2906 167 nfet_01v8 L=150000U W=140000U AS=21875000000P
+ AD=16800000000P PS=460000U PD=380000U
* device instance $2924 r0 *1 17.36,22.4 nfet_01v8
M$2924 24 142 1889 167 nfet_01v8 L=150000U W=140000U AS=21875000000P
+ AD=16800000000P PS=460000U PD=380000U
* device instance $2925 r0 *1 16.84,22.79 nfet_01v8
M$2925 3323 143 21 167 nfet_01v8 L=150000U W=140000U AS=16800000000P
+ AD=21875000000P PS=380000U PD=460000U
* device instance $2926 r0 *1 17.36,22.79 nfet_01v8
M$2926 4479 143 24 167 nfet_01v8 L=150000U W=140000U AS=16800000000P
+ AD=21875000000P PS=380000U PD=460000U
* device instance $2927 r0 *1 16.805,23.19 nfet_01v8
M$2927 167 2203 3323 167 nfet_01v8 L=150000U W=210000U AS=21875000000P
+ AD=40400000000P PS=460000U PD=560000U
* device instance $2928 r0 *1 17.395,23.19 nfet_01v8
M$2928 167 805 4479 167 nfet_01v8 L=150000U W=210000U AS=21875000000P
+ AD=40400000000P PS=460000U PD=560000U
* device instance $2929 r0 *1 16.805,23.58 nfet_01v8
M$2929 2203 3323 167 167 nfet_01v8 L=150000U W=210000U AS=40400000000P
+ AD=21875000000P PS=560000U PD=460000U
* device instance $2930 r0 *1 17.395,23.58 nfet_01v8
M$2930 805 4479 167 167 nfet_01v8 L=150000U W=210000U AS=40400000000P
+ AD=21875000000P PS=560000U PD=460000U
* device instance $2931 r0 *1 16.84,23.98 nfet_01v8
M$2931 22 143 2203 167 nfet_01v8 L=150000U W=140000U AS=21875000000P
+ AD=16800000000P PS=460000U PD=380000U
* device instance $2932 r0 *1 17.36,23.98 nfet_01v8
M$2932 23 143 805 167 nfet_01v8 L=150000U W=140000U AS=21875000000P
+ AD=16800000000P PS=460000U PD=380000U
* device instance $2933 r0 *1 16.84,24.37 nfet_01v8
M$2933 3322 144 22 167 nfet_01v8 L=150000U W=140000U AS=16800000000P
+ AD=21875000000P PS=380000U PD=460000U
* device instance $2934 r0 *1 17.36,24.37 nfet_01v8
M$2934 1314 144 23 167 nfet_01v8 L=150000U W=140000U AS=16800000000P
+ AD=21875000000P PS=380000U PD=460000U
* device instance $2935 r0 *1 16.805,24.77 nfet_01v8
M$2935 167 2915 3322 167 nfet_01v8 L=150000U W=210000U AS=21875000000P
+ AD=40400000000P PS=460000U PD=560000U
* device instance $2936 r0 *1 17.395,24.77 nfet_01v8
M$2936 167 1894 1314 167 nfet_01v8 L=150000U W=210000U AS=21875000000P
+ AD=40400000000P PS=460000U PD=560000U
* device instance $2937 r0 *1 16.805,25.16 nfet_01v8
M$2937 2915 3322 167 167 nfet_01v8 L=150000U W=210000U AS=40400000000P
+ AD=21875000000P PS=560000U PD=460000U
* device instance $2938 r0 *1 17.395,25.16 nfet_01v8
M$2938 1894 1314 167 167 nfet_01v8 L=150000U W=210000U AS=40400000000P
+ AD=21875000000P PS=560000U PD=460000U
* device instance $2939 r0 *1 16.84,25.56 nfet_01v8
M$2939 21 144 2915 167 nfet_01v8 L=150000U W=140000U AS=21875000000P
+ AD=16800000000P PS=460000U PD=380000U
* device instance $2940 r0 *1 17.36,25.56 nfet_01v8
M$2940 24 144 1894 167 nfet_01v8 L=150000U W=140000U AS=21875000000P
+ AD=16800000000P PS=460000U PD=380000U
* device instance $2941 r0 *1 16.84,25.95 nfet_01v8
M$2941 3321 145 21 167 nfet_01v8 L=150000U W=140000U AS=16800000000P
+ AD=21875000000P PS=380000U PD=460000U
* device instance $2942 r0 *1 17.36,25.95 nfet_01v8
M$2942 1313 145 24 167 nfet_01v8 L=150000U W=140000U AS=16800000000P
+ AD=21875000000P PS=380000U PD=460000U
* device instance $2943 r0 *1 16.805,26.35 nfet_01v8
M$2943 167 2893 3321 167 nfet_01v8 L=150000U W=210000U AS=21875000000P
+ AD=40400000000P PS=460000U PD=560000U
* device instance $2944 r0 *1 17.395,26.35 nfet_01v8
M$2944 167 1893 1313 167 nfet_01v8 L=150000U W=210000U AS=21875000000P
+ AD=40400000000P PS=460000U PD=560000U
* device instance $2945 r0 *1 16.805,26.74 nfet_01v8
M$2945 2893 3321 167 167 nfet_01v8 L=150000U W=210000U AS=40400000000P
+ AD=21875000000P PS=560000U PD=460000U
* device instance $2946 r0 *1 17.395,26.74 nfet_01v8
M$2946 1893 1313 167 167 nfet_01v8 L=150000U W=210000U AS=40400000000P
+ AD=21875000000P PS=560000U PD=460000U
* device instance $2947 r0 *1 16.84,27.14 nfet_01v8
M$2947 22 145 2893 167 nfet_01v8 L=150000U W=140000U AS=21875000000P
+ AD=16800000000P PS=460000U PD=380000U
* device instance $2948 r0 *1 17.36,27.14 nfet_01v8
M$2948 23 145 1893 167 nfet_01v8 L=150000U W=140000U AS=21875000000P
+ AD=16800000000P PS=460000U PD=380000U
* device instance $2949 r0 *1 27.74,21.21 nfet_01v8
M$2949 3666 142 38 167 nfet_01v8 L=150000U W=140000U AS=16800000000P
+ AD=21875000000P PS=380000U PD=460000U
* device instance $2950 r0 *1 28.26,21.21 nfet_01v8
M$2950 1194 142 39 167 nfet_01v8 L=150000U W=140000U AS=16800000000P
+ AD=21875000000P PS=380000U PD=460000U
* device instance $2951 r0 *1 27.705,21.61 nfet_01v8
M$2951 167 2917 3666 167 nfet_01v8 L=150000U W=210000U AS=21875000000P
+ AD=40400000000P PS=460000U PD=560000U
* device instance $2952 r0 *1 28.295,21.61 nfet_01v8
M$2952 167 1760 1194 167 nfet_01v8 L=150000U W=210000U AS=21875000000P
+ AD=40400000000P PS=460000U PD=560000U
* device instance $2953 r0 *1 27.705,22 nfet_01v8
M$2953 2917 3666 167 167 nfet_01v8 L=150000U W=210000U AS=40400000000P
+ AD=21875000000P PS=560000U PD=460000U
* device instance $2954 r0 *1 28.295,22 nfet_01v8
M$2954 1760 1194 167 167 nfet_01v8 L=150000U W=210000U AS=40400000000P
+ AD=21875000000P PS=560000U PD=460000U
* device instance $2955 r0 *1 27.74,22.4 nfet_01v8
M$2955 37 142 2917 167 nfet_01v8 L=150000U W=140000U AS=21875000000P
+ AD=16800000000P PS=460000U PD=380000U
* device instance $2956 r0 *1 28.26,22.4 nfet_01v8
M$2956 40 142 1760 167 nfet_01v8 L=150000U W=140000U AS=21875000000P
+ AD=16800000000P PS=460000U PD=380000U
* device instance $2957 r0 *1 27.74,22.79 nfet_01v8
M$2957 3667 143 37 167 nfet_01v8 L=150000U W=140000U AS=16800000000P
+ AD=21875000000P PS=380000U PD=460000U
* device instance $2958 r0 *1 28.26,22.79 nfet_01v8
M$2958 4521 143 40 167 nfet_01v8 L=150000U W=140000U AS=16800000000P
+ AD=21875000000P PS=380000U PD=460000U
* device instance $2959 r0 *1 27.705,23.19 nfet_01v8
M$2959 167 2875 3667 167 nfet_01v8 L=150000U W=210000U AS=21875000000P
+ AD=40400000000P PS=460000U PD=560000U
* device instance $2960 r0 *1 28.295,23.19 nfet_01v8
M$2960 167 693 4521 167 nfet_01v8 L=150000U W=210000U AS=21875000000P
+ AD=40400000000P PS=460000U PD=560000U
* device instance $2961 r0 *1 27.705,23.58 nfet_01v8
M$2961 2875 3667 167 167 nfet_01v8 L=150000U W=210000U AS=40400000000P
+ AD=21875000000P PS=560000U PD=460000U
* device instance $2962 r0 *1 28.295,23.58 nfet_01v8
M$2962 693 4521 167 167 nfet_01v8 L=150000U W=210000U AS=40400000000P
+ AD=21875000000P PS=560000U PD=460000U
* device instance $2963 r0 *1 27.74,23.98 nfet_01v8
M$2963 38 143 2875 167 nfet_01v8 L=150000U W=140000U AS=21875000000P
+ AD=16800000000P PS=460000U PD=380000U
* device instance $2964 r0 *1 28.26,23.98 nfet_01v8
M$2964 39 143 693 167 nfet_01v8 L=150000U W=140000U AS=21875000000P
+ AD=16800000000P PS=460000U PD=380000U
* device instance $2965 r0 *1 27.74,24.37 nfet_01v8
M$2965 2452 144 38 167 nfet_01v8 L=150000U W=140000U AS=16800000000P
+ AD=21875000000P PS=380000U PD=460000U
* device instance $2966 r0 *1 28.26,24.37 nfet_01v8
M$2966 1191 144 39 167 nfet_01v8 L=150000U W=140000U AS=16800000000P
+ AD=21875000000P PS=380000U PD=460000U
* device instance $2967 r0 *1 27.705,24.77 nfet_01v8
M$2967 167 2921 2452 167 nfet_01v8 L=150000U W=210000U AS=21875000000P
+ AD=40400000000P PS=460000U PD=560000U
* device instance $2968 r0 *1 28.295,24.77 nfet_01v8
M$2968 167 1757 1191 167 nfet_01v8 L=150000U W=210000U AS=21875000000P
+ AD=40400000000P PS=460000U PD=560000U
* device instance $2969 r0 *1 27.705,25.16 nfet_01v8
M$2969 2921 2452 167 167 nfet_01v8 L=150000U W=210000U AS=40400000000P
+ AD=21875000000P PS=560000U PD=460000U
* device instance $2970 r0 *1 28.295,25.16 nfet_01v8
M$2970 1757 1191 167 167 nfet_01v8 L=150000U W=210000U AS=40400000000P
+ AD=21875000000P PS=560000U PD=460000U
* device instance $2971 r0 *1 27.74,25.56 nfet_01v8
M$2971 37 144 2921 167 nfet_01v8 L=150000U W=140000U AS=21875000000P
+ AD=16800000000P PS=460000U PD=380000U
* device instance $2972 r0 *1 28.26,25.56 nfet_01v8
M$2972 40 144 1757 167 nfet_01v8 L=150000U W=140000U AS=21875000000P
+ AD=16800000000P PS=460000U PD=380000U
* device instance $2973 r0 *1 27.74,25.95 nfet_01v8
M$2973 2445 145 37 167 nfet_01v8 L=150000U W=140000U AS=16800000000P
+ AD=21875000000P PS=380000U PD=460000U
* device instance $2974 r0 *1 28.26,25.95 nfet_01v8
M$2974 1190 145 40 167 nfet_01v8 L=150000U W=140000U AS=16800000000P
+ AD=21875000000P PS=380000U PD=460000U
* device instance $2975 r0 *1 27.705,26.35 nfet_01v8
M$2975 167 2910 2445 167 nfet_01v8 L=150000U W=210000U AS=21875000000P
+ AD=40400000000P PS=460000U PD=560000U
* device instance $2976 r0 *1 28.295,26.35 nfet_01v8
M$2976 167 1756 1190 167 nfet_01v8 L=150000U W=210000U AS=21875000000P
+ AD=40400000000P PS=460000U PD=560000U
* device instance $2977 r0 *1 27.705,26.74 nfet_01v8
M$2977 2910 2445 167 167 nfet_01v8 L=150000U W=210000U AS=40400000000P
+ AD=21875000000P PS=560000U PD=460000U
* device instance $2978 r0 *1 28.295,26.74 nfet_01v8
M$2978 1756 1190 167 167 nfet_01v8 L=150000U W=210000U AS=40400000000P
+ AD=21875000000P PS=560000U PD=460000U
* device instance $2979 r0 *1 27.74,27.14 nfet_01v8
M$2979 38 145 2910 167 nfet_01v8 L=150000U W=140000U AS=21875000000P
+ AD=16800000000P PS=460000U PD=380000U
* device instance $2980 r0 *1 28.26,27.14 nfet_01v8
M$2980 39 145 1756 167 nfet_01v8 L=150000U W=140000U AS=21875000000P
+ AD=16800000000P PS=460000U PD=380000U
* device instance $2981 r0 *1 38.64,21.21 nfet_01v8
M$2981 2405 142 54 167 nfet_01v8 L=150000U W=140000U AS=16800000000P
+ AD=21875000000P PS=380000U PD=460000U
* device instance $2982 r0 *1 39.16,21.21 nfet_01v8
M$2982 1208 142 55 167 nfet_01v8 L=150000U W=140000U AS=16800000000P
+ AD=21875000000P PS=380000U PD=460000U
* device instance $2983 r0 *1 38.605,21.61 nfet_01v8
M$2983 167 2822 2405 167 nfet_01v8 L=150000U W=210000U AS=21875000000P
+ AD=40400000000P PS=460000U PD=560000U
* device instance $2984 r0 *1 39.195,21.61 nfet_01v8
M$2984 167 1778 1208 167 nfet_01v8 L=150000U W=210000U AS=21875000000P
+ AD=40400000000P PS=460000U PD=560000U
* device instance $2985 r0 *1 38.605,22 nfet_01v8
M$2985 2822 2405 167 167 nfet_01v8 L=150000U W=210000U AS=40400000000P
+ AD=21875000000P PS=560000U PD=460000U
* device instance $2986 r0 *1 39.195,22 nfet_01v8
M$2986 1778 1208 167 167 nfet_01v8 L=150000U W=210000U AS=40400000000P
+ AD=21875000000P PS=560000U PD=460000U
* device instance $2987 r0 *1 38.64,22.4 nfet_01v8
M$2987 53 142 2822 167 nfet_01v8 L=150000U W=140000U AS=21875000000P
+ AD=16800000000P PS=460000U PD=380000U
* device instance $2988 r0 *1 39.16,22.4 nfet_01v8
M$2988 56 142 1778 167 nfet_01v8 L=150000U W=140000U AS=21875000000P
+ AD=16800000000P PS=460000U PD=380000U
* device instance $2989 r0 *1 38.64,22.79 nfet_01v8
M$2989 3279 143 53 167 nfet_01v8 L=150000U W=140000U AS=16800000000P
+ AD=21875000000P PS=380000U PD=460000U
* device instance $2990 r0 *1 39.16,22.79 nfet_01v8
M$2990 4529 143 56 167 nfet_01v8 L=150000U W=140000U AS=16800000000P
+ AD=21875000000P PS=380000U PD=460000U
* device instance $2991 r0 *1 38.605,23.19 nfet_01v8
M$2991 167 2222 3279 167 nfet_01v8 L=150000U W=210000U AS=21875000000P
+ AD=40400000000P PS=460000U PD=560000U
* device instance $2992 r0 *1 39.195,23.19 nfet_01v8
M$2992 167 840 4529 167 nfet_01v8 L=150000U W=210000U AS=21875000000P
+ AD=40400000000P PS=460000U PD=560000U
* device instance $2993 r0 *1 38.605,23.58 nfet_01v8
M$2993 2222 3279 167 167 nfet_01v8 L=150000U W=210000U AS=40400000000P
+ AD=21875000000P PS=560000U PD=460000U
* device instance $2994 r0 *1 39.195,23.58 nfet_01v8
M$2994 840 4529 167 167 nfet_01v8 L=150000U W=210000U AS=40400000000P
+ AD=21875000000P PS=560000U PD=460000U
* device instance $2995 r0 *1 38.64,23.98 nfet_01v8
M$2995 54 143 2222 167 nfet_01v8 L=150000U W=140000U AS=21875000000P
+ AD=16800000000P PS=460000U PD=380000U
* device instance $2996 r0 *1 39.16,23.98 nfet_01v8
M$2996 55 143 840 167 nfet_01v8 L=150000U W=140000U AS=21875000000P
+ AD=16800000000P PS=460000U PD=380000U
* device instance $2997 r0 *1 38.64,24.37 nfet_01v8
M$2997 3278 144 54 167 nfet_01v8 L=150000U W=140000U AS=16800000000P
+ AD=21875000000P PS=380000U PD=460000U
* device instance $2998 r0 *1 39.16,24.37 nfet_01v8
M$2998 660 144 55 167 nfet_01v8 L=150000U W=140000U AS=16800000000P
+ AD=21875000000P PS=380000U PD=460000U
* device instance $2999 r0 *1 38.605,24.77 nfet_01v8
M$2999 167 2219 3278 167 nfet_01v8 L=150000U W=210000U AS=21875000000P
+ AD=40400000000P PS=460000U PD=560000U
* device instance $3000 r0 *1 39.195,24.77 nfet_01v8
M$3000 167 843 660 167 nfet_01v8 L=150000U W=210000U AS=21875000000P
+ AD=40400000000P PS=460000U PD=560000U
* device instance $3001 r0 *1 38.605,25.16 nfet_01v8
M$3001 2219 3278 167 167 nfet_01v8 L=150000U W=210000U AS=40400000000P
+ AD=21875000000P PS=560000U PD=460000U
* device instance $3002 r0 *1 39.195,25.16 nfet_01v8
M$3002 843 660 167 167 nfet_01v8 L=150000U W=210000U AS=40400000000P
+ AD=21875000000P PS=560000U PD=460000U
* device instance $3003 r0 *1 38.64,25.56 nfet_01v8
M$3003 53 144 2219 167 nfet_01v8 L=150000U W=140000U AS=21875000000P
+ AD=16800000000P PS=460000U PD=380000U
* device instance $3004 r0 *1 39.16,25.56 nfet_01v8
M$3004 56 144 843 167 nfet_01v8 L=150000U W=140000U AS=21875000000P
+ AD=16800000000P PS=460000U PD=380000U
* device instance $3005 r0 *1 38.64,25.95 nfet_01v8
M$3005 3276 145 53 167 nfet_01v8 L=150000U W=140000U AS=16800000000P
+ AD=21875000000P PS=380000U PD=460000U
* device instance $3006 r0 *1 39.16,25.95 nfet_01v8
M$3006 1228 145 56 167 nfet_01v8 L=150000U W=140000U AS=16800000000P
+ AD=21875000000P PS=380000U PD=460000U
* device instance $3007 r0 *1 38.605,26.35 nfet_01v8
M$3007 167 2904 3276 167 nfet_01v8 L=150000U W=210000U AS=21875000000P
+ AD=40400000000P PS=460000U PD=560000U
* device instance $3008 r0 *1 39.195,26.35 nfet_01v8
M$3008 167 1799 1228 167 nfet_01v8 L=150000U W=210000U AS=21875000000P
+ AD=40400000000P PS=460000U PD=560000U
* device instance $3009 r0 *1 38.605,26.74 nfet_01v8
M$3009 2904 3276 167 167 nfet_01v8 L=150000U W=210000U AS=40400000000P
+ AD=21875000000P PS=560000U PD=460000U
* device instance $3010 r0 *1 39.195,26.74 nfet_01v8
M$3010 1799 1228 167 167 nfet_01v8 L=150000U W=210000U AS=40400000000P
+ AD=21875000000P PS=560000U PD=460000U
* device instance $3011 r0 *1 38.64,27.14 nfet_01v8
M$3011 54 145 2904 167 nfet_01v8 L=150000U W=140000U AS=21875000000P
+ AD=16800000000P PS=460000U PD=380000U
* device instance $3012 r0 *1 39.16,27.14 nfet_01v8
M$3012 55 145 1799 167 nfet_01v8 L=150000U W=140000U AS=21875000000P
+ AD=16800000000P PS=460000U PD=380000U
* device instance $3013 r0 *1 49.54,21.21 nfet_01v8
M$3013 3482 142 70 167 nfet_01v8 L=150000U W=140000U AS=16800000000P
+ AD=21875000000P PS=380000U PD=460000U
* device instance $3014 r0 *1 50.06,21.21 nfet_01v8
M$3014 1124 142 71 167 nfet_01v8 L=150000U W=140000U AS=16800000000P
+ AD=21875000000P PS=380000U PD=460000U
* device instance $3015 r0 *1 49.505,21.61 nfet_01v8
M$3015 167 2729 3482 167 nfet_01v8 L=150000U W=210000U AS=21875000000P
+ AD=40400000000P PS=460000U PD=560000U
* device instance $3016 r0 *1 50.095,21.61 nfet_01v8
M$3016 167 1679 1124 167 nfet_01v8 L=150000U W=210000U AS=21875000000P
+ AD=40400000000P PS=460000U PD=560000U
* device instance $3017 r0 *1 49.505,22 nfet_01v8
M$3017 2729 3482 167 167 nfet_01v8 L=150000U W=210000U AS=40400000000P
+ AD=21875000000P PS=560000U PD=460000U
* device instance $3018 r0 *1 50.095,22 nfet_01v8
M$3018 1679 1124 167 167 nfet_01v8 L=150000U W=210000U AS=40400000000P
+ AD=21875000000P PS=560000U PD=460000U
* device instance $3019 r0 *1 49.54,22.4 nfet_01v8
M$3019 69 142 2729 167 nfet_01v8 L=150000U W=140000U AS=21875000000P
+ AD=16800000000P PS=460000U PD=380000U
* device instance $3020 r0 *1 50.06,22.4 nfet_01v8
M$3020 72 142 1679 167 nfet_01v8 L=150000U W=140000U AS=21875000000P
+ AD=16800000000P PS=460000U PD=380000U
* device instance $3021 r0 *1 49.54,22.79 nfet_01v8
M$3021 3445 143 69 167 nfet_01v8 L=150000U W=140000U AS=16800000000P
+ AD=21875000000P PS=380000U PD=460000U
* device instance $3022 r0 *1 50.06,22.79 nfet_01v8
M$3022 4382 143 72 167 nfet_01v8 L=150000U W=140000U AS=16800000000P
+ AD=21875000000P PS=380000U PD=460000U
* device instance $3023 r0 *1 49.505,23.19 nfet_01v8
M$3023 167 2008 3445 167 nfet_01v8 L=150000U W=210000U AS=21875000000P
+ AD=40400000000P PS=460000U PD=560000U
* device instance $3024 r0 *1 50.095,23.19 nfet_01v8
M$3024 167 815 4382 167 nfet_01v8 L=150000U W=210000U AS=21875000000P
+ AD=40400000000P PS=460000U PD=560000U
* device instance $3025 r0 *1 49.505,23.58 nfet_01v8
M$3025 2008 3445 167 167 nfet_01v8 L=150000U W=210000U AS=40400000000P
+ AD=21875000000P PS=560000U PD=460000U
* device instance $3026 r0 *1 50.095,23.58 nfet_01v8
M$3026 815 4382 167 167 nfet_01v8 L=150000U W=210000U AS=40400000000P
+ AD=21875000000P PS=560000U PD=460000U
* device instance $3027 r0 *1 49.54,23.98 nfet_01v8
M$3027 70 143 2008 167 nfet_01v8 L=150000U W=140000U AS=21875000000P
+ AD=16800000000P PS=460000U PD=380000U
* device instance $3028 r0 *1 50.06,23.98 nfet_01v8
M$3028 71 143 815 167 nfet_01v8 L=150000U W=140000U AS=21875000000P
+ AD=16800000000P PS=460000U PD=380000U
* device instance $3029 r0 *1 49.54,24.37 nfet_01v8
M$3029 2125 144 70 167 nfet_01v8 L=150000U W=140000U AS=16800000000P
+ AD=21875000000P PS=380000U PD=460000U
* device instance $3030 r0 *1 50.06,24.37 nfet_01v8
M$3030 642 144 71 167 nfet_01v8 L=150000U W=140000U AS=16800000000P
+ AD=21875000000P PS=380000U PD=460000U
* device instance $3031 r0 *1 49.505,24.77 nfet_01v8
M$3031 167 2262 2125 167 nfet_01v8 L=150000U W=210000U AS=21875000000P
+ AD=40400000000P PS=460000U PD=560000U
* device instance $3032 r0 *1 50.095,24.77 nfet_01v8
M$3032 167 801 642 167 nfet_01v8 L=150000U W=210000U AS=21875000000P
+ AD=40400000000P PS=460000U PD=560000U
* device instance $3033 r0 *1 49.505,25.16 nfet_01v8
M$3033 2262 2125 167 167 nfet_01v8 L=150000U W=210000U AS=40400000000P
+ AD=21875000000P PS=560000U PD=460000U
* device instance $3034 r0 *1 50.095,25.16 nfet_01v8
M$3034 801 642 167 167 nfet_01v8 L=150000U W=210000U AS=40400000000P
+ AD=21875000000P PS=560000U PD=460000U
* device instance $3035 r0 *1 49.54,25.56 nfet_01v8
M$3035 69 144 2262 167 nfet_01v8 L=150000U W=140000U AS=21875000000P
+ AD=16800000000P PS=460000U PD=380000U
* device instance $3036 r0 *1 50.06,25.56 nfet_01v8
M$3036 72 144 801 167 nfet_01v8 L=150000U W=140000U AS=21875000000P
+ AD=16800000000P PS=460000U PD=380000U
* device instance $3037 r0 *1 49.54,25.95 nfet_01v8
M$3037 2431 145 69 167 nfet_01v8 L=150000U W=140000U AS=16800000000P
+ AD=21875000000P PS=380000U PD=460000U
* device instance $3038 r0 *1 50.06,25.95 nfet_01v8
M$3038 1123 145 72 167 nfet_01v8 L=150000U W=140000U AS=16800000000P
+ AD=21875000000P PS=380000U PD=460000U
* device instance $3039 r0 *1 49.505,26.35 nfet_01v8
M$3039 167 2879 2431 167 nfet_01v8 L=150000U W=210000U AS=21875000000P
+ AD=40400000000P PS=460000U PD=560000U
* device instance $3040 r0 *1 50.095,26.35 nfet_01v8
M$3040 167 1678 1123 167 nfet_01v8 L=150000U W=210000U AS=21875000000P
+ AD=40400000000P PS=460000U PD=560000U
* device instance $3041 r0 *1 49.505,26.74 nfet_01v8
M$3041 2879 2431 167 167 nfet_01v8 L=150000U W=210000U AS=40400000000P
+ AD=21875000000P PS=560000U PD=460000U
* device instance $3042 r0 *1 50.095,26.74 nfet_01v8
M$3042 1678 1123 167 167 nfet_01v8 L=150000U W=210000U AS=40400000000P
+ AD=21875000000P PS=560000U PD=460000U
* device instance $3043 r0 *1 49.54,27.14 nfet_01v8
M$3043 70 145 2879 167 nfet_01v8 L=150000U W=140000U AS=21875000000P
+ AD=16800000000P PS=460000U PD=380000U
* device instance $3044 r0 *1 50.06,27.14 nfet_01v8
M$3044 71 145 1678 167 nfet_01v8 L=150000U W=140000U AS=21875000000P
+ AD=16800000000P PS=460000U PD=380000U
* device instance $3045 r0 *1 60.44,21.21 nfet_01v8
M$3045 2347 142 86 167 nfet_01v8 L=150000U W=140000U AS=16800000000P
+ AD=21875000000P PS=380000U PD=460000U
* device instance $3046 r0 *1 60.96,21.21 nfet_01v8
M$3046 1167 142 87 167 nfet_01v8 L=150000U W=140000U AS=16800000000P
+ AD=21875000000P PS=380000U PD=460000U
* device instance $3047 r0 *1 60.405,21.61 nfet_01v8
M$3047 167 2720 2347 167 nfet_01v8 L=150000U W=210000U AS=21875000000P
+ AD=40400000000P PS=460000U PD=560000U
* device instance $3048 r0 *1 60.995,21.61 nfet_01v8
M$3048 167 1729 1167 167 nfet_01v8 L=150000U W=210000U AS=21875000000P
+ AD=40400000000P PS=460000U PD=560000U
* device instance $3049 r0 *1 60.405,22 nfet_01v8
M$3049 2720 2347 167 167 nfet_01v8 L=150000U W=210000U AS=40400000000P
+ AD=21875000000P PS=560000U PD=460000U
* device instance $3050 r0 *1 60.995,22 nfet_01v8
M$3050 1729 1167 167 167 nfet_01v8 L=150000U W=210000U AS=40400000000P
+ AD=21875000000P PS=560000U PD=460000U
* device instance $3051 r0 *1 60.44,22.4 nfet_01v8
M$3051 85 142 2720 167 nfet_01v8 L=150000U W=140000U AS=21875000000P
+ AD=16800000000P PS=460000U PD=380000U
* device instance $3052 r0 *1 60.96,22.4 nfet_01v8
M$3052 88 142 1729 167 nfet_01v8 L=150000U W=140000U AS=21875000000P
+ AD=16800000000P PS=460000U PD=380000U
* device instance $3053 r0 *1 60.44,22.79 nfet_01v8
M$3053 3463 143 85 167 nfet_01v8 L=150000U W=140000U AS=16800000000P
+ AD=21875000000P PS=380000U PD=460000U
* device instance $3054 r0 *1 60.96,22.79 nfet_01v8
M$3054 4387 143 88 167 nfet_01v8 L=150000U W=140000U AS=16800000000P
+ AD=21875000000P PS=380000U PD=460000U
* device instance $3055 r0 *1 60.405,23.19 nfet_01v8
M$3055 167 2714 3463 167 nfet_01v8 L=150000U W=210000U AS=21875000000P
+ AD=40400000000P PS=460000U PD=560000U
* device instance $3056 r0 *1 60.995,23.19 nfet_01v8
M$3056 167 771 4387 167 nfet_01v8 L=150000U W=210000U AS=21875000000P
+ AD=40400000000P PS=460000U PD=560000U
* device instance $3057 r0 *1 60.405,23.58 nfet_01v8
M$3057 2714 3463 167 167 nfet_01v8 L=150000U W=210000U AS=40400000000P
+ AD=21875000000P PS=560000U PD=460000U
* device instance $3058 r0 *1 60.995,23.58 nfet_01v8
M$3058 771 4387 167 167 nfet_01v8 L=150000U W=210000U AS=40400000000P
+ AD=21875000000P PS=560000U PD=460000U
* device instance $3059 r0 *1 60.44,23.98 nfet_01v8
M$3059 86 143 2714 167 nfet_01v8 L=150000U W=140000U AS=21875000000P
+ AD=16800000000P PS=460000U PD=380000U
* device instance $3060 r0 *1 60.96,23.98 nfet_01v8
M$3060 87 143 771 167 nfet_01v8 L=150000U W=140000U AS=21875000000P
+ AD=16800000000P PS=460000U PD=380000U
* device instance $3061 r0 *1 60.44,24.37 nfet_01v8
M$3061 2354 144 86 167 nfet_01v8 L=150000U W=140000U AS=16800000000P
+ AD=21875000000P PS=380000U PD=460000U
* device instance $3062 r0 *1 60.96,24.37 nfet_01v8
M$3062 627 144 87 167 nfet_01v8 L=150000U W=140000U AS=16800000000P
+ AD=21875000000P PS=380000U PD=460000U
* device instance $3063 r0 *1 60.405,24.77 nfet_01v8
M$3063 167 2738 2354 167 nfet_01v8 L=150000U W=210000U AS=21875000000P
+ AD=40400000000P PS=460000U PD=560000U
* device instance $3064 r0 *1 60.995,24.77 nfet_01v8
M$3064 167 774 627 167 nfet_01v8 L=150000U W=210000U AS=21875000000P
+ AD=40400000000P PS=460000U PD=560000U
* device instance $3065 r0 *1 60.405,25.16 nfet_01v8
M$3065 2738 2354 167 167 nfet_01v8 L=150000U W=210000U AS=40400000000P
+ AD=21875000000P PS=560000U PD=460000U
* device instance $3066 r0 *1 60.995,25.16 nfet_01v8
M$3066 774 627 167 167 nfet_01v8 L=150000U W=210000U AS=40400000000P
+ AD=21875000000P PS=560000U PD=460000U
* device instance $3067 r0 *1 60.44,25.56 nfet_01v8
M$3067 85 144 2738 167 nfet_01v8 L=150000U W=140000U AS=21875000000P
+ AD=16800000000P PS=460000U PD=380000U
* device instance $3068 r0 *1 60.96,25.56 nfet_01v8
M$3068 88 144 774 167 nfet_01v8 L=150000U W=140000U AS=21875000000P
+ AD=16800000000P PS=460000U PD=380000U
* device instance $3069 r0 *1 60.44,25.95 nfet_01v8
M$3069 2353 145 85 167 nfet_01v8 L=150000U W=140000U AS=16800000000P
+ AD=21875000000P PS=380000U PD=460000U
* device instance $3070 r0 *1 60.96,25.95 nfet_01v8
M$3070 1135 145 88 167 nfet_01v8 L=150000U W=140000U AS=16800000000P
+ AD=21875000000P PS=380000U PD=460000U
* device instance $3071 r0 *1 60.405,26.35 nfet_01v8
M$3071 167 2736 2353 167 nfet_01v8 L=150000U W=210000U AS=21875000000P
+ AD=40400000000P PS=460000U PD=560000U
* device instance $3072 r0 *1 60.995,26.35 nfet_01v8
M$3072 167 1691 1135 167 nfet_01v8 L=150000U W=210000U AS=21875000000P
+ AD=40400000000P PS=460000U PD=560000U
* device instance $3073 r0 *1 60.405,26.74 nfet_01v8
M$3073 2736 2353 167 167 nfet_01v8 L=150000U W=210000U AS=40400000000P
+ AD=21875000000P PS=560000U PD=460000U
* device instance $3074 r0 *1 60.995,26.74 nfet_01v8
M$3074 1691 1135 167 167 nfet_01v8 L=150000U W=210000U AS=40400000000P
+ AD=21875000000P PS=560000U PD=460000U
* device instance $3075 r0 *1 60.44,27.14 nfet_01v8
M$3075 86 145 2736 167 nfet_01v8 L=150000U W=140000U AS=21875000000P
+ AD=16800000000P PS=460000U PD=380000U
* device instance $3076 r0 *1 60.96,27.14 nfet_01v8
M$3076 87 145 1691 167 nfet_01v8 L=150000U W=140000U AS=21875000000P
+ AD=16800000000P PS=460000U PD=380000U
* device instance $3077 r0 *1 71.34,21.21 nfet_01v8
M$3077 2398 142 102 167 nfet_01v8 L=150000U W=140000U AS=16800000000P
+ AD=21875000000P PS=380000U PD=460000U
* device instance $3078 r0 *1 71.86,21.21 nfet_01v8
M$3078 983 142 103 167 nfet_01v8 L=150000U W=140000U AS=16800000000P
+ AD=21875000000P PS=380000U PD=460000U
* device instance $3079 r0 *1 71.305,21.61 nfet_01v8
M$3079 167 2813 2398 167 nfet_01v8 L=150000U W=210000U AS=21875000000P
+ AD=40400000000P PS=460000U PD=560000U
* device instance $3080 r0 *1 71.895,21.61 nfet_01v8
M$3080 167 1516 983 167 nfet_01v8 L=150000U W=210000U AS=21875000000P
+ AD=40400000000P PS=460000U PD=560000U
* device instance $3081 r0 *1 71.305,22 nfet_01v8
M$3081 2813 2398 167 167 nfet_01v8 L=150000U W=210000U AS=40400000000P
+ AD=21875000000P PS=560000U PD=460000U
* device instance $3082 r0 *1 71.895,22 nfet_01v8
M$3082 1516 983 167 167 nfet_01v8 L=150000U W=210000U AS=40400000000P
+ AD=21875000000P PS=560000U PD=460000U
* device instance $3083 r0 *1 71.34,22.4 nfet_01v8
M$3083 101 142 2813 167 nfet_01v8 L=150000U W=140000U AS=21875000000P
+ AD=16800000000P PS=460000U PD=380000U
* device instance $3084 r0 *1 71.86,22.4 nfet_01v8
M$3084 104 142 1516 167 nfet_01v8 L=150000U W=140000U AS=21875000000P
+ AD=16800000000P PS=460000U PD=380000U
* device instance $3085 r0 *1 71.34,22.79 nfet_01v8
M$3085 3443 143 101 167 nfet_01v8 L=150000U W=140000U AS=16800000000P
+ AD=21875000000P PS=380000U PD=460000U
* device instance $3086 r0 *1 71.86,22.79 nfet_01v8
M$3086 4284 143 104 167 nfet_01v8 L=150000U W=140000U AS=16800000000P
+ AD=21875000000P PS=380000U PD=460000U
* device instance $3087 r0 *1 71.305,23.19 nfet_01v8
M$3087 167 2018 3443 167 nfet_01v8 L=150000U W=210000U AS=21875000000P
+ AD=40400000000P PS=460000U PD=560000U
* device instance $3088 r0 *1 71.895,23.19 nfet_01v8
M$3088 167 779 4284 167 nfet_01v8 L=150000U W=210000U AS=21875000000P
+ AD=40400000000P PS=460000U PD=560000U
* device instance $3089 r0 *1 71.305,23.58 nfet_01v8
M$3089 2018 3443 167 167 nfet_01v8 L=150000U W=210000U AS=40400000000P
+ AD=21875000000P PS=560000U PD=460000U
* device instance $3090 r0 *1 71.895,23.58 nfet_01v8
M$3090 779 4284 167 167 nfet_01v8 L=150000U W=210000U AS=40400000000P
+ AD=21875000000P PS=560000U PD=460000U
* device instance $3091 r0 *1 71.34,23.98 nfet_01v8
M$3091 102 143 2018 167 nfet_01v8 L=150000U W=140000U AS=21875000000P
+ AD=16800000000P PS=460000U PD=380000U
* device instance $3092 r0 *1 71.86,23.98 nfet_01v8
M$3092 103 143 779 167 nfet_01v8 L=150000U W=140000U AS=21875000000P
+ AD=16800000000P PS=460000U PD=380000U
* device instance $3093 r0 *1 71.34,24.37 nfet_01v8
M$3093 3440 144 102 167 nfet_01v8 L=150000U W=140000U AS=16800000000P
+ AD=21875000000P PS=380000U PD=460000U
* device instance $3094 r0 *1 71.86,24.37 nfet_01v8
M$3094 669 144 103 167 nfet_01v8 L=150000U W=140000U AS=16800000000P
+ AD=21875000000P PS=380000U PD=460000U
* device instance $3095 r0 *1 71.305,24.77 nfet_01v8
M$3095 167 2825 3440 167 nfet_01v8 L=150000U W=210000U AS=21875000000P
+ AD=40400000000P PS=460000U PD=560000U
* device instance $3096 r0 *1 71.895,24.77 nfet_01v8
M$3096 167 860 669 167 nfet_01v8 L=150000U W=210000U AS=21875000000P
+ AD=40400000000P PS=460000U PD=560000U
* device instance $3097 r0 *1 71.305,25.16 nfet_01v8
M$3097 2825 3440 167 167 nfet_01v8 L=150000U W=210000U AS=40400000000P
+ AD=21875000000P PS=560000U PD=460000U
* device instance $3098 r0 *1 71.895,25.16 nfet_01v8
M$3098 860 669 167 167 nfet_01v8 L=150000U W=210000U AS=40400000000P
+ AD=21875000000P PS=560000U PD=460000U
* device instance $3099 r0 *1 71.34,25.56 nfet_01v8
M$3099 101 144 2825 167 nfet_01v8 L=150000U W=140000U AS=21875000000P
+ AD=16800000000P PS=460000U PD=380000U
* device instance $3100 r0 *1 71.86,25.56 nfet_01v8
M$3100 104 144 860 167 nfet_01v8 L=150000U W=140000U AS=21875000000P
+ AD=16800000000P PS=460000U PD=380000U
* device instance $3101 r0 *1 71.34,25.95 nfet_01v8
M$3101 2403 145 101 167 nfet_01v8 L=150000U W=140000U AS=16800000000P
+ AD=21875000000P PS=380000U PD=460000U
* device instance $3102 r0 *1 71.86,25.95 nfet_01v8
M$3102 981 145 104 167 nfet_01v8 L=150000U W=140000U AS=16800000000P
+ AD=21875000000P PS=380000U PD=460000U
* device instance $3103 r0 *1 71.305,26.35 nfet_01v8
M$3103 167 2818 2403 167 nfet_01v8 L=150000U W=210000U AS=21875000000P
+ AD=40400000000P PS=460000U PD=560000U
* device instance $3104 r0 *1 71.895,26.35 nfet_01v8
M$3104 167 1514 981 167 nfet_01v8 L=150000U W=210000U AS=21875000000P
+ AD=40400000000P PS=460000U PD=560000U
* device instance $3105 r0 *1 71.305,26.74 nfet_01v8
M$3105 2818 2403 167 167 nfet_01v8 L=150000U W=210000U AS=40400000000P
+ AD=21875000000P PS=560000U PD=460000U
* device instance $3106 r0 *1 71.895,26.74 nfet_01v8
M$3106 1514 981 167 167 nfet_01v8 L=150000U W=210000U AS=40400000000P
+ AD=21875000000P PS=560000U PD=460000U
* device instance $3107 r0 *1 71.34,27.14 nfet_01v8
M$3107 102 145 2818 167 nfet_01v8 L=150000U W=140000U AS=21875000000P
+ AD=16800000000P PS=460000U PD=380000U
* device instance $3108 r0 *1 71.86,27.14 nfet_01v8
M$3108 103 145 1514 167 nfet_01v8 L=150000U W=140000U AS=21875000000P
+ AD=16800000000P PS=460000U PD=380000U
* device instance $3109 r0 *1 5.94,13.31 nfet_01v8
M$3109 2546 138 6 167 nfet_01v8 L=150000U W=140000U AS=16800000000P
+ AD=21875000000P PS=380000U PD=460000U
* device instance $3110 r0 *1 6.46,13.31 nfet_01v8
M$3110 1017 138 7 167 nfet_01v8 L=150000U W=140000U AS=16800000000P
+ AD=21875000000P PS=380000U PD=460000U
* device instance $3111 r0 *1 5.905,13.71 nfet_01v8
M$3111 167 3122 2546 167 nfet_01v8 L=150000U W=210000U AS=21875000000P
+ AD=40400000000P PS=460000U PD=560000U
* device instance $3112 r0 *1 6.495,13.71 nfet_01v8
M$3112 167 1552 1017 167 nfet_01v8 L=150000U W=210000U AS=21875000000P
+ AD=40400000000P PS=460000U PD=560000U
* device instance $3113 r0 *1 5.905,14.1 nfet_01v8
M$3113 3122 2546 167 167 nfet_01v8 L=150000U W=210000U AS=40400000000P
+ AD=21875000000P PS=560000U PD=460000U
* device instance $3114 r0 *1 6.495,14.1 nfet_01v8
M$3114 1552 1017 167 167 nfet_01v8 L=150000U W=210000U AS=40400000000P
+ AD=21875000000P PS=560000U PD=460000U
* device instance $3115 r0 *1 5.94,14.5 nfet_01v8
M$3115 5 138 3122 167 nfet_01v8 L=150000U W=140000U AS=21875000000P
+ AD=16800000000P PS=460000U PD=380000U
* device instance $3116 r0 *1 6.46,14.5 nfet_01v8
M$3116 8 138 1552 167 nfet_01v8 L=150000U W=140000U AS=21875000000P
+ AD=16800000000P PS=460000U PD=380000U
* device instance $3117 r0 *1 5.94,14.89 nfet_01v8
M$3117 3308 139 5 167 nfet_01v8 L=150000U W=140000U AS=16800000000P
+ AD=21875000000P PS=380000U PD=460000U
* device instance $3118 r0 *1 6.46,14.89 nfet_01v8
M$3118 4474 139 8 167 nfet_01v8 L=150000U W=140000U AS=16800000000P
+ AD=21875000000P PS=380000U PD=460000U
* device instance $3119 r0 *1 5.905,15.29 nfet_01v8
M$3119 167 2243 3308 167 nfet_01v8 L=150000U W=210000U AS=21875000000P
+ AD=40400000000P PS=460000U PD=560000U
* device instance $3120 r0 *1 6.495,15.29 nfet_01v8
M$3120 167 816 4474 167 nfet_01v8 L=150000U W=210000U AS=21875000000P
+ AD=40400000000P PS=460000U PD=560000U
* device instance $3121 r0 *1 5.905,15.68 nfet_01v8
M$3121 2243 3308 167 167 nfet_01v8 L=150000U W=210000U AS=40400000000P
+ AD=21875000000P PS=560000U PD=460000U
* device instance $3122 r0 *1 6.495,15.68 nfet_01v8
M$3122 816 4474 167 167 nfet_01v8 L=150000U W=210000U AS=40400000000P
+ AD=21875000000P PS=560000U PD=460000U
* device instance $3123 r0 *1 5.94,16.08 nfet_01v8
M$3123 6 139 2243 167 nfet_01v8 L=150000U W=140000U AS=21875000000P
+ AD=16800000000P PS=460000U PD=380000U
* device instance $3124 r0 *1 6.46,16.08 nfet_01v8
M$3124 7 139 816 167 nfet_01v8 L=150000U W=140000U AS=21875000000P
+ AD=16800000000P PS=460000U PD=380000U
* device instance $3125 r0 *1 5.94,16.47 nfet_01v8
M$3125 3206 140 6 167 nfet_01v8 L=150000U W=140000U AS=16800000000P
+ AD=21875000000P PS=380000U PD=460000U
* device instance $3126 r0 *1 6.46,16.47 nfet_01v8
M$3126 1014 140 7 167 nfet_01v8 L=150000U W=140000U AS=16800000000P
+ AD=21875000000P PS=380000U PD=460000U
* device instance $3127 r0 *1 5.905,16.87 nfet_01v8
M$3127 167 2689 3206 167 nfet_01v8 L=150000U W=210000U AS=21875000000P
+ AD=40400000000P PS=460000U PD=560000U
* device instance $3128 r0 *1 6.495,16.87 nfet_01v8
M$3128 167 1549 1014 167 nfet_01v8 L=150000U W=210000U AS=21875000000P
+ AD=40400000000P PS=460000U PD=560000U
* device instance $3129 r0 *1 5.905,17.26 nfet_01v8
M$3129 2689 3206 167 167 nfet_01v8 L=150000U W=210000U AS=40400000000P
+ AD=21875000000P PS=560000U PD=460000U
* device instance $3130 r0 *1 6.495,17.26 nfet_01v8
M$3130 1549 1014 167 167 nfet_01v8 L=150000U W=210000U AS=40400000000P
+ AD=21875000000P PS=560000U PD=460000U
* device instance $3131 r0 *1 5.94,17.66 nfet_01v8
M$3131 5 140 2689 167 nfet_01v8 L=150000U W=140000U AS=21875000000P
+ AD=16800000000P PS=460000U PD=380000U
* device instance $3132 r0 *1 6.46,17.66 nfet_01v8
M$3132 8 140 1549 167 nfet_01v8 L=150000U W=140000U AS=21875000000P
+ AD=16800000000P PS=460000U PD=380000U
* device instance $3133 r0 *1 5.94,18.05 nfet_01v8
M$3133 3207 141 5 167 nfet_01v8 L=150000U W=140000U AS=16800000000P
+ AD=21875000000P PS=380000U PD=460000U
* device instance $3134 r0 *1 6.46,18.05 nfet_01v8
M$3134 1015 141 8 167 nfet_01v8 L=150000U W=140000U AS=16800000000P
+ AD=21875000000P PS=380000U PD=460000U
* device instance $3135 r0 *1 5.905,18.45 nfet_01v8
M$3135 167 3124 3207 167 nfet_01v8 L=150000U W=210000U AS=21875000000P
+ AD=40400000000P PS=460000U PD=560000U
* device instance $3136 r0 *1 6.495,18.45 nfet_01v8
M$3136 167 1550 1015 167 nfet_01v8 L=150000U W=210000U AS=21875000000P
+ AD=40400000000P PS=460000U PD=560000U
* device instance $3137 r0 *1 5.905,18.84 nfet_01v8
M$3137 3124 3207 167 167 nfet_01v8 L=150000U W=210000U AS=40400000000P
+ AD=21875000000P PS=560000U PD=460000U
* device instance $3138 r0 *1 6.495,18.84 nfet_01v8
M$3138 1550 1015 167 167 nfet_01v8 L=150000U W=210000U AS=40400000000P
+ AD=21875000000P PS=560000U PD=460000U
* device instance $3139 r0 *1 5.94,19.24 nfet_01v8
M$3139 6 141 3124 167 nfet_01v8 L=150000U W=140000U AS=21875000000P
+ AD=16800000000P PS=460000U PD=380000U
* device instance $3140 r0 *1 6.46,19.24 nfet_01v8
M$3140 7 141 1550 167 nfet_01v8 L=150000U W=140000U AS=21875000000P
+ AD=16800000000P PS=460000U PD=380000U
* device instance $3141 r0 *1 82.24,21.21 nfet_01v8
M$3141 2419 142 118 167 nfet_01v8 L=150000U W=140000U AS=16800000000P
+ AD=21875000000P PS=380000U PD=460000U
* device instance $3142 r0 *1 82.76,21.21 nfet_01v8
M$3142 966 142 119 167 nfet_01v8 L=150000U W=140000U AS=16800000000P
+ AD=21875000000P PS=380000U PD=460000U
* device instance $3143 r0 *1 82.205,21.61 nfet_01v8
M$3143 167 2851 2419 167 nfet_01v8 L=150000U W=210000U AS=21875000000P
+ AD=40400000000P PS=460000U PD=560000U
* device instance $3144 r0 *1 82.795,21.61 nfet_01v8
M$3144 167 1496 966 167 nfet_01v8 L=150000U W=210000U AS=21875000000P
+ AD=40400000000P PS=460000U PD=560000U
* device instance $3145 r0 *1 82.205,22 nfet_01v8
M$3145 2851 2419 167 167 nfet_01v8 L=150000U W=210000U AS=40400000000P
+ AD=21875000000P PS=560000U PD=460000U
* device instance $3146 r0 *1 82.795,22 nfet_01v8
M$3146 1496 966 167 167 nfet_01v8 L=150000U W=210000U AS=40400000000P
+ AD=21875000000P PS=560000U PD=460000U
* device instance $3147 r0 *1 82.24,22.4 nfet_01v8
M$3147 117 142 2851 167 nfet_01v8 L=150000U W=140000U AS=21875000000P
+ AD=16800000000P PS=460000U PD=380000U
* device instance $3148 r0 *1 82.76,22.4 nfet_01v8
M$3148 120 142 1496 167 nfet_01v8 L=150000U W=140000U AS=21875000000P
+ AD=16800000000P PS=460000U PD=380000U
* device instance $3149 r0 *1 82.24,22.79 nfet_01v8
M$3149 3424 143 117 167 nfet_01v8 L=150000U W=140000U AS=16800000000P
+ AD=21875000000P PS=380000U PD=460000U
* device instance $3150 r0 *1 82.76,22.79 nfet_01v8
M$3150 4361 143 120 167 nfet_01v8 L=150000U W=140000U AS=16800000000P
+ AD=21875000000P PS=380000U PD=460000U
* device instance $3151 r0 *1 82.205,23.19 nfet_01v8
M$3151 167 2832 3424 167 nfet_01v8 L=150000U W=210000U AS=21875000000P
+ AD=40400000000P PS=460000U PD=560000U
* device instance $3152 r0 *1 82.795,23.19 nfet_01v8
M$3152 167 1523 4361 167 nfet_01v8 L=150000U W=210000U AS=21875000000P
+ AD=40400000000P PS=460000U PD=560000U
* device instance $3153 r0 *1 82.205,23.58 nfet_01v8
M$3153 2832 3424 167 167 nfet_01v8 L=150000U W=210000U AS=40400000000P
+ AD=21875000000P PS=560000U PD=460000U
* device instance $3154 r0 *1 82.795,23.58 nfet_01v8
M$3154 1523 4361 167 167 nfet_01v8 L=150000U W=210000U AS=40400000000P
+ AD=21875000000P PS=560000U PD=460000U
* device instance $3155 r0 *1 82.24,23.98 nfet_01v8
M$3155 118 143 2832 167 nfet_01v8 L=150000U W=140000U AS=21875000000P
+ AD=16800000000P PS=460000U PD=380000U
* device instance $3156 r0 *1 82.76,23.98 nfet_01v8
M$3156 119 143 1523 167 nfet_01v8 L=150000U W=140000U AS=21875000000P
+ AD=16800000000P PS=460000U PD=380000U
* device instance $3157 r0 *1 82.24,24.37 nfet_01v8
M$3157 3414 144 118 167 nfet_01v8 L=150000U W=140000U AS=16800000000P
+ AD=21875000000P PS=380000U PD=460000U
* device instance $3158 r0 *1 82.76,24.37 nfet_01v8
M$3158 640 144 119 167 nfet_01v8 L=150000U W=140000U AS=16800000000P
+ AD=21875000000P PS=380000U PD=460000U
* device instance $3159 r0 *1 82.205,24.77 nfet_01v8
M$3159 167 2835 3414 167 nfet_01v8 L=150000U W=210000U AS=21875000000P
+ AD=40400000000P PS=460000U PD=560000U
* device instance $3160 r0 *1 82.795,24.77 nfet_01v8
M$3160 167 799 640 167 nfet_01v8 L=150000U W=210000U AS=21875000000P
+ AD=40400000000P PS=460000U PD=560000U
* device instance $3161 r0 *1 82.205,25.16 nfet_01v8
M$3161 2835 3414 167 167 nfet_01v8 L=150000U W=210000U AS=40400000000P
+ AD=21875000000P PS=560000U PD=460000U
* device instance $3162 r0 *1 82.795,25.16 nfet_01v8
M$3162 799 640 167 167 nfet_01v8 L=150000U W=210000U AS=40400000000P
+ AD=21875000000P PS=560000U PD=460000U
* device instance $3163 r0 *1 82.24,25.56 nfet_01v8
M$3163 117 144 2835 167 nfet_01v8 L=150000U W=140000U AS=21875000000P
+ AD=16800000000P PS=460000U PD=380000U
* device instance $3164 r0 *1 82.76,25.56 nfet_01v8
M$3164 120 144 799 167 nfet_01v8 L=150000U W=140000U AS=21875000000P
+ AD=16800000000P PS=460000U PD=380000U
* device instance $3165 r0 *1 82.24,25.95 nfet_01v8
M$3165 2416 145 117 167 nfet_01v8 L=150000U W=140000U AS=16800000000P
+ AD=21875000000P PS=380000U PD=460000U
* device instance $3166 r0 *1 82.76,25.95 nfet_01v8
M$3166 991 145 120 167 nfet_01v8 L=150000U W=140000U AS=16800000000P
+ AD=21875000000P PS=380000U PD=460000U
* device instance $3167 r0 *1 82.205,26.35 nfet_01v8
M$3167 167 2841 2416 167 nfet_01v8 L=150000U W=210000U AS=21875000000P
+ AD=40400000000P PS=460000U PD=560000U
* device instance $3168 r0 *1 82.795,26.35 nfet_01v8
M$3168 167 1526 991 167 nfet_01v8 L=150000U W=210000U AS=21875000000P
+ AD=40400000000P PS=460000U PD=560000U
* device instance $3169 r0 *1 82.205,26.74 nfet_01v8
M$3169 2841 2416 167 167 nfet_01v8 L=150000U W=210000U AS=40400000000P
+ AD=21875000000P PS=560000U PD=460000U
* device instance $3170 r0 *1 82.795,26.74 nfet_01v8
M$3170 1526 991 167 167 nfet_01v8 L=150000U W=210000U AS=40400000000P
+ AD=21875000000P PS=560000U PD=460000U
* device instance $3171 r0 *1 82.24,27.14 nfet_01v8
M$3171 118 145 2841 167 nfet_01v8 L=150000U W=140000U AS=21875000000P
+ AD=16800000000P PS=460000U PD=380000U
* device instance $3172 r0 *1 82.76,27.14 nfet_01v8
M$3172 119 145 1526 167 nfet_01v8 L=150000U W=140000U AS=21875000000P
+ AD=16800000000P PS=460000U PD=380000U
* device instance $3173 r0 *1 30.14,60.71 nfet_01v8
M$3173 2300 162 42 167 nfet_01v8 L=150000U W=140000U AS=16800000000P
+ AD=21875000000P PS=380000U PD=460000U
* device instance $3174 r0 *1 30.66,60.71 nfet_01v8
M$3174 888 162 43 167 nfet_01v8 L=150000U W=140000U AS=16800000000P
+ AD=21875000000P PS=380000U PD=460000U
* device instance $3175 r0 *1 30.105,61.11 nfet_01v8
M$3175 167 2618 2300 167 nfet_01v8 L=150000U W=210000U AS=21875000000P
+ AD=40400000000P PS=460000U PD=560000U
* device instance $3176 r0 *1 30.695,61.11 nfet_01v8
M$3176 167 1402 888 167 nfet_01v8 L=150000U W=210000U AS=21875000000P
+ AD=40400000000P PS=460000U PD=560000U
* device instance $3177 r0 *1 30.105,61.5 nfet_01v8
M$3177 2618 2300 167 167 nfet_01v8 L=150000U W=210000U AS=40400000000P
+ AD=21875000000P PS=560000U PD=460000U
* device instance $3178 r0 *1 30.695,61.5 nfet_01v8
M$3178 1402 888 167 167 nfet_01v8 L=150000U W=210000U AS=40400000000P
+ AD=21875000000P PS=560000U PD=460000U
* device instance $3179 r0 *1 30.14,61.9 nfet_01v8
M$3179 41 162 2618 167 nfet_01v8 L=150000U W=140000U AS=21875000000P
+ AD=16800000000P PS=460000U PD=380000U
* device instance $3180 r0 *1 30.66,61.9 nfet_01v8
M$3180 44 162 1402 167 nfet_01v8 L=150000U W=140000U AS=21875000000P
+ AD=16800000000P PS=460000U PD=380000U
* device instance $3181 r0 *1 30.14,62.29 nfet_01v8
M$3181 3539 163 41 167 nfet_01v8 L=150000U W=140000U AS=16800000000P
+ AD=21875000000P PS=380000U PD=460000U
* device instance $3182 r0 *1 30.66,62.29 nfet_01v8
M$3182 4467 163 44 167 nfet_01v8 L=150000U W=140000U AS=16800000000P
+ AD=21875000000P PS=380000U PD=460000U
* device instance $3183 r0 *1 30.105,62.69 nfet_01v8
M$3183 167 2019 3539 167 nfet_01v8 L=150000U W=210000U AS=21875000000P
+ AD=40400000000P PS=460000U PD=560000U
* device instance $3184 r0 *1 30.695,62.69 nfet_01v8
M$3184 167 689 4467 167 nfet_01v8 L=150000U W=210000U AS=21875000000P
+ AD=40400000000P PS=460000U PD=560000U
* device instance $3185 r0 *1 30.105,63.08 nfet_01v8
M$3185 2019 3539 167 167 nfet_01v8 L=150000U W=210000U AS=40400000000P
+ AD=21875000000P PS=560000U PD=460000U
* device instance $3186 r0 *1 30.695,63.08 nfet_01v8
M$3186 689 4467 167 167 nfet_01v8 L=150000U W=210000U AS=40400000000P
+ AD=21875000000P PS=560000U PD=460000U
* device instance $3187 r0 *1 30.14,63.48 nfet_01v8
M$3187 42 163 2019 167 nfet_01v8 L=150000U W=140000U AS=21875000000P
+ AD=16800000000P PS=460000U PD=380000U
* device instance $3188 r0 *1 30.66,63.48 nfet_01v8
M$3188 43 163 689 167 nfet_01v8 L=150000U W=140000U AS=21875000000P
+ AD=16800000000P PS=460000U PD=380000U
* device instance $3189 r0 *1 30.14,63.87 nfet_01v8
M$3189 2079 164 42 167 nfet_01v8 L=150000U W=140000U AS=16800000000P
+ AD=21875000000P PS=380000U PD=460000U
* device instance $3190 r0 *1 30.66,63.87 nfet_01v8
M$3190 1301 164 43 167 nfet_01v8 L=150000U W=140000U AS=16800000000P
+ AD=21875000000P PS=380000U PD=460000U
* device instance $3191 r0 *1 30.105,64.27 nfet_01v8
M$3191 167 2159 2079 167 nfet_01v8 L=150000U W=210000U AS=21875000000P
+ AD=40400000000P PS=460000U PD=560000U
* device instance $3192 r0 *1 30.695,64.27 nfet_01v8
M$3192 167 1879 1301 167 nfet_01v8 L=150000U W=210000U AS=21875000000P
+ AD=40400000000P PS=460000U PD=560000U
* device instance $3193 r0 *1 30.105,64.66 nfet_01v8
M$3193 2159 2079 167 167 nfet_01v8 L=150000U W=210000U AS=40400000000P
+ AD=21875000000P PS=560000U PD=460000U
* device instance $3194 r0 *1 30.695,64.66 nfet_01v8
M$3194 1879 1301 167 167 nfet_01v8 L=150000U W=210000U AS=40400000000P
+ AD=21875000000P PS=560000U PD=460000U
* device instance $3195 r0 *1 30.14,65.06 nfet_01v8
M$3195 41 164 2159 167 nfet_01v8 L=150000U W=140000U AS=21875000000P
+ AD=16800000000P PS=460000U PD=380000U
* device instance $3196 r0 *1 30.66,65.06 nfet_01v8
M$3196 44 164 1879 167 nfet_01v8 L=150000U W=140000U AS=21875000000P
+ AD=16800000000P PS=460000U PD=380000U
* device instance $3197 r0 *1 30.14,65.45 nfet_01v8
M$3197 3538 165 41 167 nfet_01v8 L=150000U W=140000U AS=16800000000P
+ AD=21875000000P PS=380000U PD=460000U
* device instance $3198 r0 *1 30.66,65.45 nfet_01v8
M$3198 1307 165 44 167 nfet_01v8 L=150000U W=140000U AS=16800000000P
+ AD=21875000000P PS=380000U PD=460000U
* device instance $3199 r0 *1 30.105,65.85 nfet_01v8
M$3199 167 2568 3538 167 nfet_01v8 L=150000U W=210000U AS=21875000000P
+ AD=40400000000P PS=460000U PD=560000U
* device instance $3200 r0 *1 30.695,65.85 nfet_01v8
M$3200 167 1886 1307 167 nfet_01v8 L=150000U W=210000U AS=21875000000P
+ AD=40400000000P PS=460000U PD=560000U
* device instance $3201 r0 *1 30.105,66.24 nfet_01v8
M$3201 2568 3538 167 167 nfet_01v8 L=150000U W=210000U AS=40400000000P
+ AD=21875000000P PS=560000U PD=460000U
* device instance $3202 r0 *1 30.695,66.24 nfet_01v8
M$3202 1886 1307 167 167 nfet_01v8 L=150000U W=210000U AS=40400000000P
+ AD=21875000000P PS=560000U PD=460000U
* device instance $3203 r0 *1 30.14,66.64 nfet_01v8
M$3203 42 165 2568 167 nfet_01v8 L=150000U W=140000U AS=21875000000P
+ AD=16800000000P PS=460000U PD=380000U
* device instance $3204 r0 *1 30.66,66.64 nfet_01v8
M$3204 43 165 1886 167 nfet_01v8 L=150000U W=140000U AS=21875000000P
+ AD=16800000000P PS=460000U PD=380000U
* device instance $3205 r0 *1 84.64,37.01 nfet_01v8
M$3205 2332 150 122 167 nfet_01v8 L=150000U W=140000U AS=16800000000P
+ AD=21875000000P PS=380000U PD=460000U
* device instance $3206 r0 *1 85.16,37.01 nfet_01v8
M$3206 1195 150 123 167 nfet_01v8 L=150000U W=140000U AS=16800000000P
+ AD=21875000000P PS=380000U PD=460000U
* device instance $3207 r0 *1 84.605,37.41 nfet_01v8
M$3207 167 2679 2332 167 nfet_01v8 L=150000U W=210000U AS=21875000000P
+ AD=40400000000P PS=460000U PD=560000U
* device instance $3208 r0 *1 85.195,37.41 nfet_01v8
M$3208 167 1762 1195 167 nfet_01v8 L=150000U W=210000U AS=21875000000P
+ AD=40400000000P PS=460000U PD=560000U
* device instance $3209 r0 *1 84.605,37.8 nfet_01v8
M$3209 2679 2332 167 167 nfet_01v8 L=150000U W=210000U AS=40400000000P
+ AD=21875000000P PS=560000U PD=460000U
* device instance $3210 r0 *1 85.195,37.8 nfet_01v8
M$3210 1762 1195 167 167 nfet_01v8 L=150000U W=210000U AS=40400000000P
+ AD=21875000000P PS=560000U PD=460000U
* device instance $3211 r0 *1 84.64,38.2 nfet_01v8
M$3211 121 150 2679 167 nfet_01v8 L=150000U W=140000U AS=21875000000P
+ AD=16800000000P PS=460000U PD=380000U
* device instance $3212 r0 *1 85.16,38.2 nfet_01v8
M$3212 124 150 1762 167 nfet_01v8 L=150000U W=140000U AS=21875000000P
+ AD=16800000000P PS=460000U PD=380000U
* device instance $3213 r0 *1 84.64,38.59 nfet_01v8
M$3213 3514 151 121 167 nfet_01v8 L=150000U W=140000U AS=16800000000P
+ AD=21875000000P PS=380000U PD=460000U
* device instance $3214 r0 *1 85.16,38.59 nfet_01v8
M$3214 4525 151 124 167 nfet_01v8 L=150000U W=140000U AS=16800000000P
+ AD=21875000000P PS=380000U PD=460000U
* device instance $3215 r0 *1 84.605,38.99 nfet_01v8
M$3215 167 2234 3514 167 nfet_01v8 L=150000U W=210000U AS=21875000000P
+ AD=40400000000P PS=460000U PD=560000U
* device instance $3216 r0 *1 85.195,38.99 nfet_01v8
M$3216 167 684 4525 167 nfet_01v8 L=150000U W=210000U AS=21875000000P
+ AD=40400000000P PS=460000U PD=560000U
* device instance $3217 r0 *1 84.605,39.38 nfet_01v8
M$3217 2234 3514 167 167 nfet_01v8 L=150000U W=210000U AS=40400000000P
+ AD=21875000000P PS=560000U PD=460000U
* device instance $3218 r0 *1 85.195,39.38 nfet_01v8
M$3218 684 4525 167 167 nfet_01v8 L=150000U W=210000U AS=40400000000P
+ AD=21875000000P PS=560000U PD=460000U
* device instance $3219 r0 *1 84.64,39.78 nfet_01v8
M$3219 122 151 2234 167 nfet_01v8 L=150000U W=140000U AS=21875000000P
+ AD=16800000000P PS=460000U PD=380000U
* device instance $3220 r0 *1 85.16,39.78 nfet_01v8
M$3220 123 151 684 167 nfet_01v8 L=150000U W=140000U AS=21875000000P
+ AD=16800000000P PS=460000U PD=380000U
* device instance $3221 r0 *1 84.64,40.17 nfet_01v8
M$3221 2289 152 122 167 nfet_01v8 L=150000U W=140000U AS=16800000000P
+ AD=21875000000P PS=380000U PD=460000U
* device instance $3222 r0 *1 85.16,40.17 nfet_01v8
M$3222 1189 152 123 167 nfet_01v8 L=150000U W=140000U AS=16800000000P
+ AD=21875000000P PS=380000U PD=460000U
* device instance $3223 r0 *1 84.605,40.57 nfet_01v8
M$3223 167 2597 2289 167 nfet_01v8 L=150000U W=210000U AS=21875000000P
+ AD=40400000000P PS=460000U PD=560000U
* device instance $3224 r0 *1 85.195,40.57 nfet_01v8
M$3224 167 1755 1189 167 nfet_01v8 L=150000U W=210000U AS=21875000000P
+ AD=40400000000P PS=460000U PD=560000U
* device instance $3225 r0 *1 84.605,40.96 nfet_01v8
M$3225 2597 2289 167 167 nfet_01v8 L=150000U W=210000U AS=40400000000P
+ AD=21875000000P PS=560000U PD=460000U
* device instance $3226 r0 *1 85.195,40.96 nfet_01v8
M$3226 1755 1189 167 167 nfet_01v8 L=150000U W=210000U AS=40400000000P
+ AD=21875000000P PS=560000U PD=460000U
* device instance $3227 r0 *1 84.64,41.36 nfet_01v8
M$3227 121 152 2597 167 nfet_01v8 L=150000U W=140000U AS=21875000000P
+ AD=16800000000P PS=460000U PD=380000U
* device instance $3228 r0 *1 85.16,41.36 nfet_01v8
M$3228 124 152 1755 167 nfet_01v8 L=150000U W=140000U AS=21875000000P
+ AD=16800000000P PS=460000U PD=380000U
* device instance $3229 r0 *1 84.64,41.75 nfet_01v8
M$3229 2325 153 121 167 nfet_01v8 L=150000U W=140000U AS=16800000000P
+ AD=21875000000P PS=380000U PD=460000U
* device instance $3230 r0 *1 85.16,41.75 nfet_01v8
M$3230 1230 153 124 167 nfet_01v8 L=150000U W=140000U AS=16800000000P
+ AD=21875000000P PS=380000U PD=460000U
* device instance $3231 r0 *1 84.605,42.15 nfet_01v8
M$3231 167 2666 2325 167 nfet_01v8 L=150000U W=210000U AS=21875000000P
+ AD=40400000000P PS=460000U PD=560000U
* device instance $3232 r0 *1 85.195,42.15 nfet_01v8
M$3232 167 1802 1230 167 nfet_01v8 L=150000U W=210000U AS=21875000000P
+ AD=40400000000P PS=460000U PD=560000U
* device instance $3233 r0 *1 84.605,42.54 nfet_01v8
M$3233 2666 2325 167 167 nfet_01v8 L=150000U W=210000U AS=40400000000P
+ AD=21875000000P PS=560000U PD=460000U
* device instance $3234 r0 *1 85.195,42.54 nfet_01v8
M$3234 1802 1230 167 167 nfet_01v8 L=150000U W=210000U AS=40400000000P
+ AD=21875000000P PS=560000U PD=460000U
* device instance $3235 r0 *1 84.64,42.94 nfet_01v8
M$3235 122 153 2666 167 nfet_01v8 L=150000U W=140000U AS=21875000000P
+ AD=16800000000P PS=460000U PD=380000U
* device instance $3236 r0 *1 85.16,42.94 nfet_01v8
M$3236 123 153 1802 167 nfet_01v8 L=150000U W=140000U AS=21875000000P
+ AD=16800000000P PS=460000U PD=380000U
* device instance $3237 r0 *1 73.74,37.01 nfet_01v8
M$3237 3503 150 106 167 nfet_01v8 L=150000U W=140000U AS=16800000000P
+ AD=21875000000P PS=380000U PD=460000U
* device instance $3238 r0 *1 74.26,37.01 nfet_01v8
M$3238 1341 150 107 167 nfet_01v8 L=150000U W=140000U AS=16800000000P
+ AD=21875000000P PS=380000U PD=460000U
* device instance $3239 r0 *1 73.705,37.41 nfet_01v8
M$3239 167 2585 3503 167 nfet_01v8 L=150000U W=210000U AS=21875000000P
+ AD=40400000000P PS=460000U PD=560000U
* device instance $3240 r0 *1 74.295,37.41 nfet_01v8
M$3240 167 1927 1341 167 nfet_01v8 L=150000U W=210000U AS=21875000000P
+ AD=40400000000P PS=460000U PD=560000U
* device instance $3241 r0 *1 73.705,37.8 nfet_01v8
M$3241 2585 3503 167 167 nfet_01v8 L=150000U W=210000U AS=40400000000P
+ AD=21875000000P PS=560000U PD=460000U
* device instance $3242 r0 *1 74.295,37.8 nfet_01v8
M$3242 1927 1341 167 167 nfet_01v8 L=150000U W=210000U AS=40400000000P
+ AD=21875000000P PS=560000U PD=460000U
* device instance $3243 r0 *1 73.74,38.2 nfet_01v8
M$3243 105 150 2585 167 nfet_01v8 L=150000U W=140000U AS=21875000000P
+ AD=16800000000P PS=460000U PD=380000U
* device instance $3244 r0 *1 74.26,38.2 nfet_01v8
M$3244 108 150 1927 167 nfet_01v8 L=150000U W=140000U AS=21875000000P
+ AD=16800000000P PS=460000U PD=380000U
* device instance $3245 r0 *1 73.74,38.59 nfet_01v8
M$3245 3504 151 105 167 nfet_01v8 L=150000U W=140000U AS=16800000000P
+ AD=21875000000P PS=380000U PD=460000U
* device instance $3246 r0 *1 74.26,38.59 nfet_01v8
M$3246 4536 151 108 167 nfet_01v8 L=150000U W=140000U AS=16800000000P
+ AD=21875000000P PS=380000U PD=460000U
* device instance $3247 r0 *1 73.705,38.99 nfet_01v8
M$3247 167 2583 3504 167 nfet_01v8 L=150000U W=210000U AS=21875000000P
+ AD=40400000000P PS=460000U PD=560000U
* device instance $3248 r0 *1 74.295,38.99 nfet_01v8
M$3248 167 1933 4536 167 nfet_01v8 L=150000U W=210000U AS=21875000000P
+ AD=40400000000P PS=460000U PD=560000U
* device instance $3249 r0 *1 73.705,39.38 nfet_01v8
M$3249 2583 3504 167 167 nfet_01v8 L=150000U W=210000U AS=40400000000P
+ AD=21875000000P PS=560000U PD=460000U
* device instance $3250 r0 *1 74.295,39.38 nfet_01v8
M$3250 1933 4536 167 167 nfet_01v8 L=150000U W=210000U AS=40400000000P
+ AD=21875000000P PS=560000U PD=460000U
* device instance $3251 r0 *1 73.74,39.78 nfet_01v8
M$3251 106 151 2583 167 nfet_01v8 L=150000U W=140000U AS=21875000000P
+ AD=16800000000P PS=460000U PD=380000U
* device instance $3252 r0 *1 74.26,39.78 nfet_01v8
M$3252 107 151 1933 167 nfet_01v8 L=150000U W=140000U AS=21875000000P
+ AD=16800000000P PS=460000U PD=380000U
* device instance $3253 r0 *1 73.74,40.17 nfet_01v8
M$3253 2286 152 106 167 nfet_01v8 L=150000U W=140000U AS=16800000000P
+ AD=21875000000P PS=380000U PD=460000U
* device instance $3254 r0 *1 74.26,40.17 nfet_01v8
M$3254 633 152 107 167 nfet_01v8 L=150000U W=140000U AS=16800000000P
+ AD=21875000000P PS=380000U PD=460000U
* device instance $3255 r0 *1 73.705,40.57 nfet_01v8
M$3255 167 2593 2286 167 nfet_01v8 L=150000U W=210000U AS=21875000000P
+ AD=40400000000P PS=460000U PD=560000U
* device instance $3256 r0 *1 74.295,40.57 nfet_01v8
M$3256 167 784 633 167 nfet_01v8 L=150000U W=210000U AS=21875000000P
+ AD=40400000000P PS=460000U PD=560000U
* device instance $3257 r0 *1 73.705,40.96 nfet_01v8
M$3257 2593 2286 167 167 nfet_01v8 L=150000U W=210000U AS=40400000000P
+ AD=21875000000P PS=560000U PD=460000U
* device instance $3258 r0 *1 74.295,40.96 nfet_01v8
M$3258 784 633 167 167 nfet_01v8 L=150000U W=210000U AS=40400000000P
+ AD=21875000000P PS=560000U PD=460000U
* device instance $3259 r0 *1 73.74,41.36 nfet_01v8
M$3259 105 152 2593 167 nfet_01v8 L=150000U W=140000U AS=21875000000P
+ AD=16800000000P PS=460000U PD=380000U
* device instance $3260 r0 *1 74.26,41.36 nfet_01v8
M$3260 108 152 784 167 nfet_01v8 L=150000U W=140000U AS=21875000000P
+ AD=16800000000P PS=460000U PD=380000U
* device instance $3261 r0 *1 73.74,41.75 nfet_01v8
M$3261 3502 153 105 167 nfet_01v8 L=150000U W=140000U AS=16800000000P
+ AD=21875000000P PS=380000U PD=460000U
* device instance $3262 r0 *1 74.26,41.75 nfet_01v8
M$3262 1376 153 108 167 nfet_01v8 L=150000U W=140000U AS=16800000000P
+ AD=21875000000P PS=380000U PD=460000U
* device instance $3263 r0 *1 73.705,42.15 nfet_01v8
M$3263 167 2594 3502 167 nfet_01v8 L=150000U W=210000U AS=21875000000P
+ AD=40400000000P PS=460000U PD=560000U
* device instance $3264 r0 *1 74.295,42.15 nfet_01v8
M$3264 167 1969 1376 167 nfet_01v8 L=150000U W=210000U AS=21875000000P
+ AD=40400000000P PS=460000U PD=560000U
* device instance $3265 r0 *1 73.705,42.54 nfet_01v8
M$3265 2594 3502 167 167 nfet_01v8 L=150000U W=210000U AS=40400000000P
+ AD=21875000000P PS=560000U PD=460000U
* device instance $3266 r0 *1 74.295,42.54 nfet_01v8
M$3266 1969 1376 167 167 nfet_01v8 L=150000U W=210000U AS=40400000000P
+ AD=21875000000P PS=560000U PD=460000U
* device instance $3267 r0 *1 73.74,42.94 nfet_01v8
M$3267 106 153 2594 167 nfet_01v8 L=150000U W=140000U AS=21875000000P
+ AD=16800000000P PS=460000U PD=380000U
* device instance $3268 r0 *1 74.26,42.94 nfet_01v8
M$3268 107 153 1969 167 nfet_01v8 L=150000U W=140000U AS=21875000000P
+ AD=16800000000P PS=460000U PD=380000U
* device instance $3269 r0 *1 62.84,37.01 nfet_01v8
M$3269 3616 150 90 167 nfet_01v8 L=150000U W=140000U AS=16800000000P
+ AD=21875000000P PS=380000U PD=460000U
* device instance $3270 r0 *1 63.36,37.01 nfet_01v8
M$3270 941 150 91 167 nfet_01v8 L=150000U W=140000U AS=16800000000P
+ AD=21875000000P PS=380000U PD=460000U
* device instance $3271 r0 *1 62.805,37.41 nfet_01v8
M$3271 167 2598 3616 167 nfet_01v8 L=150000U W=210000U AS=21875000000P
+ AD=40400000000P PS=460000U PD=560000U
* device instance $3272 r0 *1 63.395,37.41 nfet_01v8
M$3272 167 1464 941 167 nfet_01v8 L=150000U W=210000U AS=21875000000P
+ AD=40400000000P PS=460000U PD=560000U
* device instance $3273 r0 *1 62.805,37.8 nfet_01v8
M$3273 2598 3616 167 167 nfet_01v8 L=150000U W=210000U AS=40400000000P
+ AD=21875000000P PS=560000U PD=460000U
* device instance $3274 r0 *1 63.395,37.8 nfet_01v8
M$3274 1464 941 167 167 nfet_01v8 L=150000U W=210000U AS=40400000000P
+ AD=21875000000P PS=560000U PD=460000U
* device instance $3275 r0 *1 62.84,38.2 nfet_01v8
M$3275 89 150 2598 167 nfet_01v8 L=150000U W=140000U AS=21875000000P
+ AD=16800000000P PS=460000U PD=380000U
* device instance $3276 r0 *1 63.36,38.2 nfet_01v8
M$3276 92 150 1464 167 nfet_01v8 L=150000U W=140000U AS=21875000000P
+ AD=16800000000P PS=460000U PD=380000U
* device instance $3277 r0 *1 62.84,38.59 nfet_01v8
M$3277 3615 151 89 167 nfet_01v8 L=150000U W=140000U AS=16800000000P
+ AD=21875000000P PS=380000U PD=460000U
* device instance $3278 r0 *1 63.36,38.59 nfet_01v8
M$3278 4304 151 92 167 nfet_01v8 L=150000U W=140000U AS=16800000000P
+ AD=21875000000P PS=380000U PD=460000U
* device instance $3279 r0 *1 62.805,38.99 nfet_01v8
M$3279 167 2599 3615 167 nfet_01v8 L=150000U W=210000U AS=21875000000P
+ AD=40400000000P PS=460000U PD=560000U
* device instance $3280 r0 *1 63.395,38.99 nfet_01v8
M$3280 167 1486 4304 167 nfet_01v8 L=150000U W=210000U AS=21875000000P
+ AD=40400000000P PS=460000U PD=560000U
* device instance $3281 r0 *1 62.805,39.38 nfet_01v8
M$3281 2599 3615 167 167 nfet_01v8 L=150000U W=210000U AS=40400000000P
+ AD=21875000000P PS=560000U PD=460000U
* device instance $3282 r0 *1 63.395,39.38 nfet_01v8
M$3282 1486 4304 167 167 nfet_01v8 L=150000U W=210000U AS=40400000000P
+ AD=21875000000P PS=560000U PD=460000U
* device instance $3283 r0 *1 62.84,39.78 nfet_01v8
M$3283 90 151 2599 167 nfet_01v8 L=150000U W=140000U AS=21875000000P
+ AD=16800000000P PS=460000U PD=380000U
* device instance $3284 r0 *1 63.36,39.78 nfet_01v8
M$3284 91 151 1486 167 nfet_01v8 L=150000U W=140000U AS=21875000000P
+ AD=16800000000P PS=460000U PD=380000U
* device instance $3285 r0 *1 62.84,40.17 nfet_01v8
M$3285 2291 152 90 167 nfet_01v8 L=150000U W=140000U AS=16800000000P
+ AD=21875000000P PS=380000U PD=460000U
* device instance $3286 r0 *1 63.36,40.17 nfet_01v8
M$3286 961 152 91 167 nfet_01v8 L=150000U W=140000U AS=16800000000P
+ AD=21875000000P PS=380000U PD=460000U
* device instance $3287 r0 *1 62.805,40.57 nfet_01v8
M$3287 167 2601 2291 167 nfet_01v8 L=150000U W=210000U AS=21875000000P
+ AD=40400000000P PS=460000U PD=560000U
* device instance $3288 r0 *1 63.395,40.57 nfet_01v8
M$3288 167 1490 961 167 nfet_01v8 L=150000U W=210000U AS=21875000000P
+ AD=40400000000P PS=460000U PD=560000U
* device instance $3289 r0 *1 62.805,40.96 nfet_01v8
M$3289 2601 2291 167 167 nfet_01v8 L=150000U W=210000U AS=40400000000P
+ AD=21875000000P PS=560000U PD=460000U
* device instance $3290 r0 *1 63.395,40.96 nfet_01v8
M$3290 1490 961 167 167 nfet_01v8 L=150000U W=210000U AS=40400000000P
+ AD=21875000000P PS=560000U PD=460000U
* device instance $3291 r0 *1 62.84,41.36 nfet_01v8
M$3291 89 152 2601 167 nfet_01v8 L=150000U W=140000U AS=21875000000P
+ AD=16800000000P PS=460000U PD=380000U
* device instance $3292 r0 *1 63.36,41.36 nfet_01v8
M$3292 92 152 1490 167 nfet_01v8 L=150000U W=140000U AS=21875000000P
+ AD=16800000000P PS=460000U PD=380000U
* device instance $3293 r0 *1 62.84,41.75 nfet_01v8
M$3293 2292 153 89 167 nfet_01v8 L=150000U W=140000U AS=16800000000P
+ AD=21875000000P PS=380000U PD=460000U
* device instance $3294 r0 *1 63.36,41.75 nfet_01v8
M$3294 960 153 92 167 nfet_01v8 L=150000U W=140000U AS=16800000000P
+ AD=21875000000P PS=380000U PD=460000U
* device instance $3295 r0 *1 62.805,42.15 nfet_01v8
M$3295 167 2603 2292 167 nfet_01v8 L=150000U W=210000U AS=21875000000P
+ AD=40400000000P PS=460000U PD=560000U
* device instance $3296 r0 *1 63.395,42.15 nfet_01v8
M$3296 167 1488 960 167 nfet_01v8 L=150000U W=210000U AS=21875000000P
+ AD=40400000000P PS=460000U PD=560000U
* device instance $3297 r0 *1 62.805,42.54 nfet_01v8
M$3297 2603 2292 167 167 nfet_01v8 L=150000U W=210000U AS=40400000000P
+ AD=21875000000P PS=560000U PD=460000U
* device instance $3298 r0 *1 63.395,42.54 nfet_01v8
M$3298 1488 960 167 167 nfet_01v8 L=150000U W=210000U AS=40400000000P
+ AD=21875000000P PS=560000U PD=460000U
* device instance $3299 r0 *1 62.84,42.94 nfet_01v8
M$3299 90 153 2603 167 nfet_01v8 L=150000U W=140000U AS=21875000000P
+ AD=16800000000P PS=460000U PD=380000U
* device instance $3300 r0 *1 63.36,42.94 nfet_01v8
M$3300 91 153 1488 167 nfet_01v8 L=150000U W=140000U AS=21875000000P
+ AD=16800000000P PS=460000U PD=380000U
* device instance $3301 r0 *1 51.94,37.01 nfet_01v8
M$3301 3608 150 74 167 nfet_01v8 L=150000U W=140000U AS=16800000000P
+ AD=21875000000P PS=380000U PD=460000U
* device instance $3302 r0 *1 52.46,37.01 nfet_01v8
M$3302 968 150 75 167 nfet_01v8 L=150000U W=140000U AS=16800000000P
+ AD=21875000000P PS=380000U PD=460000U
* device instance $3303 r0 *1 51.905,37.41 nfet_01v8
M$3303 167 2680 3608 167 nfet_01v8 L=150000U W=210000U AS=21875000000P
+ AD=40400000000P PS=460000U PD=560000U
* device instance $3304 r0 *1 52.495,37.41 nfet_01v8
M$3304 167 1498 968 167 nfet_01v8 L=150000U W=210000U AS=21875000000P
+ AD=40400000000P PS=460000U PD=560000U
* device instance $3305 r0 *1 51.905,37.8 nfet_01v8
M$3305 2680 3608 167 167 nfet_01v8 L=150000U W=210000U AS=40400000000P
+ AD=21875000000P PS=560000U PD=460000U
* device instance $3306 r0 *1 52.495,37.8 nfet_01v8
M$3306 1498 968 167 167 nfet_01v8 L=150000U W=210000U AS=40400000000P
+ AD=21875000000P PS=560000U PD=460000U
* device instance $3307 r0 *1 51.94,38.2 nfet_01v8
M$3307 73 150 2680 167 nfet_01v8 L=150000U W=140000U AS=21875000000P
+ AD=16800000000P PS=460000U PD=380000U
* device instance $3308 r0 *1 52.46,38.2 nfet_01v8
M$3308 76 150 1498 167 nfet_01v8 L=150000U W=140000U AS=21875000000P
+ AD=16800000000P PS=460000U PD=380000U
* device instance $3309 r0 *1 51.94,38.59 nfet_01v8
M$3309 3607 151 73 167 nfet_01v8 L=150000U W=140000U AS=16800000000P
+ AD=21875000000P PS=380000U PD=460000U
* device instance $3310 r0 *1 52.46,38.59 nfet_01v8
M$3310 4293 151 76 167 nfet_01v8 L=150000U W=140000U AS=16800000000P
+ AD=21875000000P PS=380000U PD=460000U
* device instance $3311 r0 *1 51.905,38.99 nfet_01v8
M$3311 167 2041 3607 167 nfet_01v8 L=150000U W=210000U AS=21875000000P
+ AD=40400000000P PS=460000U PD=560000U
* device instance $3312 r0 *1 52.495,38.99 nfet_01v8
M$3312 167 1495 4293 167 nfet_01v8 L=150000U W=210000U AS=21875000000P
+ AD=40400000000P PS=460000U PD=560000U
* device instance $3313 r0 *1 51.905,39.38 nfet_01v8
M$3313 2041 3607 167 167 nfet_01v8 L=150000U W=210000U AS=40400000000P
+ AD=21875000000P PS=560000U PD=460000U
* device instance $3314 r0 *1 52.495,39.38 nfet_01v8
M$3314 1495 4293 167 167 nfet_01v8 L=150000U W=210000U AS=40400000000P
+ AD=21875000000P PS=560000U PD=460000U
* device instance $3315 r0 *1 51.94,39.78 nfet_01v8
M$3315 74 151 2041 167 nfet_01v8 L=150000U W=140000U AS=21875000000P
+ AD=16800000000P PS=460000U PD=380000U
* device instance $3316 r0 *1 52.46,39.78 nfet_01v8
M$3316 75 151 1495 167 nfet_01v8 L=150000U W=140000U AS=21875000000P
+ AD=16800000000P PS=460000U PD=380000U
* device instance $3317 r0 *1 51.94,40.17 nfet_01v8
M$3317 3602 152 74 167 nfet_01v8 L=150000U W=140000U AS=16800000000P
+ AD=21875000000P PS=380000U PD=460000U
* device instance $3318 r0 *1 52.46,40.17 nfet_01v8
M$3318 639 152 75 167 nfet_01v8 L=150000U W=140000U AS=16800000000P
+ AD=21875000000P PS=380000U PD=460000U
* device instance $3319 r0 *1 51.905,40.57 nfet_01v8
M$3319 167 2168 3602 167 nfet_01v8 L=150000U W=210000U AS=21875000000P
+ AD=40400000000P PS=460000U PD=560000U
* device instance $3320 r0 *1 52.495,40.57 nfet_01v8
M$3320 167 797 639 167 nfet_01v8 L=150000U W=210000U AS=21875000000P
+ AD=40400000000P PS=460000U PD=560000U
* device instance $3321 r0 *1 51.905,40.96 nfet_01v8
M$3321 2168 3602 167 167 nfet_01v8 L=150000U W=210000U AS=40400000000P
+ AD=21875000000P PS=560000U PD=460000U
* device instance $3322 r0 *1 52.495,40.96 nfet_01v8
M$3322 797 639 167 167 nfet_01v8 L=150000U W=210000U AS=40400000000P
+ AD=21875000000P PS=560000U PD=460000U
* device instance $3323 r0 *1 51.94,41.36 nfet_01v8
M$3323 73 152 2168 167 nfet_01v8 L=150000U W=140000U AS=21875000000P
+ AD=16800000000P PS=460000U PD=380000U
* device instance $3324 r0 *1 52.46,41.36 nfet_01v8
M$3324 76 152 797 167 nfet_01v8 L=150000U W=140000U AS=21875000000P
+ AD=16800000000P PS=460000U PD=380000U
* device instance $3325 r0 *1 51.94,41.75 nfet_01v8
M$3325 2322 153 73 167 nfet_01v8 L=150000U W=140000U AS=16800000000P
+ AD=21875000000P PS=380000U PD=460000U
* device instance $3326 r0 *1 52.46,41.75 nfet_01v8
M$3326 994 153 76 167 nfet_01v8 L=150000U W=140000U AS=16800000000P
+ AD=21875000000P PS=380000U PD=460000U
* device instance $3327 r0 *1 51.905,42.15 nfet_01v8
M$3327 167 2661 2322 167 nfet_01v8 L=150000U W=210000U AS=21875000000P
+ AD=40400000000P PS=460000U PD=560000U
* device instance $3328 r0 *1 52.495,42.15 nfet_01v8
M$3328 167 1529 994 167 nfet_01v8 L=150000U W=210000U AS=21875000000P
+ AD=40400000000P PS=460000U PD=560000U
* device instance $3329 r0 *1 51.905,42.54 nfet_01v8
M$3329 2661 2322 167 167 nfet_01v8 L=150000U W=210000U AS=40400000000P
+ AD=21875000000P PS=560000U PD=460000U
* device instance $3330 r0 *1 52.495,42.54 nfet_01v8
M$3330 1529 994 167 167 nfet_01v8 L=150000U W=210000U AS=40400000000P
+ AD=21875000000P PS=560000U PD=460000U
* device instance $3331 r0 *1 51.94,42.94 nfet_01v8
M$3331 74 153 2661 167 nfet_01v8 L=150000U W=140000U AS=21875000000P
+ AD=16800000000P PS=460000U PD=380000U
* device instance $3332 r0 *1 52.46,42.94 nfet_01v8
M$3332 75 153 1529 167 nfet_01v8 L=150000U W=140000U AS=21875000000P
+ AD=16800000000P PS=460000U PD=380000U
* device instance $3333 r0 *1 73.74,60.71 nfet_01v8
M$3333 2413 162 106 167 nfet_01v8 L=150000U W=140000U AS=16800000000P
+ AD=21875000000P PS=380000U PD=460000U
* device instance $3334 r0 *1 74.26,60.71 nfet_01v8
M$3334 1357 162 107 167 nfet_01v8 L=150000U W=140000U AS=16800000000P
+ AD=21875000000P PS=380000U PD=460000U
* device instance $3335 r0 *1 73.705,61.11 nfet_01v8
M$3335 167 2837 2413 167 nfet_01v8 L=150000U W=210000U AS=21875000000P
+ AD=40400000000P PS=460000U PD=560000U
* device instance $3336 r0 *1 74.295,61.11 nfet_01v8
M$3336 167 1946 1357 167 nfet_01v8 L=150000U W=210000U AS=21875000000P
+ AD=40400000000P PS=460000U PD=560000U
* device instance $3337 r0 *1 73.705,61.5 nfet_01v8
M$3337 2837 2413 167 167 nfet_01v8 L=150000U W=210000U AS=40400000000P
+ AD=21875000000P PS=560000U PD=460000U
* device instance $3338 r0 *1 74.295,61.5 nfet_01v8
M$3338 1946 1357 167 167 nfet_01v8 L=150000U W=210000U AS=40400000000P
+ AD=21875000000P PS=560000U PD=460000U
* device instance $3339 r0 *1 73.74,61.9 nfet_01v8
M$3339 105 162 2837 167 nfet_01v8 L=150000U W=140000U AS=21875000000P
+ AD=16800000000P PS=460000U PD=380000U
* device instance $3340 r0 *1 74.26,61.9 nfet_01v8
M$3340 108 162 1946 167 nfet_01v8 L=150000U W=140000U AS=21875000000P
+ AD=16800000000P PS=460000U PD=380000U
* device instance $3341 r0 *1 73.74,62.29 nfet_01v8
M$3341 3173 163 105 167 nfet_01v8 L=150000U W=140000U AS=16800000000P
+ AD=21875000000P PS=380000U PD=460000U
* device instance $3342 r0 *1 74.26,62.29 nfet_01v8
M$3342 4510 163 108 167 nfet_01v8 L=150000U W=140000U AS=16800000000P
+ AD=21875000000P PS=380000U PD=460000U
* device instance $3343 r0 *1 73.705,62.69 nfet_01v8
M$3343 167 2066 3173 167 nfet_01v8 L=150000U W=210000U AS=21875000000P
+ AD=40400000000P PS=460000U PD=560000U
* device instance $3344 r0 *1 74.295,62.69 nfet_01v8
M$3344 167 1558 4510 167 nfet_01v8 L=150000U W=210000U AS=21875000000P
+ AD=40400000000P PS=460000U PD=560000U
* device instance $3345 r0 *1 73.705,63.08 nfet_01v8
M$3345 2066 3173 167 167 nfet_01v8 L=150000U W=210000U AS=40400000000P
+ AD=21875000000P PS=560000U PD=460000U
* device instance $3346 r0 *1 74.295,63.08 nfet_01v8
M$3346 1558 4510 167 167 nfet_01v8 L=150000U W=210000U AS=40400000000P
+ AD=21875000000P PS=560000U PD=460000U
* device instance $3347 r0 *1 73.74,63.48 nfet_01v8
M$3347 106 163 2066 167 nfet_01v8 L=150000U W=140000U AS=21875000000P
+ AD=16800000000P PS=460000U PD=380000U
* device instance $3348 r0 *1 74.26,63.48 nfet_01v8
M$3348 107 163 1558 167 nfet_01v8 L=150000U W=140000U AS=21875000000P
+ AD=16800000000P PS=460000U PD=380000U
* device instance $3349 r0 *1 73.74,63.87 nfet_01v8
M$3349 2121 164 106 167 nfet_01v8 L=150000U W=140000U AS=16800000000P
+ AD=21875000000P PS=380000U PD=460000U
* device instance $3350 r0 *1 74.26,63.87 nfet_01v8
M$3350 626 164 107 167 nfet_01v8 L=150000U W=140000U AS=16800000000P
+ AD=21875000000P PS=380000U PD=460000U
* device instance $3351 r0 *1 73.705,64.27 nfet_01v8
M$3351 167 2252 2121 167 nfet_01v8 L=150000U W=210000U AS=21875000000P
+ AD=40400000000P PS=460000U PD=560000U
* device instance $3352 r0 *1 74.295,64.27 nfet_01v8
M$3352 167 772 626 167 nfet_01v8 L=150000U W=210000U AS=21875000000P
+ AD=40400000000P PS=460000U PD=560000U
* device instance $3353 r0 *1 73.705,64.66 nfet_01v8
M$3353 2252 2121 167 167 nfet_01v8 L=150000U W=210000U AS=40400000000P
+ AD=21875000000P PS=560000U PD=460000U
* device instance $3354 r0 *1 74.295,64.66 nfet_01v8
M$3354 772 626 167 167 nfet_01v8 L=150000U W=210000U AS=40400000000P
+ AD=21875000000P PS=560000U PD=460000U
* device instance $3355 r0 *1 73.74,65.06 nfet_01v8
M$3355 105 164 2252 167 nfet_01v8 L=150000U W=140000U AS=21875000000P
+ AD=16800000000P PS=460000U PD=380000U
* device instance $3356 r0 *1 74.26,65.06 nfet_01v8
M$3356 108 164 772 167 nfet_01v8 L=150000U W=140000U AS=21875000000P
+ AD=16800000000P PS=460000U PD=380000U
* device instance $3357 r0 *1 73.74,65.45 nfet_01v8
M$3357 3143 165 105 167 nfet_01v8 L=150000U W=140000U AS=16800000000P
+ AD=21875000000P PS=380000U PD=460000U
* device instance $3358 r0 *1 74.26,65.45 nfet_01v8
M$3358 1027 165 108 167 nfet_01v8 L=150000U W=140000U AS=16800000000P
+ AD=21875000000P PS=380000U PD=460000U
* device instance $3359 r0 *1 73.705,65.85 nfet_01v8
M$3359 167 3028 3143 167 nfet_01v8 L=150000U W=210000U AS=21875000000P
+ AD=40400000000P PS=460000U PD=560000U
* device instance $3360 r0 *1 74.295,65.85 nfet_01v8
M$3360 167 1565 1027 167 nfet_01v8 L=150000U W=210000U AS=21875000000P
+ AD=40400000000P PS=460000U PD=560000U
* device instance $3361 r0 *1 73.705,66.24 nfet_01v8
M$3361 3028 3143 167 167 nfet_01v8 L=150000U W=210000U AS=40400000000P
+ AD=21875000000P PS=560000U PD=460000U
* device instance $3362 r0 *1 74.295,66.24 nfet_01v8
M$3362 1565 1027 167 167 nfet_01v8 L=150000U W=210000U AS=40400000000P
+ AD=21875000000P PS=560000U PD=460000U
* device instance $3363 r0 *1 73.74,66.64 nfet_01v8
M$3363 106 165 3028 167 nfet_01v8 L=150000U W=140000U AS=21875000000P
+ AD=16800000000P PS=460000U PD=380000U
* device instance $3364 r0 *1 74.26,66.64 nfet_01v8
M$3364 107 165 1565 167 nfet_01v8 L=150000U W=140000U AS=21875000000P
+ AD=16800000000P PS=460000U PD=380000U
* device instance $3365 r0 *1 41.04,37.01 nfet_01v8
M$3365 2335 150 58 167 nfet_01v8 L=150000U W=140000U AS=16800000000P
+ AD=21875000000P PS=380000U PD=460000U
* device instance $3366 r0 *1 41.56,37.01 nfet_01v8
M$3366 1234 150 59 167 nfet_01v8 L=150000U W=140000U AS=16800000000P
+ AD=21875000000P PS=380000U PD=460000U
* device instance $3367 r0 *1 41.005,37.41 nfet_01v8
M$3367 167 2688 2335 167 nfet_01v8 L=150000U W=210000U AS=21875000000P
+ AD=40400000000P PS=460000U PD=560000U
* device instance $3368 r0 *1 41.595,37.41 nfet_01v8
M$3368 167 1806 1234 167 nfet_01v8 L=150000U W=210000U AS=21875000000P
+ AD=40400000000P PS=460000U PD=560000U
* device instance $3369 r0 *1 41.005,37.8 nfet_01v8
M$3369 2688 2335 167 167 nfet_01v8 L=150000U W=210000U AS=40400000000P
+ AD=21875000000P PS=560000U PD=460000U
* device instance $3370 r0 *1 41.595,37.8 nfet_01v8
M$3370 1806 1234 167 167 nfet_01v8 L=150000U W=210000U AS=40400000000P
+ AD=21875000000P PS=560000U PD=460000U
* device instance $3371 r0 *1 41.04,38.2 nfet_01v8
M$3371 57 150 2688 167 nfet_01v8 L=150000U W=140000U AS=21875000000P
+ AD=16800000000P PS=460000U PD=380000U
* device instance $3372 r0 *1 41.56,38.2 nfet_01v8
M$3372 60 150 1806 167 nfet_01v8 L=150000U W=140000U AS=21875000000P
+ AD=16800000000P PS=460000U PD=380000U
* device instance $3373 r0 *1 41.04,38.59 nfet_01v8
M$3373 3675 151 57 167 nfet_01v8 L=150000U W=140000U AS=16800000000P
+ AD=21875000000P PS=380000U PD=460000U
* device instance $3374 r0 *1 41.56,38.59 nfet_01v8
M$3374 4425 151 60 167 nfet_01v8 L=150000U W=140000U AS=16800000000P
+ AD=21875000000P PS=380000U PD=460000U
* device instance $3375 r0 *1 41.005,38.99 nfet_01v8
M$3375 167 1986 3675 167 nfet_01v8 L=150000U W=210000U AS=21875000000P
+ AD=40400000000P PS=460000U PD=560000U
* device instance $3376 r0 *1 41.595,38.99 nfet_01v8
M$3376 167 1832 4425 167 nfet_01v8 L=150000U W=210000U AS=21875000000P
+ AD=40400000000P PS=460000U PD=560000U
* device instance $3377 r0 *1 41.005,39.38 nfet_01v8
M$3377 1986 3675 167 167 nfet_01v8 L=150000U W=210000U AS=40400000000P
+ AD=21875000000P PS=560000U PD=460000U
* device instance $3378 r0 *1 41.595,39.38 nfet_01v8
M$3378 1832 4425 167 167 nfet_01v8 L=150000U W=210000U AS=40400000000P
+ AD=21875000000P PS=560000U PD=460000U
* device instance $3379 r0 *1 41.04,39.78 nfet_01v8
M$3379 58 151 1986 167 nfet_01v8 L=150000U W=140000U AS=21875000000P
+ AD=16800000000P PS=460000U PD=380000U
* device instance $3380 r0 *1 41.56,39.78 nfet_01v8
M$3380 59 151 1832 167 nfet_01v8 L=150000U W=140000U AS=21875000000P
+ AD=16800000000P PS=460000U PD=380000U
* device instance $3381 r0 *1 41.04,40.17 nfet_01v8
M$3381 2113 152 58 167 nfet_01v8 L=150000U W=140000U AS=16800000000P
+ AD=21875000000P PS=380000U PD=460000U
* device instance $3382 r0 *1 41.56,40.17 nfet_01v8
M$3382 599 152 59 167 nfet_01v8 L=150000U W=140000U AS=16800000000P
+ AD=21875000000P PS=380000U PD=460000U
* device instance $3383 r0 *1 41.005,40.57 nfet_01v8
M$3383 167 2236 2113 167 nfet_01v8 L=150000U W=210000U AS=21875000000P
+ AD=40400000000P PS=460000U PD=560000U
* device instance $3384 r0 *1 41.595,40.57 nfet_01v8
M$3384 167 717 599 167 nfet_01v8 L=150000U W=210000U AS=21875000000P
+ AD=40400000000P PS=460000U PD=560000U
* device instance $3385 r0 *1 41.005,40.96 nfet_01v8
M$3385 2236 2113 167 167 nfet_01v8 L=150000U W=210000U AS=40400000000P
+ AD=21875000000P PS=560000U PD=460000U
* device instance $3386 r0 *1 41.595,40.96 nfet_01v8
M$3386 717 599 167 167 nfet_01v8 L=150000U W=210000U AS=40400000000P
+ AD=21875000000P PS=560000U PD=460000U
* device instance $3387 r0 *1 41.04,41.36 nfet_01v8
M$3387 57 152 2236 167 nfet_01v8 L=150000U W=140000U AS=21875000000P
+ AD=16800000000P PS=460000U PD=380000U
* device instance $3388 r0 *1 41.56,41.36 nfet_01v8
M$3388 60 152 717 167 nfet_01v8 L=150000U W=140000U AS=21875000000P
+ AD=16800000000P PS=460000U PD=380000U
* device instance $3389 r0 *1 41.04,41.75 nfet_01v8
M$3389 3672 153 57 167 nfet_01v8 L=150000U W=140000U AS=16800000000P
+ AD=21875000000P PS=380000U PD=460000U
* device instance $3390 r0 *1 41.56,41.75 nfet_01v8
M$3390 1232 153 60 167 nfet_01v8 L=150000U W=140000U AS=16800000000P
+ AD=21875000000P PS=380000U PD=460000U
* device instance $3391 r0 *1 41.005,42.15 nfet_01v8
M$3391 167 2681 3672 167 nfet_01v8 L=150000U W=210000U AS=21875000000P
+ AD=40400000000P PS=460000U PD=560000U
* device instance $3392 r0 *1 41.595,42.15 nfet_01v8
M$3392 167 1804 1232 167 nfet_01v8 L=150000U W=210000U AS=21875000000P
+ AD=40400000000P PS=460000U PD=560000U
* device instance $3393 r0 *1 41.005,42.54 nfet_01v8
M$3393 2681 3672 167 167 nfet_01v8 L=150000U W=210000U AS=40400000000P
+ AD=21875000000P PS=560000U PD=460000U
* device instance $3394 r0 *1 41.595,42.54 nfet_01v8
M$3394 1804 1232 167 167 nfet_01v8 L=150000U W=210000U AS=40400000000P
+ AD=21875000000P PS=560000U PD=460000U
* device instance $3395 r0 *1 41.04,42.94 nfet_01v8
M$3395 58 153 2681 167 nfet_01v8 L=150000U W=140000U AS=21875000000P
+ AD=16800000000P PS=460000U PD=380000U
* device instance $3396 r0 *1 41.56,42.94 nfet_01v8
M$3396 59 153 1804 167 nfet_01v8 L=150000U W=140000U AS=21875000000P
+ AD=16800000000P PS=460000U PD=380000U
* device instance $3397 r0 *1 30.14,37.01 nfet_01v8
M$3397 2379 150 42 167 nfet_01v8 L=150000U W=140000U AS=16800000000P
+ AD=21875000000P PS=380000U PD=460000U
* device instance $3398 r0 *1 30.66,37.01 nfet_01v8
M$3398 1249 150 43 167 nfet_01v8 L=150000U W=140000U AS=16800000000P
+ AD=21875000000P PS=380000U PD=460000U
* device instance $3399 r0 *1 30.105,37.41 nfet_01v8
M$3399 167 2781 2379 167 nfet_01v8 L=150000U W=210000U AS=21875000000P
+ AD=40400000000P PS=460000U PD=560000U
* device instance $3400 r0 *1 30.695,37.41 nfet_01v8
M$3400 167 1821 1249 167 nfet_01v8 L=150000U W=210000U AS=21875000000P
+ AD=40400000000P PS=460000U PD=560000U
* device instance $3401 r0 *1 30.105,37.8 nfet_01v8
M$3401 2781 2379 167 167 nfet_01v8 L=150000U W=210000U AS=40400000000P
+ AD=21875000000P PS=560000U PD=460000U
* device instance $3402 r0 *1 30.695,37.8 nfet_01v8
M$3402 1821 1249 167 167 nfet_01v8 L=150000U W=210000U AS=40400000000P
+ AD=21875000000P PS=560000U PD=460000U
* device instance $3403 r0 *1 30.14,38.2 nfet_01v8
M$3403 41 150 2781 167 nfet_01v8 L=150000U W=140000U AS=21875000000P
+ AD=16800000000P PS=460000U PD=380000U
* device instance $3404 r0 *1 30.66,38.2 nfet_01v8
M$3404 44 150 1821 167 nfet_01v8 L=150000U W=140000U AS=21875000000P
+ AD=16800000000P PS=460000U PD=380000U
* device instance $3405 r0 *1 30.14,38.59 nfet_01v8
M$3405 3627 151 41 167 nfet_01v8 L=150000U W=140000U AS=16800000000P
+ AD=21875000000P PS=380000U PD=460000U
* device instance $3406 r0 *1 30.66,38.59 nfet_01v8
M$3406 4421 151 44 167 nfet_01v8 L=150000U W=140000U AS=16800000000P
+ AD=21875000000P PS=380000U PD=460000U
* device instance $3407 r0 *1 30.105,38.99 nfet_01v8
M$3407 167 2048 3627 167 nfet_01v8 L=150000U W=210000U AS=21875000000P
+ AD=40400000000P PS=460000U PD=560000U
* device instance $3408 r0 *1 30.695,38.99 nfet_01v8
M$3408 167 1822 4421 167 nfet_01v8 L=150000U W=210000U AS=21875000000P
+ AD=40400000000P PS=460000U PD=560000U
* device instance $3409 r0 *1 30.105,39.38 nfet_01v8
M$3409 2048 3627 167 167 nfet_01v8 L=150000U W=210000U AS=40400000000P
+ AD=21875000000P PS=560000U PD=460000U
* device instance $3410 r0 *1 30.695,39.38 nfet_01v8
M$3410 1822 4421 167 167 nfet_01v8 L=150000U W=210000U AS=40400000000P
+ AD=21875000000P PS=560000U PD=460000U
* device instance $3411 r0 *1 30.14,39.78 nfet_01v8
M$3411 42 151 2048 167 nfet_01v8 L=150000U W=140000U AS=21875000000P
+ AD=16800000000P PS=460000U PD=380000U
* device instance $3412 r0 *1 30.66,39.78 nfet_01v8
M$3412 43 151 1822 167 nfet_01v8 L=150000U W=140000U AS=21875000000P
+ AD=16800000000P PS=460000U PD=380000U
* device instance $3413 r0 *1 30.14,40.17 nfet_01v8
M$3413 2120 152 42 167 nfet_01v8 L=150000U W=140000U AS=16800000000P
+ AD=21875000000P PS=380000U PD=460000U
* device instance $3414 r0 *1 30.66,40.17 nfet_01v8
M$3414 1250 152 43 167 nfet_01v8 L=150000U W=140000U AS=16800000000P
+ AD=21875000000P PS=380000U PD=460000U
* device instance $3415 r0 *1 30.105,40.57 nfet_01v8
M$3415 167 2249 2120 167 nfet_01v8 L=150000U W=210000U AS=21875000000P
+ AD=40400000000P PS=460000U PD=560000U
* device instance $3416 r0 *1 30.695,40.57 nfet_01v8
M$3416 167 1823 1250 167 nfet_01v8 L=150000U W=210000U AS=21875000000P
+ AD=40400000000P PS=460000U PD=560000U
* device instance $3417 r0 *1 30.105,40.96 nfet_01v8
M$3417 2249 2120 167 167 nfet_01v8 L=150000U W=210000U AS=40400000000P
+ AD=21875000000P PS=560000U PD=460000U
* device instance $3418 r0 *1 30.695,40.96 nfet_01v8
M$3418 1823 1250 167 167 nfet_01v8 L=150000U W=210000U AS=40400000000P
+ AD=21875000000P PS=560000U PD=460000U
* device instance $3419 r0 *1 30.14,41.36 nfet_01v8
M$3419 41 152 2249 167 nfet_01v8 L=150000U W=140000U AS=21875000000P
+ AD=16800000000P PS=460000U PD=380000U
* device instance $3420 r0 *1 30.66,41.36 nfet_01v8
M$3420 44 152 1823 167 nfet_01v8 L=150000U W=140000U AS=21875000000P
+ AD=16800000000P PS=460000U PD=380000U
* device instance $3421 r0 *1 30.14,41.75 nfet_01v8
M$3421 2382 153 41 167 nfet_01v8 L=150000U W=140000U AS=16800000000P
+ AD=21875000000P PS=380000U PD=460000U
* device instance $3422 r0 *1 30.66,41.75 nfet_01v8
M$3422 1251 153 44 167 nfet_01v8 L=150000U W=140000U AS=16800000000P
+ AD=21875000000P PS=380000U PD=460000U
* device instance $3423 r0 *1 30.105,42.15 nfet_01v8
M$3423 167 2784 2382 167 nfet_01v8 L=150000U W=210000U AS=21875000000P
+ AD=40400000000P PS=460000U PD=560000U
* device instance $3424 r0 *1 30.695,42.15 nfet_01v8
M$3424 167 1824 1251 167 nfet_01v8 L=150000U W=210000U AS=21875000000P
+ AD=40400000000P PS=460000U PD=560000U
* device instance $3425 r0 *1 30.105,42.54 nfet_01v8
M$3425 2784 2382 167 167 nfet_01v8 L=150000U W=210000U AS=40400000000P
+ AD=21875000000P PS=560000U PD=460000U
* device instance $3426 r0 *1 30.695,42.54 nfet_01v8
M$3426 1824 1251 167 167 nfet_01v8 L=150000U W=210000U AS=40400000000P
+ AD=21875000000P PS=560000U PD=460000U
* device instance $3427 r0 *1 30.14,42.94 nfet_01v8
M$3427 42 153 2784 167 nfet_01v8 L=150000U W=140000U AS=21875000000P
+ AD=16800000000P PS=460000U PD=380000U
* device instance $3428 r0 *1 30.66,42.94 nfet_01v8
M$3428 43 153 1824 167 nfet_01v8 L=150000U W=140000U AS=21875000000P
+ AD=16800000000P PS=460000U PD=380000U
* device instance $3429 r0 *1 19.24,37.01 nfet_01v8
M$3429 2525 150 26 167 nfet_01v8 L=150000U W=140000U AS=16800000000P
+ AD=21875000000P PS=380000U PD=460000U
* device instance $3430 r0 *1 19.76,37.01 nfet_01v8
M$3430 1216 150 27 167 nfet_01v8 L=150000U W=140000U AS=16800000000P
+ AD=21875000000P PS=380000U PD=460000U
* device instance $3431 r0 *1 19.205,37.41 nfet_01v8
M$3431 167 3084 2525 167 nfet_01v8 L=150000U W=210000U AS=21875000000P
+ AD=40400000000P PS=460000U PD=560000U
* device instance $3432 r0 *1 19.795,37.41 nfet_01v8
M$3432 167 1787 1216 167 nfet_01v8 L=150000U W=210000U AS=21875000000P
+ AD=40400000000P PS=460000U PD=560000U
* device instance $3433 r0 *1 19.205,37.8 nfet_01v8
M$3433 3084 2525 167 167 nfet_01v8 L=150000U W=210000U AS=40400000000P
+ AD=21875000000P PS=560000U PD=460000U
* device instance $3434 r0 *1 19.795,37.8 nfet_01v8
M$3434 1787 1216 167 167 nfet_01v8 L=150000U W=210000U AS=40400000000P
+ AD=21875000000P PS=560000U PD=460000U
* device instance $3435 r0 *1 19.24,38.2 nfet_01v8
M$3435 25 150 3084 167 nfet_01v8 L=150000U W=140000U AS=21875000000P
+ AD=16800000000P PS=460000U PD=380000U
* device instance $3436 r0 *1 19.76,38.2 nfet_01v8
M$3436 28 150 1787 167 nfet_01v8 L=150000U W=140000U AS=21875000000P
+ AD=16800000000P PS=460000U PD=380000U
* device instance $3437 r0 *1 19.24,38.59 nfet_01v8
M$3437 3638 151 25 167 nfet_01v8 L=150000U W=140000U AS=16800000000P
+ AD=21875000000P PS=380000U PD=460000U
* device instance $3438 r0 *1 19.76,38.59 nfet_01v8
M$3438 4404 151 28 167 nfet_01v8 L=150000U W=140000U AS=16800000000P
+ AD=21875000000P PS=380000U PD=460000U
* device instance $3439 r0 *1 19.205,38.99 nfet_01v8
M$3439 167 2040 3638 167 nfet_01v8 L=150000U W=210000U AS=21875000000P
+ AD=40400000000P PS=460000U PD=560000U
* device instance $3440 r0 *1 19.795,38.99 nfet_01v8
M$3440 167 1801 4404 167 nfet_01v8 L=150000U W=210000U AS=21875000000P
+ AD=40400000000P PS=460000U PD=560000U
* device instance $3441 r0 *1 19.205,39.38 nfet_01v8
M$3441 2040 3638 167 167 nfet_01v8 L=150000U W=210000U AS=40400000000P
+ AD=21875000000P PS=560000U PD=460000U
* device instance $3442 r0 *1 19.795,39.38 nfet_01v8
M$3442 1801 4404 167 167 nfet_01v8 L=150000U W=210000U AS=40400000000P
+ AD=21875000000P PS=560000U PD=460000U
* device instance $3443 r0 *1 19.24,39.78 nfet_01v8
M$3443 26 151 2040 167 nfet_01v8 L=150000U W=140000U AS=21875000000P
+ AD=16800000000P PS=460000U PD=380000U
* device instance $3444 r0 *1 19.76,39.78 nfet_01v8
M$3444 27 151 1801 167 nfet_01v8 L=150000U W=140000U AS=21875000000P
+ AD=16800000000P PS=460000U PD=380000U
* device instance $3445 r0 *1 19.24,40.17 nfet_01v8
M$3445 3626 152 26 167 nfet_01v8 L=150000U W=140000U AS=16800000000P
+ AD=21875000000P PS=380000U PD=460000U
* device instance $3446 r0 *1 19.76,40.17 nfet_01v8
M$3446 1352 152 27 167 nfet_01v8 L=150000U W=140000U AS=16800000000P
+ AD=21875000000P PS=380000U PD=460000U
* device instance $3447 r0 *1 19.205,40.57 nfet_01v8
M$3447 167 3111 3626 167 nfet_01v8 L=150000U W=210000U AS=21875000000P
+ AD=40400000000P PS=460000U PD=560000U
* device instance $3448 r0 *1 19.795,40.57 nfet_01v8
M$3448 167 1940 1352 167 nfet_01v8 L=150000U W=210000U AS=21875000000P
+ AD=40400000000P PS=460000U PD=560000U
* device instance $3449 r0 *1 19.205,40.96 nfet_01v8
M$3449 3111 3626 167 167 nfet_01v8 L=150000U W=210000U AS=40400000000P
+ AD=21875000000P PS=560000U PD=460000U
* device instance $3450 r0 *1 19.795,40.96 nfet_01v8
M$3450 1940 1352 167 167 nfet_01v8 L=150000U W=210000U AS=40400000000P
+ AD=21875000000P PS=560000U PD=460000U
* device instance $3451 r0 *1 19.24,41.36 nfet_01v8
M$3451 25 152 3111 167 nfet_01v8 L=150000U W=140000U AS=21875000000P
+ AD=16800000000P PS=460000U PD=380000U
* device instance $3452 r0 *1 19.76,41.36 nfet_01v8
M$3452 28 152 1940 167 nfet_01v8 L=150000U W=140000U AS=21875000000P
+ AD=16800000000P PS=460000U PD=380000U
* device instance $3453 r0 *1 19.24,41.75 nfet_01v8
M$3453 3634 153 25 167 nfet_01v8 L=150000U W=140000U AS=16800000000P
+ AD=21875000000P PS=380000U PD=460000U
* device instance $3454 r0 *1 19.76,41.75 nfet_01v8
M$3454 1354 153 28 167 nfet_01v8 L=150000U W=140000U AS=16800000000P
+ AD=21875000000P PS=380000U PD=460000U
* device instance $3455 r0 *1 19.205,42.15 nfet_01v8
M$3455 167 3096 3634 167 nfet_01v8 L=150000U W=210000U AS=21875000000P
+ AD=40400000000P PS=460000U PD=560000U
* device instance $3456 r0 *1 19.795,42.15 nfet_01v8
M$3456 167 1942 1354 167 nfet_01v8 L=150000U W=210000U AS=21875000000P
+ AD=40400000000P PS=460000U PD=560000U
* device instance $3457 r0 *1 19.205,42.54 nfet_01v8
M$3457 3096 3634 167 167 nfet_01v8 L=150000U W=210000U AS=40400000000P
+ AD=21875000000P PS=560000U PD=460000U
* device instance $3458 r0 *1 19.795,42.54 nfet_01v8
M$3458 1942 1354 167 167 nfet_01v8 L=150000U W=210000U AS=40400000000P
+ AD=21875000000P PS=560000U PD=460000U
* device instance $3459 r0 *1 19.24,42.94 nfet_01v8
M$3459 26 153 3096 167 nfet_01v8 L=150000U W=140000U AS=21875000000P
+ AD=16800000000P PS=460000U PD=380000U
* device instance $3460 r0 *1 19.76,42.94 nfet_01v8
M$3460 27 153 1942 167 nfet_01v8 L=150000U W=140000U AS=21875000000P
+ AD=16800000000P PS=460000U PD=380000U
* device instance $3461 r0 *1 8.34,37.01 nfet_01v8
M$3461 2524 150 10 167 nfet_01v8 L=150000U W=140000U AS=16800000000P
+ AD=21875000000P PS=380000U PD=460000U
* device instance $3462 r0 *1 8.86,37.01 nfet_01v8
M$3462 1378 150 11 167 nfet_01v8 L=150000U W=140000U AS=16800000000P
+ AD=21875000000P PS=380000U PD=460000U
* device instance $3463 r0 *1 8.305,37.41 nfet_01v8
M$3463 167 3083 2524 167 nfet_01v8 L=150000U W=210000U AS=21875000000P
+ AD=40400000000P PS=460000U PD=560000U
* device instance $3464 r0 *1 8.895,37.41 nfet_01v8
M$3464 167 1971 1378 167 nfet_01v8 L=150000U W=210000U AS=21875000000P
+ AD=40400000000P PS=460000U PD=560000U
* device instance $3465 r0 *1 8.305,37.8 nfet_01v8
M$3465 3083 2524 167 167 nfet_01v8 L=150000U W=210000U AS=40400000000P
+ AD=21875000000P PS=560000U PD=460000U
* device instance $3466 r0 *1 8.895,37.8 nfet_01v8
M$3466 1971 1378 167 167 nfet_01v8 L=150000U W=210000U AS=40400000000P
+ AD=21875000000P PS=560000U PD=460000U
* device instance $3467 r0 *1 8.34,38.2 nfet_01v8
M$3467 9 150 3083 167 nfet_01v8 L=150000U W=140000U AS=21875000000P
+ AD=16800000000P PS=460000U PD=380000U
* device instance $3468 r0 *1 8.86,38.2 nfet_01v8
M$3468 12 150 1971 167 nfet_01v8 L=150000U W=140000U AS=21875000000P
+ AD=16800000000P PS=460000U PD=380000U
* device instance $3469 r0 *1 8.34,38.59 nfet_01v8
M$3469 3735 151 9 167 nfet_01v8 L=150000U W=140000U AS=16800000000P
+ AD=21875000000P PS=380000U PD=460000U
* device instance $3470 r0 *1 8.86,38.59 nfet_01v8
M$3470 4400 151 12 167 nfet_01v8 L=150000U W=140000U AS=16800000000P
+ AD=21875000000P PS=380000U PD=460000U
* device instance $3471 r0 *1 8.305,38.99 nfet_01v8
M$3471 167 2144 3735 167 nfet_01v8 L=150000U W=210000U AS=21875000000P
+ AD=40400000000P PS=460000U PD=560000U
* device instance $3472 r0 *1 8.895,38.99 nfet_01v8
M$3472 167 1926 4400 167 nfet_01v8 L=150000U W=210000U AS=21875000000P
+ AD=40400000000P PS=460000U PD=560000U
* device instance $3473 r0 *1 8.305,39.38 nfet_01v8
M$3473 2144 3735 167 167 nfet_01v8 L=150000U W=210000U AS=40400000000P
+ AD=21875000000P PS=560000U PD=460000U
* device instance $3474 r0 *1 8.895,39.38 nfet_01v8
M$3474 1926 4400 167 167 nfet_01v8 L=150000U W=210000U AS=40400000000P
+ AD=21875000000P PS=560000U PD=460000U
* device instance $3475 r0 *1 8.34,39.78 nfet_01v8
M$3475 10 151 2144 167 nfet_01v8 L=150000U W=140000U AS=21875000000P
+ AD=16800000000P PS=460000U PD=380000U
* device instance $3476 r0 *1 8.86,39.78 nfet_01v8
M$3476 11 151 1926 167 nfet_01v8 L=150000U W=140000U AS=21875000000P
+ AD=16800000000P PS=460000U PD=380000U
* device instance $3477 r0 *1 8.34,40.17 nfet_01v8
M$3477 3725 152 10 167 nfet_01v8 L=150000U W=140000U AS=16800000000P
+ AD=21875000000P PS=380000U PD=460000U
* device instance $3478 r0 *1 8.86,40.17 nfet_01v8
M$3478 585 152 11 167 nfet_01v8 L=150000U W=140000U AS=16800000000P
+ AD=21875000000P PS=380000U PD=460000U
* device instance $3479 r0 *1 8.305,40.57 nfet_01v8
M$3479 167 3086 3725 167 nfet_01v8 L=150000U W=210000U AS=21875000000P
+ AD=40400000000P PS=460000U PD=560000U
* device instance $3480 r0 *1 8.895,40.57 nfet_01v8
M$3480 167 687 585 167 nfet_01v8 L=150000U W=210000U AS=21875000000P
+ AD=40400000000P PS=460000U PD=560000U
* device instance $3481 r0 *1 8.305,40.96 nfet_01v8
M$3481 3086 3725 167 167 nfet_01v8 L=150000U W=210000U AS=40400000000P
+ AD=21875000000P PS=560000U PD=460000U
* device instance $3482 r0 *1 8.895,40.96 nfet_01v8
M$3482 687 585 167 167 nfet_01v8 L=150000U W=210000U AS=40400000000P
+ AD=21875000000P PS=560000U PD=460000U
* device instance $3483 r0 *1 8.34,41.36 nfet_01v8
M$3483 9 152 3086 167 nfet_01v8 L=150000U W=140000U AS=21875000000P
+ AD=16800000000P PS=460000U PD=380000U
* device instance $3484 r0 *1 8.86,41.36 nfet_01v8
M$3484 12 152 687 167 nfet_01v8 L=150000U W=140000U AS=21875000000P
+ AD=16800000000P PS=460000U PD=380000U
* device instance $3485 r0 *1 8.34,41.75 nfet_01v8
M$3485 3727 153 9 167 nfet_01v8 L=150000U W=140000U AS=16800000000P
+ AD=21875000000P PS=380000U PD=460000U
* device instance $3486 r0 *1 8.86,41.75 nfet_01v8
M$3486 1292 153 12 167 nfet_01v8 L=150000U W=140000U AS=16800000000P
+ AD=21875000000P PS=380000U PD=460000U
* device instance $3487 r0 *1 8.305,42.15 nfet_01v8
M$3487 167 3077 3727 167 nfet_01v8 L=150000U W=210000U AS=21875000000P
+ AD=40400000000P PS=460000U PD=560000U
* device instance $3488 r0 *1 8.895,42.15 nfet_01v8
M$3488 167 1869 1292 167 nfet_01v8 L=150000U W=210000U AS=21875000000P
+ AD=40400000000P PS=460000U PD=560000U
* device instance $3489 r0 *1 8.305,42.54 nfet_01v8
M$3489 3077 3727 167 167 nfet_01v8 L=150000U W=210000U AS=40400000000P
+ AD=21875000000P PS=560000U PD=460000U
* device instance $3490 r0 *1 8.895,42.54 nfet_01v8
M$3490 1869 1292 167 167 nfet_01v8 L=150000U W=210000U AS=40400000000P
+ AD=21875000000P PS=560000U PD=460000U
* device instance $3491 r0 *1 8.34,42.94 nfet_01v8
M$3491 10 153 3077 167 nfet_01v8 L=150000U W=140000U AS=21875000000P
+ AD=16800000000P PS=460000U PD=380000U
* device instance $3492 r0 *1 8.86,42.94 nfet_01v8
M$3492 11 153 1869 167 nfet_01v8 L=150000U W=140000U AS=21875000000P
+ AD=16800000000P PS=460000U PD=380000U
* device instance $3493 r0 *1 41.04,60.71 nfet_01v8
M$3493 2316 162 58 167 nfet_01v8 L=150000U W=140000U AS=16800000000P
+ AD=21875000000P PS=380000U PD=460000U
* device instance $3494 r0 *1 41.56,60.71 nfet_01v8
M$3494 935 162 59 167 nfet_01v8 L=150000U W=140000U AS=16800000000P
+ AD=21875000000P PS=380000U PD=460000U
* device instance $3495 r0 *1 41.005,61.11 nfet_01v8
M$3495 167 2650 2316 167 nfet_01v8 L=150000U W=210000U AS=21875000000P
+ AD=40400000000P PS=460000U PD=560000U
* device instance $3496 r0 *1 41.595,61.11 nfet_01v8
M$3496 167 1456 935 167 nfet_01v8 L=150000U W=210000U AS=21875000000P
+ AD=40400000000P PS=460000U PD=560000U
* device instance $3497 r0 *1 41.005,61.5 nfet_01v8
M$3497 2650 2316 167 167 nfet_01v8 L=150000U W=210000U AS=40400000000P
+ AD=21875000000P PS=560000U PD=460000U
* device instance $3498 r0 *1 41.595,61.5 nfet_01v8
M$3498 1456 935 167 167 nfet_01v8 L=150000U W=210000U AS=40400000000P
+ AD=21875000000P PS=560000U PD=460000U
* device instance $3499 r0 *1 41.04,61.9 nfet_01v8
M$3499 57 162 2650 167 nfet_01v8 L=150000U W=140000U AS=21875000000P
+ AD=16800000000P PS=460000U PD=380000U
* device instance $3500 r0 *1 41.56,61.9 nfet_01v8
M$3500 60 162 1456 167 nfet_01v8 L=150000U W=140000U AS=21875000000P
+ AD=16800000000P PS=460000U PD=380000U
* device instance $3501 r0 *1 41.04,62.29 nfet_01v8
M$3501 3496 163 57 167 nfet_01v8 L=150000U W=140000U AS=16800000000P
+ AD=21875000000P PS=380000U PD=460000U
* device instance $3502 r0 *1 41.56,62.29 nfet_01v8
M$3502 4401 163 60 167 nfet_01v8 L=150000U W=140000U AS=16800000000P
+ AD=21875000000P PS=380000U PD=460000U
* device instance $3503 r0 *1 41.005,62.69 nfet_01v8
M$3503 167 2555 3496 167 nfet_01v8 L=150000U W=210000U AS=21875000000P
+ AD=40400000000P PS=460000U PD=560000U
* device instance $3504 r0 *1 41.595,62.69 nfet_01v8
M$3504 167 700 4401 167 nfet_01v8 L=150000U W=210000U AS=21875000000P
+ AD=40400000000P PS=460000U PD=560000U
* device instance $3505 r0 *1 41.005,63.08 nfet_01v8
M$3505 2555 3496 167 167 nfet_01v8 L=150000U W=210000U AS=40400000000P
+ AD=21875000000P PS=560000U PD=460000U
* device instance $3506 r0 *1 41.595,63.08 nfet_01v8
M$3506 700 4401 167 167 nfet_01v8 L=150000U W=210000U AS=40400000000P
+ AD=21875000000P PS=560000U PD=460000U
* device instance $3507 r0 *1 41.04,63.48 nfet_01v8
M$3507 58 163 2555 167 nfet_01v8 L=150000U W=140000U AS=21875000000P
+ AD=16800000000P PS=460000U PD=380000U
* device instance $3508 r0 *1 41.56,63.48 nfet_01v8
M$3508 59 163 700 167 nfet_01v8 L=150000U W=140000U AS=21875000000P
+ AD=16800000000P PS=460000U PD=380000U
* device instance $3509 r0 *1 41.04,63.87 nfet_01v8
M$3509 3499 164 58 167 nfet_01v8 L=150000U W=140000U AS=16800000000P
+ AD=21875000000P PS=380000U PD=460000U
* device instance $3510 r0 *1 41.56,63.87 nfet_01v8
M$3510 588 164 59 167 nfet_01v8 L=150000U W=140000U AS=16800000000P
+ AD=21875000000P PS=380000U PD=460000U
* device instance $3511 r0 *1 41.005,64.27 nfet_01v8
M$3511 167 2133 3499 167 nfet_01v8 L=150000U W=210000U AS=21875000000P
+ AD=40400000000P PS=460000U PD=560000U
* device instance $3512 r0 *1 41.595,64.27 nfet_01v8
M$3512 167 695 588 167 nfet_01v8 L=150000U W=210000U AS=21875000000P
+ AD=40400000000P PS=460000U PD=560000U
* device instance $3513 r0 *1 41.005,64.66 nfet_01v8
M$3513 2133 3499 167 167 nfet_01v8 L=150000U W=210000U AS=40400000000P
+ AD=21875000000P PS=560000U PD=460000U
* device instance $3514 r0 *1 41.595,64.66 nfet_01v8
M$3514 695 588 167 167 nfet_01v8 L=150000U W=210000U AS=40400000000P
+ AD=21875000000P PS=560000U PD=460000U
* device instance $3515 r0 *1 41.04,65.06 nfet_01v8
M$3515 57 164 2133 167 nfet_01v8 L=150000U W=140000U AS=21875000000P
+ AD=16800000000P PS=460000U PD=380000U
* device instance $3516 r0 *1 41.56,65.06 nfet_01v8
M$3516 60 164 695 167 nfet_01v8 L=150000U W=140000U AS=21875000000P
+ AD=16800000000P PS=460000U PD=380000U
* device instance $3517 r0 *1 41.04,65.45 nfet_01v8
M$3517 3495 165 57 167 nfet_01v8 L=150000U W=140000U AS=16800000000P
+ AD=21875000000P PS=380000U PD=460000U
* device instance $3518 r0 *1 41.56,65.45 nfet_01v8
M$3518 1244 165 60 167 nfet_01v8 L=150000U W=140000U AS=16800000000P
+ AD=21875000000P PS=380000U PD=460000U
* device instance $3519 r0 *1 41.005,65.85 nfet_01v8
M$3519 167 2573 3495 167 nfet_01v8 L=150000U W=210000U AS=21875000000P
+ AD=40400000000P PS=460000U PD=560000U
* device instance $3520 r0 *1 41.595,65.85 nfet_01v8
M$3520 167 1816 1244 167 nfet_01v8 L=150000U W=210000U AS=21875000000P
+ AD=40400000000P PS=460000U PD=560000U
* device instance $3521 r0 *1 41.005,66.24 nfet_01v8
M$3521 2573 3495 167 167 nfet_01v8 L=150000U W=210000U AS=40400000000P
+ AD=21875000000P PS=560000U PD=460000U
* device instance $3522 r0 *1 41.595,66.24 nfet_01v8
M$3522 1816 1244 167 167 nfet_01v8 L=150000U W=210000U AS=40400000000P
+ AD=21875000000P PS=560000U PD=460000U
* device instance $3523 r0 *1 41.04,66.64 nfet_01v8
M$3523 58 165 2573 167 nfet_01v8 L=150000U W=140000U AS=21875000000P
+ AD=16800000000P PS=460000U PD=380000U
* device instance $3524 r0 *1 41.56,66.64 nfet_01v8
M$3524 59 165 1816 167 nfet_01v8 L=150000U W=140000U AS=21875000000P
+ AD=16800000000P PS=460000U PD=380000U
* device instance $3525 r0 *1 84.64,44.91 nfet_01v8
M$3525 2307 154 122 167 nfet_01v8 L=150000U W=140000U AS=16800000000P
+ AD=21875000000P PS=380000U PD=460000U
* device instance $3526 r0 *1 85.16,44.91 nfet_01v8
M$3526 1000 154 123 167 nfet_01v8 L=150000U W=140000U AS=16800000000P
+ AD=21875000000P PS=380000U PD=460000U
* device instance $3527 r0 *1 84.605,45.31 nfet_01v8
M$3527 167 2630 2307 167 nfet_01v8 L=150000U W=210000U AS=21875000000P
+ AD=40400000000P PS=460000U PD=560000U
* device instance $3528 r0 *1 85.195,45.31 nfet_01v8
M$3528 167 1535 1000 167 nfet_01v8 L=150000U W=210000U AS=21875000000P
+ AD=40400000000P PS=460000U PD=560000U
* device instance $3529 r0 *1 84.605,45.7 nfet_01v8
M$3529 2630 2307 167 167 nfet_01v8 L=150000U W=210000U AS=40400000000P
+ AD=21875000000P PS=560000U PD=460000U
* device instance $3530 r0 *1 85.195,45.7 nfet_01v8
M$3530 1535 1000 167 167 nfet_01v8 L=150000U W=210000U AS=40400000000P
+ AD=21875000000P PS=560000U PD=460000U
* device instance $3531 r0 *1 84.64,46.1 nfet_01v8
M$3531 121 154 2630 167 nfet_01v8 L=150000U W=140000U AS=21875000000P
+ AD=16800000000P PS=460000U PD=380000U
* device instance $3532 r0 *1 85.16,46.1 nfet_01v8
M$3532 124 154 1535 167 nfet_01v8 L=150000U W=140000U AS=21875000000P
+ AD=16800000000P PS=460000U PD=380000U
* device instance $3533 r0 *1 84.64,46.49 nfet_01v8
M$3533 3590 155 121 167 nfet_01v8 L=150000U W=140000U AS=16800000000P
+ AD=21875000000P PS=380000U PD=460000U
* device instance $3534 r0 *1 85.16,46.49 nfet_01v8
M$3534 4506 155 124 167 nfet_01v8 L=150000U W=140000U AS=16800000000P
+ AD=21875000000P PS=380000U PD=460000U
* device instance $3535 r0 *1 84.605,46.89 nfet_01v8
M$3535 167 2142 3590 167 nfet_01v8 L=150000U W=210000U AS=21875000000P
+ AD=40400000000P PS=460000U PD=560000U
* device instance $3536 r0 *1 85.195,46.89 nfet_01v8
M$3536 167 846 4506 167 nfet_01v8 L=150000U W=210000U AS=21875000000P
+ AD=40400000000P PS=460000U PD=560000U
* device instance $3537 r0 *1 84.605,47.28 nfet_01v8
M$3537 2142 3590 167 167 nfet_01v8 L=150000U W=210000U AS=40400000000P
+ AD=21875000000P PS=560000U PD=460000U
* device instance $3538 r0 *1 85.195,47.28 nfet_01v8
M$3538 846 4506 167 167 nfet_01v8 L=150000U W=210000U AS=40400000000P
+ AD=21875000000P PS=560000U PD=460000U
* device instance $3539 r0 *1 84.64,47.68 nfet_01v8
M$3539 122 155 2142 167 nfet_01v8 L=150000U W=140000U AS=21875000000P
+ AD=16800000000P PS=460000U PD=380000U
* device instance $3540 r0 *1 85.16,47.68 nfet_01v8
M$3540 123 155 846 167 nfet_01v8 L=150000U W=140000U AS=21875000000P
+ AD=16800000000P PS=460000U PD=380000U
* device instance $3541 r0 *1 84.64,48.07 nfet_01v8
M$3541 2084 156 122 167 nfet_01v8 L=150000U W=140000U AS=16800000000P
+ AD=21875000000P PS=380000U PD=460000U
* device instance $3542 r0 *1 85.16,48.07 nfet_01v8
M$3542 995 156 123 167 nfet_01v8 L=150000U W=140000U AS=16800000000P
+ AD=21875000000P PS=380000U PD=460000U
* device instance $3543 r0 *1 84.605,48.47 nfet_01v8
M$3543 167 2167 2084 167 nfet_01v8 L=150000U W=210000U AS=21875000000P
+ AD=40400000000P PS=460000U PD=560000U
* device instance $3544 r0 *1 85.195,48.47 nfet_01v8
M$3544 167 1530 995 167 nfet_01v8 L=150000U W=210000U AS=21875000000P
+ AD=40400000000P PS=460000U PD=560000U
* device instance $3545 r0 *1 84.605,48.86 nfet_01v8
M$3545 2167 2084 167 167 nfet_01v8 L=150000U W=210000U AS=40400000000P
+ AD=21875000000P PS=560000U PD=460000U
* device instance $3546 r0 *1 85.195,48.86 nfet_01v8
M$3546 1530 995 167 167 nfet_01v8 L=150000U W=210000U AS=40400000000P
+ AD=21875000000P PS=560000U PD=460000U
* device instance $3547 r0 *1 84.64,49.26 nfet_01v8
M$3547 121 156 2167 167 nfet_01v8 L=150000U W=140000U AS=21875000000P
+ AD=16800000000P PS=460000U PD=380000U
* device instance $3548 r0 *1 85.16,49.26 nfet_01v8
M$3548 124 156 1530 167 nfet_01v8 L=150000U W=140000U AS=21875000000P
+ AD=16800000000P PS=460000U PD=380000U
* device instance $3549 r0 *1 84.64,49.65 nfet_01v8
M$3549 3587 157 121 167 nfet_01v8 L=150000U W=140000U AS=16800000000P
+ AD=21875000000P PS=380000U PD=460000U
* device instance $3550 r0 *1 85.16,49.65 nfet_01v8
M$3550 1011 157 124 167 nfet_01v8 L=150000U W=140000U AS=16800000000P
+ AD=21875000000P PS=380000U PD=460000U
* device instance $3551 r0 *1 84.605,50.05 nfet_01v8
M$3551 167 2626 3587 167 nfet_01v8 L=150000U W=210000U AS=21875000000P
+ AD=40400000000P PS=460000U PD=560000U
* device instance $3552 r0 *1 85.195,50.05 nfet_01v8
M$3552 167 1546 1011 167 nfet_01v8 L=150000U W=210000U AS=21875000000P
+ AD=40400000000P PS=460000U PD=560000U
* device instance $3553 r0 *1 84.605,50.44 nfet_01v8
M$3553 2626 3587 167 167 nfet_01v8 L=150000U W=210000U AS=40400000000P
+ AD=21875000000P PS=560000U PD=460000U
* device instance $3554 r0 *1 85.195,50.44 nfet_01v8
M$3554 1546 1011 167 167 nfet_01v8 L=150000U W=210000U AS=40400000000P
+ AD=21875000000P PS=560000U PD=460000U
* device instance $3555 r0 *1 84.64,50.84 nfet_01v8
M$3555 122 157 2626 167 nfet_01v8 L=150000U W=140000U AS=21875000000P
+ AD=16800000000P PS=460000U PD=380000U
* device instance $3556 r0 *1 85.16,50.84 nfet_01v8
M$3556 123 157 1546 167 nfet_01v8 L=150000U W=140000U AS=21875000000P
+ AD=16800000000P PS=460000U PD=380000U
* device instance $3557 r0 *1 73.74,44.91 nfet_01v8
M$3557 2294 154 106 167 nfet_01v8 L=150000U W=140000U AS=16800000000P
+ AD=21875000000P PS=380000U PD=460000U
* device instance $3558 r0 *1 74.26,44.91 nfet_01v8
M$3558 1337 154 107 167 nfet_01v8 L=150000U W=140000U AS=16800000000P
+ AD=21875000000P PS=380000U PD=460000U
* device instance $3559 r0 *1 73.705,45.31 nfet_01v8
M$3559 167 2610 2294 167 nfet_01v8 L=150000U W=210000U AS=21875000000P
+ AD=40400000000P PS=460000U PD=560000U
* device instance $3560 r0 *1 74.295,45.31 nfet_01v8
M$3560 167 1919 1337 167 nfet_01v8 L=150000U W=210000U AS=21875000000P
+ AD=40400000000P PS=460000U PD=560000U
* device instance $3561 r0 *1 73.705,45.7 nfet_01v8
M$3561 2610 2294 167 167 nfet_01v8 L=150000U W=210000U AS=40400000000P
+ AD=21875000000P PS=560000U PD=460000U
* device instance $3562 r0 *1 74.295,45.7 nfet_01v8
M$3562 1919 1337 167 167 nfet_01v8 L=150000U W=210000U AS=40400000000P
+ AD=21875000000P PS=560000U PD=460000U
* device instance $3563 r0 *1 73.74,46.1 nfet_01v8
M$3563 105 154 2610 167 nfet_01v8 L=150000U W=140000U AS=21875000000P
+ AD=16800000000P PS=460000U PD=380000U
* device instance $3564 r0 *1 74.26,46.1 nfet_01v8
M$3564 108 154 1919 167 nfet_01v8 L=150000U W=140000U AS=21875000000P
+ AD=16800000000P PS=460000U PD=380000U
* device instance $3565 r0 *1 73.74,46.49 nfet_01v8
M$3565 3595 155 105 167 nfet_01v8 L=150000U W=140000U AS=16800000000P
+ AD=21875000000P PS=380000U PD=460000U
* device instance $3566 r0 *1 74.26,46.49 nfet_01v8
M$3566 4471 155 108 167 nfet_01v8 L=150000U W=140000U AS=16800000000P
+ AD=21875000000P PS=380000U PD=460000U
* device instance $3567 r0 *1 73.705,46.89 nfet_01v8
M$3567 167 1979 3595 167 nfet_01v8 L=150000U W=210000U AS=21875000000P
+ AD=40400000000P PS=460000U PD=560000U
* device instance $3568 r0 *1 74.295,46.89 nfet_01v8
M$3568 167 1913 4471 167 nfet_01v8 L=150000U W=210000U AS=21875000000P
+ AD=40400000000P PS=460000U PD=560000U
* device instance $3569 r0 *1 73.705,47.28 nfet_01v8
M$3569 1979 3595 167 167 nfet_01v8 L=150000U W=210000U AS=40400000000P
+ AD=21875000000P PS=560000U PD=460000U
* device instance $3570 r0 *1 74.295,47.28 nfet_01v8
M$3570 1913 4471 167 167 nfet_01v8 L=150000U W=210000U AS=40400000000P
+ AD=21875000000P PS=560000U PD=460000U
* device instance $3571 r0 *1 73.74,47.68 nfet_01v8
M$3571 106 155 1979 167 nfet_01v8 L=150000U W=140000U AS=21875000000P
+ AD=16800000000P PS=460000U PD=380000U
* device instance $3572 r0 *1 74.26,47.68 nfet_01v8
M$3572 107 155 1913 167 nfet_01v8 L=150000U W=140000U AS=21875000000P
+ AD=16800000000P PS=460000U PD=380000U
* device instance $3573 r0 *1 73.74,48.07 nfet_01v8
M$3573 3596 156 106 167 nfet_01v8 L=150000U W=140000U AS=16800000000P
+ AD=21875000000P PS=380000U PD=460000U
* device instance $3574 r0 *1 74.26,48.07 nfet_01v8
M$3574 646 156 107 167 nfet_01v8 L=150000U W=140000U AS=16800000000P
+ AD=21875000000P PS=380000U PD=460000U
* device instance $3575 r0 *1 73.705,48.47 nfet_01v8
M$3575 167 2607 3596 167 nfet_01v8 L=150000U W=210000U AS=21875000000P
+ AD=40400000000P PS=460000U PD=560000U
* device instance $3576 r0 *1 74.295,48.47 nfet_01v8
M$3576 167 808 646 167 nfet_01v8 L=150000U W=210000U AS=21875000000P
+ AD=40400000000P PS=460000U PD=560000U
* device instance $3577 r0 *1 73.705,48.86 nfet_01v8
M$3577 2607 3596 167 167 nfet_01v8 L=150000U W=210000U AS=40400000000P
+ AD=21875000000P PS=560000U PD=460000U
* device instance $3578 r0 *1 74.295,48.86 nfet_01v8
M$3578 808 646 167 167 nfet_01v8 L=150000U W=210000U AS=40400000000P
+ AD=21875000000P PS=560000U PD=460000U
* device instance $3579 r0 *1 73.74,49.26 nfet_01v8
M$3579 105 156 2607 167 nfet_01v8 L=150000U W=140000U AS=21875000000P
+ AD=16800000000P PS=460000U PD=380000U
* device instance $3580 r0 *1 74.26,49.26 nfet_01v8
M$3580 108 156 808 167 nfet_01v8 L=150000U W=140000U AS=21875000000P
+ AD=16800000000P PS=460000U PD=380000U
* device instance $3581 r0 *1 73.74,49.65 nfet_01v8
M$3581 3594 157 105 167 nfet_01v8 L=150000U W=140000U AS=16800000000P
+ AD=21875000000P PS=380000U PD=460000U
* device instance $3582 r0 *1 74.26,49.65 nfet_01v8
M$3582 1318 157 108 167 nfet_01v8 L=150000U W=140000U AS=16800000000P
+ AD=21875000000P PS=380000U PD=460000U
* device instance $3583 r0 *1 73.705,50.05 nfet_01v8
M$3583 167 2613 3594 167 nfet_01v8 L=150000U W=210000U AS=21875000000P
+ AD=40400000000P PS=460000U PD=560000U
* device instance $3584 r0 *1 74.295,50.05 nfet_01v8
M$3584 167 1898 1318 167 nfet_01v8 L=150000U W=210000U AS=21875000000P
+ AD=40400000000P PS=460000U PD=560000U
* device instance $3585 r0 *1 73.705,50.44 nfet_01v8
M$3585 2613 3594 167 167 nfet_01v8 L=150000U W=210000U AS=40400000000P
+ AD=21875000000P PS=560000U PD=460000U
* device instance $3586 r0 *1 74.295,50.44 nfet_01v8
M$3586 1898 1318 167 167 nfet_01v8 L=150000U W=210000U AS=40400000000P
+ AD=21875000000P PS=560000U PD=460000U
* device instance $3587 r0 *1 73.74,50.84 nfet_01v8
M$3587 106 157 2613 167 nfet_01v8 L=150000U W=140000U AS=21875000000P
+ AD=16800000000P PS=460000U PD=380000U
* device instance $3588 r0 *1 74.26,50.84 nfet_01v8
M$3588 107 157 1898 167 nfet_01v8 L=150000U W=140000U AS=21875000000P
+ AD=16800000000P PS=460000U PD=380000U
* device instance $3589 r0 *1 19.24,52.81 nfet_01v8
M$3589 2321 158 26 167 nfet_01v8 L=150000U W=140000U AS=16800000000P
+ AD=21875000000P PS=380000U PD=460000U
* device instance $3590 r0 *1 19.76,52.81 nfet_01v8
M$3590 1242 158 27 167 nfet_01v8 L=150000U W=140000U AS=16800000000P
+ AD=21875000000P PS=380000U PD=460000U
* device instance $3591 r0 *1 19.205,53.21 nfet_01v8
M$3591 167 2659 2321 167 nfet_01v8 L=150000U W=210000U AS=21875000000P
+ AD=40400000000P PS=460000U PD=560000U
* device instance $3592 r0 *1 19.795,53.21 nfet_01v8
M$3592 167 1814 1242 167 nfet_01v8 L=150000U W=210000U AS=21875000000P
+ AD=40400000000P PS=460000U PD=560000U
* device instance $3593 r0 *1 19.205,53.6 nfet_01v8
M$3593 2659 2321 167 167 nfet_01v8 L=150000U W=210000U AS=40400000000P
+ AD=21875000000P PS=560000U PD=460000U
* device instance $3594 r0 *1 19.795,53.6 nfet_01v8
M$3594 1814 1242 167 167 nfet_01v8 L=150000U W=210000U AS=40400000000P
+ AD=21875000000P PS=560000U PD=460000U
* device instance $3595 r0 *1 19.24,54 nfet_01v8
M$3595 25 158 2659 167 nfet_01v8 L=150000U W=140000U AS=21875000000P
+ AD=16800000000P PS=460000U PD=380000U
* device instance $3596 r0 *1 19.76,54 nfet_01v8
M$3596 28 158 1814 167 nfet_01v8 L=150000U W=140000U AS=21875000000P
+ AD=16800000000P PS=460000U PD=380000U
* device instance $3597 r0 *1 19.24,54.39 nfet_01v8
M$3597 3739 159 25 167 nfet_01v8 L=150000U W=140000U AS=16800000000P
+ AD=21875000000P PS=380000U PD=460000U
* device instance $3598 r0 *1 19.76,54.39 nfet_01v8
M$3598 4470 159 28 167 nfet_01v8 L=150000U W=140000U AS=16800000000P
+ AD=21875000000P PS=380000U PD=460000U
* device instance $3599 r0 *1 19.205,54.79 nfet_01v8
M$3599 167 2221 3739 167 nfet_01v8 L=150000U W=210000U AS=21875000000P
+ AD=40400000000P PS=460000U PD=560000U
* device instance $3600 r0 *1 19.795,54.79 nfet_01v8
M$3600 167 1404 4470 167 nfet_01v8 L=150000U W=210000U AS=21875000000P
+ AD=40400000000P PS=460000U PD=560000U
* device instance $3601 r0 *1 19.205,55.18 nfet_01v8
M$3601 2221 3739 167 167 nfet_01v8 L=150000U W=210000U AS=40400000000P
+ AD=21875000000P PS=560000U PD=460000U
* device instance $3602 r0 *1 19.795,55.18 nfet_01v8
M$3602 1404 4470 167 167 nfet_01v8 L=150000U W=210000U AS=40400000000P
+ AD=21875000000P PS=560000U PD=460000U
* device instance $3603 r0 *1 19.24,55.58 nfet_01v8
M$3603 26 159 2221 167 nfet_01v8 L=150000U W=140000U AS=21875000000P
+ AD=16800000000P PS=460000U PD=380000U
* device instance $3604 r0 *1 19.76,55.58 nfet_01v8
M$3604 27 159 1404 167 nfet_01v8 L=150000U W=140000U AS=21875000000P
+ AD=16800000000P PS=460000U PD=380000U
* device instance $3605 r0 *1 19.24,55.97 nfet_01v8
M$3605 3740 160 26 167 nfet_01v8 L=150000U W=140000U AS=16800000000P
+ AD=21875000000P PS=380000U PD=460000U
* device instance $3606 r0 *1 19.76,55.97 nfet_01v8
M$3606 930 160 27 167 nfet_01v8 L=150000U W=140000U AS=16800000000P
+ AD=21875000000P PS=380000U PD=460000U
* device instance $3607 r0 *1 19.205,56.37 nfet_01v8
M$3607 167 2954 3740 167 nfet_01v8 L=150000U W=210000U AS=21875000000P
+ AD=40400000000P PS=460000U PD=560000U
* device instance $3608 r0 *1 19.795,56.37 nfet_01v8
M$3608 167 1448 930 167 nfet_01v8 L=150000U W=210000U AS=21875000000P
+ AD=40400000000P PS=460000U PD=560000U
* device instance $3609 r0 *1 19.205,56.76 nfet_01v8
M$3609 2954 3740 167 167 nfet_01v8 L=150000U W=210000U AS=40400000000P
+ AD=21875000000P PS=560000U PD=460000U
* device instance $3610 r0 *1 19.795,56.76 nfet_01v8
M$3610 1448 930 167 167 nfet_01v8 L=150000U W=210000U AS=40400000000P
+ AD=21875000000P PS=560000U PD=460000U
* device instance $3611 r0 *1 19.24,57.16 nfet_01v8
M$3611 25 160 2954 167 nfet_01v8 L=150000U W=140000U AS=21875000000P
+ AD=16800000000P PS=460000U PD=380000U
* device instance $3612 r0 *1 19.76,57.16 nfet_01v8
M$3612 28 160 1448 167 nfet_01v8 L=150000U W=140000U AS=21875000000P
+ AD=16800000000P PS=460000U PD=380000U
* device instance $3613 r0 *1 19.24,57.55 nfet_01v8
M$3613 3699 161 25 167 nfet_01v8 L=150000U W=140000U AS=16800000000P
+ AD=21875000000P PS=380000U PD=460000U
* device instance $3614 r0 *1 19.76,57.55 nfet_01v8
M$3614 922 161 28 167 nfet_01v8 L=150000U W=140000U AS=16800000000P
+ AD=21875000000P PS=380000U PD=460000U
* device instance $3615 r0 *1 19.205,57.95 nfet_01v8
M$3615 167 2971 3699 167 nfet_01v8 L=150000U W=210000U AS=21875000000P
+ AD=40400000000P PS=460000U PD=560000U
* device instance $3616 r0 *1 19.795,57.95 nfet_01v8
M$3616 167 1440 922 167 nfet_01v8 L=150000U W=210000U AS=21875000000P
+ AD=40400000000P PS=460000U PD=560000U
* device instance $3617 r0 *1 19.205,58.34 nfet_01v8
M$3617 2971 3699 167 167 nfet_01v8 L=150000U W=210000U AS=40400000000P
+ AD=21875000000P PS=560000U PD=460000U
* device instance $3618 r0 *1 19.795,58.34 nfet_01v8
M$3618 1440 922 167 167 nfet_01v8 L=150000U W=210000U AS=40400000000P
+ AD=21875000000P PS=560000U PD=460000U
* device instance $3619 r0 *1 19.24,58.74 nfet_01v8
M$3619 26 161 2971 167 nfet_01v8 L=150000U W=140000U AS=21875000000P
+ AD=16800000000P PS=460000U PD=380000U
* device instance $3620 r0 *1 19.76,58.74 nfet_01v8
M$3620 27 161 1440 167 nfet_01v8 L=150000U W=140000U AS=21875000000P
+ AD=16800000000P PS=460000U PD=380000U
* device instance $3621 r0 *1 30.14,52.81 nfet_01v8
M$3621 3500 158 42 167 nfet_01v8 L=150000U W=140000U AS=16800000000P
+ AD=21875000000P PS=380000U PD=460000U
* device instance $3622 r0 *1 30.66,52.81 nfet_01v8
M$3622 1239 158 43 167 nfet_01v8 L=150000U W=140000U AS=16800000000P
+ AD=21875000000P PS=380000U PD=460000U
* device instance $3623 r0 *1 30.105,53.21 nfet_01v8
M$3623 167 2656 3500 167 nfet_01v8 L=150000U W=210000U AS=21875000000P
+ AD=40400000000P PS=460000U PD=560000U
* device instance $3624 r0 *1 30.695,53.21 nfet_01v8
M$3624 167 1811 1239 167 nfet_01v8 L=150000U W=210000U AS=21875000000P
+ AD=40400000000P PS=460000U PD=560000U
* device instance $3625 r0 *1 30.105,53.6 nfet_01v8
M$3625 2656 3500 167 167 nfet_01v8 L=150000U W=210000U AS=40400000000P
+ AD=21875000000P PS=560000U PD=460000U
* device instance $3626 r0 *1 30.695,53.6 nfet_01v8
M$3626 1811 1239 167 167 nfet_01v8 L=150000U W=210000U AS=40400000000P
+ AD=21875000000P PS=560000U PD=460000U
* device instance $3627 r0 *1 30.14,54 nfet_01v8
M$3627 41 158 2656 167 nfet_01v8 L=150000U W=140000U AS=21875000000P
+ AD=16800000000P PS=460000U PD=380000U
* device instance $3628 r0 *1 30.66,54 nfet_01v8
M$3628 44 158 1811 167 nfet_01v8 L=150000U W=140000U AS=21875000000P
+ AD=16800000000P PS=460000U PD=380000U
* device instance $3629 r0 *1 30.14,54.39 nfet_01v8
M$3629 3551 159 41 167 nfet_01v8 L=150000U W=140000U AS=16800000000P
+ AD=21875000000P PS=380000U PD=460000U
* device instance $3630 r0 *1 30.66,54.39 nfet_01v8
M$3630 4444 159 44 167 nfet_01v8 L=150000U W=140000U AS=16800000000P
+ AD=21875000000P PS=380000U PD=460000U
* device instance $3631 r0 *1 30.105,54.79 nfet_01v8
M$3631 167 2264 3551 167 nfet_01v8 L=150000U W=210000U AS=21875000000P
+ AD=40400000000P PS=460000U PD=560000U
* device instance $3632 r0 *1 30.695,54.79 nfet_01v8
M$3632 167 1400 4444 167 nfet_01v8 L=150000U W=210000U AS=21875000000P
+ AD=40400000000P PS=460000U PD=560000U
* device instance $3633 r0 *1 30.105,55.18 nfet_01v8
M$3633 2264 3551 167 167 nfet_01v8 L=150000U W=210000U AS=40400000000P
+ AD=21875000000P PS=560000U PD=460000U
* device instance $3634 r0 *1 30.695,55.18 nfet_01v8
M$3634 1400 4444 167 167 nfet_01v8 L=150000U W=210000U AS=40400000000P
+ AD=21875000000P PS=560000U PD=460000U
* device instance $3635 r0 *1 30.14,55.58 nfet_01v8
M$3635 42 159 2264 167 nfet_01v8 L=150000U W=140000U AS=21875000000P
+ AD=16800000000P PS=460000U PD=380000U
* device instance $3636 r0 *1 30.66,55.58 nfet_01v8
M$3636 43 159 1400 167 nfet_01v8 L=150000U W=140000U AS=21875000000P
+ AD=16800000000P PS=460000U PD=380000U
* device instance $3637 r0 *1 30.14,55.97 nfet_01v8
M$3637 2295 160 42 167 nfet_01v8 L=150000U W=140000U AS=16800000000P
+ AD=21875000000P PS=380000U PD=460000U
* device instance $3638 r0 *1 30.66,55.97 nfet_01v8
M$3638 894 160 43 167 nfet_01v8 L=150000U W=140000U AS=16800000000P
+ AD=21875000000P PS=380000U PD=460000U
* device instance $3639 r0 *1 30.105,56.37 nfet_01v8
M$3639 167 2611 2295 167 nfet_01v8 L=150000U W=210000U AS=21875000000P
+ AD=40400000000P PS=460000U PD=560000U
* device instance $3640 r0 *1 30.695,56.37 nfet_01v8
M$3640 167 1409 894 167 nfet_01v8 L=150000U W=210000U AS=21875000000P
+ AD=40400000000P PS=460000U PD=560000U
* device instance $3641 r0 *1 30.105,56.76 nfet_01v8
M$3641 2611 2295 167 167 nfet_01v8 L=150000U W=210000U AS=40400000000P
+ AD=21875000000P PS=560000U PD=460000U
* device instance $3642 r0 *1 30.695,56.76 nfet_01v8
M$3642 1409 894 167 167 nfet_01v8 L=150000U W=210000U AS=40400000000P
+ AD=21875000000P PS=560000U PD=460000U
* device instance $3643 r0 *1 30.14,57.16 nfet_01v8
M$3643 41 160 2611 167 nfet_01v8 L=150000U W=140000U AS=21875000000P
+ AD=16800000000P PS=460000U PD=380000U
* device instance $3644 r0 *1 30.66,57.16 nfet_01v8
M$3644 44 160 1409 167 nfet_01v8 L=150000U W=140000U AS=21875000000P
+ AD=16800000000P PS=460000U PD=380000U
* device instance $3645 r0 *1 30.14,57.55 nfet_01v8
M$3645 3552 161 41 167 nfet_01v8 L=150000U W=140000U AS=16800000000P
+ AD=21875000000P PS=380000U PD=460000U
* device instance $3646 r0 *1 30.66,57.55 nfet_01v8
M$3646 933 161 44 167 nfet_01v8 L=150000U W=140000U AS=16800000000P
+ AD=21875000000P PS=380000U PD=460000U
* device instance $3647 r0 *1 30.105,57.95 nfet_01v8
M$3647 167 2616 3552 167 nfet_01v8 L=150000U W=210000U AS=21875000000P
+ AD=40400000000P PS=460000U PD=560000U
* device instance $3648 r0 *1 30.695,57.95 nfet_01v8
M$3648 167 1451 933 167 nfet_01v8 L=150000U W=210000U AS=21875000000P
+ AD=40400000000P PS=460000U PD=560000U
* device instance $3649 r0 *1 30.105,58.34 nfet_01v8
M$3649 2616 3552 167 167 nfet_01v8 L=150000U W=210000U AS=40400000000P
+ AD=21875000000P PS=560000U PD=460000U
* device instance $3650 r0 *1 30.695,58.34 nfet_01v8
M$3650 1451 933 167 167 nfet_01v8 L=150000U W=210000U AS=40400000000P
+ AD=21875000000P PS=560000U PD=460000U
* device instance $3651 r0 *1 30.14,58.74 nfet_01v8
M$3651 42 161 2616 167 nfet_01v8 L=150000U W=140000U AS=21875000000P
+ AD=16800000000P PS=460000U PD=380000U
* device instance $3652 r0 *1 30.66,58.74 nfet_01v8
M$3652 43 161 1451 167 nfet_01v8 L=150000U W=140000U AS=21875000000P
+ AD=16800000000P PS=460000U PD=380000U
* device instance $3653 r0 *1 41.04,52.81 nfet_01v8
M$3653 3489 158 58 167 nfet_01v8 L=150000U W=140000U AS=16800000000P
+ AD=21875000000P PS=380000U PD=460000U
* device instance $3654 r0 *1 41.56,52.81 nfet_01v8
M$3654 1246 158 59 167 nfet_01v8 L=150000U W=140000U AS=16800000000P
+ AD=21875000000P PS=380000U PD=460000U
* device instance $3655 r0 *1 41.005,53.21 nfet_01v8
M$3655 167 2655 3489 167 nfet_01v8 L=150000U W=210000U AS=21875000000P
+ AD=40400000000P PS=460000U PD=560000U
* device instance $3656 r0 *1 41.595,53.21 nfet_01v8
M$3656 167 1818 1246 167 nfet_01v8 L=150000U W=210000U AS=21875000000P
+ AD=40400000000P PS=460000U PD=560000U
* device instance $3657 r0 *1 41.005,53.6 nfet_01v8
M$3657 2655 3489 167 167 nfet_01v8 L=150000U W=210000U AS=40400000000P
+ AD=21875000000P PS=560000U PD=460000U
* device instance $3658 r0 *1 41.595,53.6 nfet_01v8
M$3658 1818 1246 167 167 nfet_01v8 L=150000U W=210000U AS=40400000000P
+ AD=21875000000P PS=560000U PD=460000U
* device instance $3659 r0 *1 41.04,54 nfet_01v8
M$3659 57 158 2655 167 nfet_01v8 L=150000U W=140000U AS=21875000000P
+ AD=16800000000P PS=460000U PD=380000U
* device instance $3660 r0 *1 41.56,54 nfet_01v8
M$3660 60 158 1818 167 nfet_01v8 L=150000U W=140000U AS=21875000000P
+ AD=16800000000P PS=460000U PD=380000U
* device instance $3661 r0 *1 41.04,54.39 nfet_01v8
M$3661 3532 159 57 167 nfet_01v8 L=150000U W=140000U AS=16800000000P
+ AD=21875000000P PS=380000U PD=460000U
* device instance $3662 r0 *1 41.56,54.39 nfet_01v8
M$3662 4438 159 60 167 nfet_01v8 L=150000U W=140000U AS=16800000000P
+ AD=21875000000P PS=380000U PD=460000U
* device instance $3663 r0 *1 41.005,54.79 nfet_01v8
M$3663 167 2023 3532 167 nfet_01v8 L=150000U W=210000U AS=21875000000P
+ AD=40400000000P PS=460000U PD=560000U
* device instance $3664 r0 *1 41.595,54.79 nfet_01v8
M$3664 167 1452 4438 167 nfet_01v8 L=150000U W=210000U AS=21875000000P
+ AD=40400000000P PS=460000U PD=560000U
* device instance $3665 r0 *1 41.005,55.18 nfet_01v8
M$3665 2023 3532 167 167 nfet_01v8 L=150000U W=210000U AS=40400000000P
+ AD=21875000000P PS=560000U PD=460000U
* device instance $3666 r0 *1 41.595,55.18 nfet_01v8
M$3666 1452 4438 167 167 nfet_01v8 L=150000U W=210000U AS=40400000000P
+ AD=21875000000P PS=560000U PD=460000U
* device instance $3667 r0 *1 41.04,55.58 nfet_01v8
M$3667 58 159 2023 167 nfet_01v8 L=150000U W=140000U AS=21875000000P
+ AD=16800000000P PS=460000U PD=380000U
* device instance $3668 r0 *1 41.56,55.58 nfet_01v8
M$3668 59 159 1452 167 nfet_01v8 L=150000U W=140000U AS=21875000000P
+ AD=16800000000P PS=460000U PD=380000U
* device instance $3669 r0 *1 41.04,55.97 nfet_01v8
M$3669 2087 160 58 167 nfet_01v8 L=150000U W=140000U AS=16800000000P
+ AD=21875000000P PS=380000U PD=460000U
* device instance $3670 r0 *1 41.56,55.97 nfet_01v8
M$3670 872 160 59 167 nfet_01v8 L=150000U W=140000U AS=16800000000P
+ AD=21875000000P PS=380000U PD=460000U
* device instance $3671 r0 *1 41.005,56.37 nfet_01v8
M$3671 167 2174 2087 167 nfet_01v8 L=150000U W=210000U AS=21875000000P
+ AD=40400000000P PS=460000U PD=560000U
* device instance $3672 r0 *1 41.595,56.37 nfet_01v8
M$3672 167 1380 872 167 nfet_01v8 L=150000U W=210000U AS=21875000000P
+ AD=40400000000P PS=460000U PD=560000U
* device instance $3673 r0 *1 41.005,56.76 nfet_01v8
M$3673 2174 2087 167 167 nfet_01v8 L=150000U W=210000U AS=40400000000P
+ AD=21875000000P PS=560000U PD=460000U
* device instance $3674 r0 *1 41.595,56.76 nfet_01v8
M$3674 1380 872 167 167 nfet_01v8 L=150000U W=210000U AS=40400000000P
+ AD=21875000000P PS=560000U PD=460000U
* device instance $3675 r0 *1 41.04,57.16 nfet_01v8
M$3675 57 160 2174 167 nfet_01v8 L=150000U W=140000U AS=21875000000P
+ AD=16800000000P PS=460000U PD=380000U
* device instance $3676 r0 *1 41.56,57.16 nfet_01v8
M$3676 60 160 1380 167 nfet_01v8 L=150000U W=140000U AS=21875000000P
+ AD=16800000000P PS=460000U PD=380000U
* device instance $3677 r0 *1 41.04,57.55 nfet_01v8
M$3677 2271 161 57 167 nfet_01v8 L=150000U W=140000U AS=16800000000P
+ AD=21875000000P PS=380000U PD=460000U
* device instance $3678 r0 *1 41.56,57.55 nfet_01v8
M$3678 938 161 60 167 nfet_01v8 L=150000U W=140000U AS=16800000000P
+ AD=21875000000P PS=380000U PD=460000U
* device instance $3679 r0 *1 41.005,57.95 nfet_01v8
M$3679 167 2557 2271 167 nfet_01v8 L=150000U W=210000U AS=21875000000P
+ AD=40400000000P PS=460000U PD=560000U
* device instance $3680 r0 *1 41.595,57.95 nfet_01v8
M$3680 167 1461 938 167 nfet_01v8 L=150000U W=210000U AS=21875000000P
+ AD=40400000000P PS=460000U PD=560000U
* device instance $3681 r0 *1 41.005,58.34 nfet_01v8
M$3681 2557 2271 167 167 nfet_01v8 L=150000U W=210000U AS=40400000000P
+ AD=21875000000P PS=560000U PD=460000U
* device instance $3682 r0 *1 41.595,58.34 nfet_01v8
M$3682 1461 938 167 167 nfet_01v8 L=150000U W=210000U AS=40400000000P
+ AD=21875000000P PS=560000U PD=460000U
* device instance $3683 r0 *1 41.04,58.74 nfet_01v8
M$3683 58 161 2557 167 nfet_01v8 L=150000U W=140000U AS=21875000000P
+ AD=16800000000P PS=460000U PD=380000U
* device instance $3684 r0 *1 41.56,58.74 nfet_01v8
M$3684 59 161 1461 167 nfet_01v8 L=150000U W=140000U AS=21875000000P
+ AD=16800000000P PS=460000U PD=380000U
* device instance $3685 r0 *1 51.94,52.81 nfet_01v8
M$3685 3161 158 74 167 nfet_01v8 L=150000U W=140000U AS=16800000000P
+ AD=21875000000P PS=380000U PD=460000U
* device instance $3686 r0 *1 52.46,52.81 nfet_01v8
M$3686 1061 158 75 167 nfet_01v8 L=150000U W=140000U AS=16800000000P
+ AD=21875000000P PS=380000U PD=460000U
* device instance $3687 r0 *1 51.905,53.21 nfet_01v8
M$3687 167 3121 3161 167 nfet_01v8 L=150000U W=210000U AS=21875000000P
+ AD=40400000000P PS=460000U PD=560000U
* device instance $3688 r0 *1 52.495,53.21 nfet_01v8
M$3688 167 1605 1061 167 nfet_01v8 L=150000U W=210000U AS=21875000000P
+ AD=40400000000P PS=460000U PD=560000U
* device instance $3689 r0 *1 51.905,53.6 nfet_01v8
M$3689 3121 3161 167 167 nfet_01v8 L=150000U W=210000U AS=40400000000P
+ AD=21875000000P PS=560000U PD=460000U
* device instance $3690 r0 *1 52.495,53.6 nfet_01v8
M$3690 1605 1061 167 167 nfet_01v8 L=150000U W=210000U AS=40400000000P
+ AD=21875000000P PS=560000U PD=460000U
* device instance $3691 r0 *1 51.94,54 nfet_01v8
M$3691 73 158 3121 167 nfet_01v8 L=150000U W=140000U AS=21875000000P
+ AD=16800000000P PS=460000U PD=380000U
* device instance $3692 r0 *1 52.46,54 nfet_01v8
M$3692 76 158 1605 167 nfet_01v8 L=150000U W=140000U AS=21875000000P
+ AD=16800000000P PS=460000U PD=380000U
* device instance $3693 r0 *1 51.94,54.39 nfet_01v8
M$3693 3568 159 73 167 nfet_01v8 L=150000U W=140000U AS=16800000000P
+ AD=21875000000P PS=380000U PD=460000U
* device instance $3694 r0 *1 52.46,54.39 nfet_01v8
M$3694 4346 159 76 167 nfet_01v8 L=150000U W=140000U AS=16800000000P
+ AD=21875000000P PS=380000U PD=460000U
* device instance $3695 r0 *1 51.905,54.79 nfet_01v8
M$3695 167 2134 3568 167 nfet_01v8 L=150000U W=210000U AS=21875000000P
+ AD=40400000000P PS=460000U PD=560000U
* device instance $3696 r0 *1 52.495,54.79 nfet_01v8
M$3696 167 710 4346 167 nfet_01v8 L=150000U W=210000U AS=21875000000P
+ AD=40400000000P PS=460000U PD=560000U
* device instance $3697 r0 *1 51.905,55.18 nfet_01v8
M$3697 2134 3568 167 167 nfet_01v8 L=150000U W=210000U AS=40400000000P
+ AD=21875000000P PS=560000U PD=460000U
* device instance $3698 r0 *1 52.495,55.18 nfet_01v8
M$3698 710 4346 167 167 nfet_01v8 L=150000U W=210000U AS=40400000000P
+ AD=21875000000P PS=560000U PD=460000U
* device instance $3699 r0 *1 51.94,55.58 nfet_01v8
M$3699 74 159 2134 167 nfet_01v8 L=150000U W=140000U AS=21875000000P
+ AD=16800000000P PS=460000U PD=380000U
* device instance $3700 r0 *1 52.46,55.58 nfet_01v8
M$3700 75 159 710 167 nfet_01v8 L=150000U W=140000U AS=21875000000P
+ AD=16800000000P PS=460000U PD=380000U
* device instance $3701 r0 *1 51.94,55.97 nfet_01v8
M$3701 2080 160 74 167 nfet_01v8 L=150000U W=140000U AS=16800000000P
+ AD=21875000000P PS=380000U PD=460000U
* device instance $3702 r0 *1 52.46,55.97 nfet_01v8
M$3702 1117 160 75 167 nfet_01v8 L=150000U W=140000U AS=16800000000P
+ AD=21875000000P PS=380000U PD=460000U
* device instance $3703 r0 *1 51.905,56.37 nfet_01v8
M$3703 167 2160 2080 167 nfet_01v8 L=150000U W=210000U AS=21875000000P
+ AD=40400000000P PS=460000U PD=560000U
* device instance $3704 r0 *1 52.495,56.37 nfet_01v8
M$3704 167 1672 1117 167 nfet_01v8 L=150000U W=210000U AS=21875000000P
+ AD=40400000000P PS=460000U PD=560000U
* device instance $3705 r0 *1 51.905,56.76 nfet_01v8
M$3705 2160 2080 167 167 nfet_01v8 L=150000U W=210000U AS=40400000000P
+ AD=21875000000P PS=560000U PD=460000U
* device instance $3706 r0 *1 52.495,56.76 nfet_01v8
M$3706 1672 1117 167 167 nfet_01v8 L=150000U W=210000U AS=40400000000P
+ AD=21875000000P PS=560000U PD=460000U
* device instance $3707 r0 *1 51.94,57.16 nfet_01v8
M$3707 73 160 2160 167 nfet_01v8 L=150000U W=140000U AS=21875000000P
+ AD=16800000000P PS=460000U PD=380000U
* device instance $3708 r0 *1 52.46,57.16 nfet_01v8
M$3708 76 160 1672 167 nfet_01v8 L=150000U W=140000U AS=21875000000P
+ AD=16800000000P PS=460000U PD=380000U
* device instance $3709 r0 *1 51.94,57.55 nfet_01v8
M$3709 2318 161 73 167 nfet_01v8 L=150000U W=140000U AS=16800000000P
+ AD=21875000000P PS=380000U PD=460000U
* device instance $3710 r0 *1 52.46,57.55 nfet_01v8
M$3710 1182 161 76 167 nfet_01v8 L=150000U W=140000U AS=16800000000P
+ AD=21875000000P PS=380000U PD=460000U
* device instance $3711 r0 *1 51.905,57.95 nfet_01v8
M$3711 167 2653 2318 167 nfet_01v8 L=150000U W=210000U AS=21875000000P
+ AD=40400000000P PS=460000U PD=560000U
* device instance $3712 r0 *1 52.495,57.95 nfet_01v8
M$3712 167 1745 1182 167 nfet_01v8 L=150000U W=210000U AS=21875000000P
+ AD=40400000000P PS=460000U PD=560000U
* device instance $3713 r0 *1 51.905,58.34 nfet_01v8
M$3713 2653 2318 167 167 nfet_01v8 L=150000U W=210000U AS=40400000000P
+ AD=21875000000P PS=560000U PD=460000U
* device instance $3714 r0 *1 52.495,58.34 nfet_01v8
M$3714 1745 1182 167 167 nfet_01v8 L=150000U W=210000U AS=40400000000P
+ AD=21875000000P PS=560000U PD=460000U
* device instance $3715 r0 *1 51.94,58.74 nfet_01v8
M$3715 74 161 2653 167 nfet_01v8 L=150000U W=140000U AS=21875000000P
+ AD=16800000000P PS=460000U PD=380000U
* device instance $3716 r0 *1 52.46,58.74 nfet_01v8
M$3716 75 161 1745 167 nfet_01v8 L=150000U W=140000U AS=21875000000P
+ AD=16800000000P PS=460000U PD=380000U
* device instance $3717 r0 *1 62.84,52.81 nfet_01v8
M$3717 3167 158 90 167 nfet_01v8 L=150000U W=140000U AS=16800000000P
+ AD=21875000000P PS=380000U PD=460000U
* device instance $3718 r0 *1 63.36,52.81 nfet_01v8
M$3718 1058 158 91 167 nfet_01v8 L=150000U W=140000U AS=16800000000P
+ AD=21875000000P PS=380000U PD=460000U
* device instance $3719 r0 *1 62.805,53.21 nfet_01v8
M$3719 167 3059 3167 167 nfet_01v8 L=150000U W=210000U AS=21875000000P
+ AD=40400000000P PS=460000U PD=560000U
* device instance $3720 r0 *1 63.395,53.21 nfet_01v8
M$3720 167 1602 1058 167 nfet_01v8 L=150000U W=210000U AS=21875000000P
+ AD=40400000000P PS=460000U PD=560000U
* device instance $3721 r0 *1 62.805,53.6 nfet_01v8
M$3721 3059 3167 167 167 nfet_01v8 L=150000U W=210000U AS=40400000000P
+ AD=21875000000P PS=560000U PD=460000U
* device instance $3722 r0 *1 63.395,53.6 nfet_01v8
M$3722 1602 1058 167 167 nfet_01v8 L=150000U W=210000U AS=40400000000P
+ AD=21875000000P PS=560000U PD=460000U
* device instance $3723 r0 *1 62.84,54 nfet_01v8
M$3723 89 158 3059 167 nfet_01v8 L=150000U W=140000U AS=21875000000P
+ AD=16800000000P PS=460000U PD=380000U
* device instance $3724 r0 *1 63.36,54 nfet_01v8
M$3724 92 158 1602 167 nfet_01v8 L=150000U W=140000U AS=21875000000P
+ AD=16800000000P PS=460000U PD=380000U
* device instance $3725 r0 *1 62.84,54.39 nfet_01v8
M$3725 3579 159 89 167 nfet_01v8 L=150000U W=140000U AS=16800000000P
+ AD=21875000000P PS=380000U PD=460000U
* device instance $3726 r0 *1 63.36,54.39 nfet_01v8
M$3726 4344 159 92 167 nfet_01v8 L=150000U W=140000U AS=16800000000P
+ AD=21875000000P PS=380000U PD=460000U
* device instance $3727 r0 *1 62.805,54.79 nfet_01v8
M$3727 167 2251 3579 167 nfet_01v8 L=150000U W=210000U AS=21875000000P
+ AD=40400000000P PS=460000U PD=560000U
* device instance $3728 r0 *1 63.395,54.79 nfet_01v8
M$3728 167 1662 4344 167 nfet_01v8 L=150000U W=210000U AS=21875000000P
+ AD=40400000000P PS=460000U PD=560000U
* device instance $3729 r0 *1 62.805,55.18 nfet_01v8
M$3729 2251 3579 167 167 nfet_01v8 L=150000U W=210000U AS=40400000000P
+ AD=21875000000P PS=560000U PD=460000U
* device instance $3730 r0 *1 63.395,55.18 nfet_01v8
M$3730 1662 4344 167 167 nfet_01v8 L=150000U W=210000U AS=40400000000P
+ AD=21875000000P PS=560000U PD=460000U
* device instance $3731 r0 *1 62.84,55.58 nfet_01v8
M$3731 90 159 2251 167 nfet_01v8 L=150000U W=140000U AS=21875000000P
+ AD=16800000000P PS=460000U PD=380000U
* device instance $3732 r0 *1 63.36,55.58 nfet_01v8
M$3732 91 159 1662 167 nfet_01v8 L=150000U W=140000U AS=21875000000P
+ AD=16800000000P PS=460000U PD=380000U
* device instance $3733 r0 *1 62.84,55.97 nfet_01v8
M$3733 3577 160 90 167 nfet_01v8 L=150000U W=140000U AS=16800000000P
+ AD=21875000000P PS=380000U PD=460000U
* device instance $3734 r0 *1 63.36,55.97 nfet_01v8
M$3734 1077 160 91 167 nfet_01v8 L=150000U W=140000U AS=16800000000P
+ AD=21875000000P PS=380000U PD=460000U
* device instance $3735 r0 *1 62.805,56.37 nfet_01v8
M$3735 167 2548 3577 167 nfet_01v8 L=150000U W=210000U AS=21875000000P
+ AD=40400000000P PS=460000U PD=560000U
* device instance $3736 r0 *1 63.395,56.37 nfet_01v8
M$3736 167 1622 1077 167 nfet_01v8 L=150000U W=210000U AS=21875000000P
+ AD=40400000000P PS=460000U PD=560000U
* device instance $3737 r0 *1 62.805,56.76 nfet_01v8
M$3737 2548 3577 167 167 nfet_01v8 L=150000U W=210000U AS=40400000000P
+ AD=21875000000P PS=560000U PD=460000U
* device instance $3738 r0 *1 63.395,56.76 nfet_01v8
M$3738 1622 1077 167 167 nfet_01v8 L=150000U W=210000U AS=40400000000P
+ AD=21875000000P PS=560000U PD=460000U
* device instance $3739 r0 *1 62.84,57.16 nfet_01v8
M$3739 89 160 2548 167 nfet_01v8 L=150000U W=140000U AS=21875000000P
+ AD=16800000000P PS=460000U PD=380000U
* device instance $3740 r0 *1 63.36,57.16 nfet_01v8
M$3740 92 160 1622 167 nfet_01v8 L=150000U W=140000U AS=21875000000P
+ AD=16800000000P PS=460000U PD=380000U
* device instance $3741 r0 *1 62.84,57.55 nfet_01v8
M$3741 2270 161 89 167 nfet_01v8 L=150000U W=140000U AS=16800000000P
+ AD=21875000000P PS=380000U PD=460000U
* device instance $3742 r0 *1 63.36,57.55 nfet_01v8
M$3742 1074 161 92 167 nfet_01v8 L=150000U W=140000U AS=16800000000P
+ AD=21875000000P PS=380000U PD=460000U
* device instance $3743 r0 *1 62.805,57.95 nfet_01v8
M$3743 167 2554 2270 167 nfet_01v8 L=150000U W=210000U AS=21875000000P
+ AD=40400000000P PS=460000U PD=560000U
* device instance $3744 r0 *1 63.395,57.95 nfet_01v8
M$3744 167 1619 1074 167 nfet_01v8 L=150000U W=210000U AS=21875000000P
+ AD=40400000000P PS=460000U PD=560000U
* device instance $3745 r0 *1 62.805,58.34 nfet_01v8
M$3745 2554 2270 167 167 nfet_01v8 L=150000U W=210000U AS=40400000000P
+ AD=21875000000P PS=560000U PD=460000U
* device instance $3746 r0 *1 63.395,58.34 nfet_01v8
M$3746 1619 1074 167 167 nfet_01v8 L=150000U W=210000U AS=40400000000P
+ AD=21875000000P PS=560000U PD=460000U
* device instance $3747 r0 *1 62.84,58.74 nfet_01v8
M$3747 90 161 2554 167 nfet_01v8 L=150000U W=140000U AS=21875000000P
+ AD=16800000000P PS=460000U PD=380000U
* device instance $3748 r0 *1 63.36,58.74 nfet_01v8
M$3748 91 161 1619 167 nfet_01v8 L=150000U W=140000U AS=21875000000P
+ AD=16800000000P PS=460000U PD=380000U
* device instance $3749 r0 *1 8.34,52.81 nfet_01v8
M$3749 3490 158 10 167 nfet_01v8 L=150000U W=140000U AS=16800000000P
+ AD=21875000000P PS=380000U PD=460000U
* device instance $3750 r0 *1 8.86,52.81 nfet_01v8
M$3750 1257 158 11 167 nfet_01v8 L=150000U W=140000U AS=16800000000P
+ AD=21875000000P PS=380000U PD=460000U
* device instance $3751 r0 *1 8.305,53.21 nfet_01v8
M$3751 167 2660 3490 167 nfet_01v8 L=150000U W=210000U AS=21875000000P
+ AD=40400000000P PS=460000U PD=560000U
* device instance $3752 r0 *1 8.895,53.21 nfet_01v8
M$3752 167 1833 1257 167 nfet_01v8 L=150000U W=210000U AS=21875000000P
+ AD=40400000000P PS=460000U PD=560000U
* device instance $3753 r0 *1 8.305,53.6 nfet_01v8
M$3753 2660 3490 167 167 nfet_01v8 L=150000U W=210000U AS=40400000000P
+ AD=21875000000P PS=560000U PD=460000U
* device instance $3754 r0 *1 8.895,53.6 nfet_01v8
M$3754 1833 1257 167 167 nfet_01v8 L=150000U W=210000U AS=40400000000P
+ AD=21875000000P PS=560000U PD=460000U
* device instance $3755 r0 *1 8.34,54 nfet_01v8
M$3755 9 158 2660 167 nfet_01v8 L=150000U W=140000U AS=21875000000P
+ AD=16800000000P PS=460000U PD=380000U
* device instance $3756 r0 *1 8.86,54 nfet_01v8
M$3756 12 158 1833 167 nfet_01v8 L=150000U W=140000U AS=21875000000P
+ AD=16800000000P PS=460000U PD=380000U
* device instance $3757 r0 *1 8.34,54.39 nfet_01v8
M$3757 3692 159 9 167 nfet_01v8 L=150000U W=140000U AS=16800000000P
+ AD=21875000000P PS=380000U PD=460000U
* device instance $3758 r0 *1 8.86,54.39 nfet_01v8
M$3758 4434 159 12 167 nfet_01v8 L=150000U W=140000U AS=16800000000P
+ AD=21875000000P PS=380000U PD=460000U
* device instance $3759 r0 *1 8.305,54.79 nfet_01v8
M$3759 167 1978 3692 167 nfet_01v8 L=150000U W=210000U AS=21875000000P
+ AD=40400000000P PS=460000U PD=560000U
* device instance $3760 r0 *1 8.895,54.79 nfet_01v8
M$3760 167 1453 4434 167 nfet_01v8 L=150000U W=210000U AS=21875000000P
+ AD=40400000000P PS=460000U PD=560000U
* device instance $3761 r0 *1 8.305,55.18 nfet_01v8
M$3761 1978 3692 167 167 nfet_01v8 L=150000U W=210000U AS=40400000000P
+ AD=21875000000P PS=560000U PD=460000U
* device instance $3762 r0 *1 8.895,55.18 nfet_01v8
M$3762 1453 4434 167 167 nfet_01v8 L=150000U W=210000U AS=40400000000P
+ AD=21875000000P PS=560000U PD=460000U
* device instance $3763 r0 *1 8.34,55.58 nfet_01v8
M$3763 10 159 1978 167 nfet_01v8 L=150000U W=140000U AS=21875000000P
+ AD=16800000000P PS=460000U PD=380000U
* device instance $3764 r0 *1 8.86,55.58 nfet_01v8
M$3764 11 159 1453 167 nfet_01v8 L=150000U W=140000U AS=21875000000P
+ AD=16800000000P PS=460000U PD=380000U
* device instance $3765 r0 *1 8.34,55.97 nfet_01v8
M$3765 3694 160 10 167 nfet_01v8 L=150000U W=140000U AS=16800000000P
+ AD=21875000000P PS=380000U PD=460000U
* device instance $3766 r0 *1 8.86,55.97 nfet_01v8
M$3766 647 160 11 167 nfet_01v8 L=150000U W=140000U AS=16800000000P
+ AD=21875000000P PS=380000U PD=460000U
* device instance $3767 r0 *1 8.305,56.37 nfet_01v8
M$3767 167 2259 3694 167 nfet_01v8 L=150000U W=210000U AS=21875000000P
+ AD=40400000000P PS=460000U PD=560000U
* device instance $3768 r0 *1 8.895,56.37 nfet_01v8
M$3768 167 811 647 167 nfet_01v8 L=150000U W=210000U AS=21875000000P
+ AD=40400000000P PS=460000U PD=560000U
* device instance $3769 r0 *1 8.305,56.76 nfet_01v8
M$3769 2259 3694 167 167 nfet_01v8 L=150000U W=210000U AS=40400000000P
+ AD=21875000000P PS=560000U PD=460000U
* device instance $3770 r0 *1 8.895,56.76 nfet_01v8
M$3770 811 647 167 167 nfet_01v8 L=150000U W=210000U AS=40400000000P
+ AD=21875000000P PS=560000U PD=460000U
* device instance $3771 r0 *1 8.34,57.16 nfet_01v8
M$3771 9 160 2259 167 nfet_01v8 L=150000U W=140000U AS=21875000000P
+ AD=16800000000P PS=460000U PD=380000U
* device instance $3772 r0 *1 8.86,57.16 nfet_01v8
M$3772 12 160 811 167 nfet_01v8 L=150000U W=140000U AS=21875000000P
+ AD=16800000000P PS=460000U PD=380000U
* device instance $3773 r0 *1 8.34,57.55 nfet_01v8
M$3773 3717 161 9 167 nfet_01v8 L=150000U W=140000U AS=16800000000P
+ AD=21875000000P PS=380000U PD=460000U
* device instance $3774 r0 *1 8.86,57.55 nfet_01v8
M$3774 902 161 12 167 nfet_01v8 L=150000U W=140000U AS=16800000000P
+ AD=21875000000P PS=380000U PD=460000U
* device instance $3775 r0 *1 8.305,57.95 nfet_01v8
M$3775 167 2944 3717 167 nfet_01v8 L=150000U W=210000U AS=21875000000P
+ AD=40400000000P PS=460000U PD=560000U
* device instance $3776 r0 *1 8.895,57.95 nfet_01v8
M$3776 167 1419 902 167 nfet_01v8 L=150000U W=210000U AS=21875000000P
+ AD=40400000000P PS=460000U PD=560000U
* device instance $3777 r0 *1 8.305,58.34 nfet_01v8
M$3777 2944 3717 167 167 nfet_01v8 L=150000U W=210000U AS=40400000000P
+ AD=21875000000P PS=560000U PD=460000U
* device instance $3778 r0 *1 8.895,58.34 nfet_01v8
M$3778 1419 902 167 167 nfet_01v8 L=150000U W=210000U AS=40400000000P
+ AD=21875000000P PS=560000U PD=460000U
* device instance $3779 r0 *1 8.34,58.74 nfet_01v8
M$3779 10 161 2944 167 nfet_01v8 L=150000U W=140000U AS=21875000000P
+ AD=16800000000P PS=460000U PD=380000U
* device instance $3780 r0 *1 8.86,58.74 nfet_01v8
M$3780 11 161 1419 167 nfet_01v8 L=150000U W=140000U AS=21875000000P
+ AD=16800000000P PS=460000U PD=380000U
* device instance $3781 r0 *1 73.74,52.81 nfet_01v8
M$3781 2522 158 106 167 nfet_01v8 L=150000U W=140000U AS=16800000000P
+ AD=21875000000P PS=380000U PD=460000U
* device instance $3782 r0 *1 74.26,52.81 nfet_01v8
M$3782 1091 158 107 167 nfet_01v8 L=150000U W=140000U AS=16800000000P
+ AD=21875000000P PS=380000U PD=460000U
* device instance $3783 r0 *1 73.705,53.21 nfet_01v8
M$3783 167 3080 2522 167 nfet_01v8 L=150000U W=210000U AS=21875000000P
+ AD=40400000000P PS=460000U PD=560000U
* device instance $3784 r0 *1 74.295,53.21 nfet_01v8
M$3784 167 1637 1091 167 nfet_01v8 L=150000U W=210000U AS=21875000000P
+ AD=40400000000P PS=460000U PD=560000U
* device instance $3785 r0 *1 73.705,53.6 nfet_01v8
M$3785 3080 2522 167 167 nfet_01v8 L=150000U W=210000U AS=40400000000P
+ AD=21875000000P PS=560000U PD=460000U
* device instance $3786 r0 *1 74.295,53.6 nfet_01v8
M$3786 1637 1091 167 167 nfet_01v8 L=150000U W=210000U AS=40400000000P
+ AD=21875000000P PS=560000U PD=460000U
* device instance $3787 r0 *1 73.74,54 nfet_01v8
M$3787 105 158 3080 167 nfet_01v8 L=150000U W=140000U AS=21875000000P
+ AD=16800000000P PS=460000U PD=380000U
* device instance $3788 r0 *1 74.26,54 nfet_01v8
M$3788 108 158 1637 167 nfet_01v8 L=150000U W=140000U AS=21875000000P
+ AD=16800000000P PS=460000U PD=380000U
* device instance $3789 r0 *1 73.74,54.39 nfet_01v8
M$3789 3132 159 105 167 nfet_01v8 L=150000U W=140000U AS=16800000000P
+ AD=21875000000P PS=380000U PD=460000U
* device instance $3790 r0 *1 74.26,54.39 nfet_01v8
M$3790 4530 159 108 167 nfet_01v8 L=150000U W=140000U AS=16800000000P
+ AD=21875000000P PS=380000U PD=460000U
* device instance $3791 r0 *1 73.705,54.79 nfet_01v8
M$3791 167 1996 3132 167 nfet_01v8 L=150000U W=210000U AS=21875000000P
+ AD=40400000000P PS=460000U PD=560000U
* device instance $3792 r0 *1 74.295,54.79 nfet_01v8
M$3792 167 686 4530 167 nfet_01v8 L=150000U W=210000U AS=21875000000P
+ AD=40400000000P PS=460000U PD=560000U
* device instance $3793 r0 *1 73.705,55.18 nfet_01v8
M$3793 1996 3132 167 167 nfet_01v8 L=150000U W=210000U AS=40400000000P
+ AD=21875000000P PS=560000U PD=460000U
* device instance $3794 r0 *1 74.295,55.18 nfet_01v8
M$3794 686 4530 167 167 nfet_01v8 L=150000U W=210000U AS=40400000000P
+ AD=21875000000P PS=560000U PD=460000U
* device instance $3795 r0 *1 73.74,55.58 nfet_01v8
M$3795 106 159 1996 167 nfet_01v8 L=150000U W=140000U AS=21875000000P
+ AD=16800000000P PS=460000U PD=380000U
* device instance $3796 r0 *1 74.26,55.58 nfet_01v8
M$3796 107 159 686 167 nfet_01v8 L=150000U W=140000U AS=21875000000P
+ AD=16800000000P PS=460000U PD=380000U
* device instance $3797 r0 *1 73.74,55.97 nfet_01v8
M$3797 2399 160 106 167 nfet_01v8 L=150000U W=140000U AS=16800000000P
+ AD=21875000000P PS=380000U PD=460000U
* device instance $3798 r0 *1 74.26,55.97 nfet_01v8
M$3798 653 160 107 167 nfet_01v8 L=150000U W=140000U AS=16800000000P
+ AD=21875000000P PS=380000U PD=460000U
* device instance $3799 r0 *1 73.705,56.37 nfet_01v8
M$3799 167 2814 2399 167 nfet_01v8 L=150000U W=210000U AS=21875000000P
+ AD=40400000000P PS=460000U PD=560000U
* device instance $3800 r0 *1 74.295,56.37 nfet_01v8
M$3800 167 830 653 167 nfet_01v8 L=150000U W=210000U AS=21875000000P
+ AD=40400000000P PS=460000U PD=560000U
* device instance $3801 r0 *1 73.705,56.76 nfet_01v8
M$3801 2814 2399 167 167 nfet_01v8 L=150000U W=210000U AS=40400000000P
+ AD=21875000000P PS=560000U PD=460000U
* device instance $3802 r0 *1 74.295,56.76 nfet_01v8
M$3802 830 653 167 167 nfet_01v8 L=150000U W=210000U AS=40400000000P
+ AD=21875000000P PS=560000U PD=460000U
* device instance $3803 r0 *1 73.74,57.16 nfet_01v8
M$3803 105 160 2814 167 nfet_01v8 L=150000U W=140000U AS=21875000000P
+ AD=16800000000P PS=460000U PD=380000U
* device instance $3804 r0 *1 74.26,57.16 nfet_01v8
M$3804 108 160 830 167 nfet_01v8 L=150000U W=140000U AS=21875000000P
+ AD=16800000000P PS=460000U PD=380000U
* device instance $3805 r0 *1 73.74,57.55 nfet_01v8
M$3805 3138 161 105 167 nfet_01v8 L=150000U W=140000U AS=16800000000P
+ AD=21875000000P PS=380000U PD=460000U
* device instance $3806 r0 *1 74.26,57.55 nfet_01v8
M$3806 1358 161 108 167 nfet_01v8 L=150000U W=140000U AS=16800000000P
+ AD=21875000000P PS=380000U PD=460000U
* device instance $3807 r0 *1 73.705,57.95 nfet_01v8
M$3807 167 2866 3138 167 nfet_01v8 L=150000U W=210000U AS=21875000000P
+ AD=40400000000P PS=460000U PD=560000U
* device instance $3808 r0 *1 74.295,57.95 nfet_01v8
M$3808 167 1947 1358 167 nfet_01v8 L=150000U W=210000U AS=21875000000P
+ AD=40400000000P PS=460000U PD=560000U
* device instance $3809 r0 *1 73.705,58.34 nfet_01v8
M$3809 2866 3138 167 167 nfet_01v8 L=150000U W=210000U AS=40400000000P
+ AD=21875000000P PS=560000U PD=460000U
* device instance $3810 r0 *1 74.295,58.34 nfet_01v8
M$3810 1947 1358 167 167 nfet_01v8 L=150000U W=210000U AS=40400000000P
+ AD=21875000000P PS=560000U PD=460000U
* device instance $3811 r0 *1 73.74,58.74 nfet_01v8
M$3811 106 161 2866 167 nfet_01v8 L=150000U W=140000U AS=21875000000P
+ AD=16800000000P PS=460000U PD=380000U
* device instance $3812 r0 *1 74.26,58.74 nfet_01v8
M$3812 107 161 1947 167 nfet_01v8 L=150000U W=140000U AS=21875000000P
+ AD=16800000000P PS=460000U PD=380000U
* device instance $3813 r0 *1 62.84,44.91 nfet_01v8
M$3813 2276 154 90 167 nfet_01v8 L=150000U W=140000U AS=16800000000P
+ AD=21875000000P PS=380000U PD=460000U
* device instance $3814 r0 *1 63.36,44.91 nfet_01v8
M$3814 1130 154 91 167 nfet_01v8 L=150000U W=140000U AS=16800000000P
+ AD=21875000000P PS=380000U PD=460000U
* device instance $3815 r0 *1 62.805,45.31 nfet_01v8
M$3815 167 2574 2276 167 nfet_01v8 L=150000U W=210000U AS=21875000000P
+ AD=40400000000P PS=460000U PD=560000U
* device instance $3816 r0 *1 63.395,45.31 nfet_01v8
M$3816 167 1685 1130 167 nfet_01v8 L=150000U W=210000U AS=21875000000P
+ AD=40400000000P PS=460000U PD=560000U
* device instance $3817 r0 *1 62.805,45.7 nfet_01v8
M$3817 2574 2276 167 167 nfet_01v8 L=150000U W=210000U AS=40400000000P
+ AD=21875000000P PS=560000U PD=460000U
* device instance $3818 r0 *1 63.395,45.7 nfet_01v8
M$3818 1685 1130 167 167 nfet_01v8 L=150000U W=210000U AS=40400000000P
+ AD=21875000000P PS=560000U PD=460000U
* device instance $3819 r0 *1 62.84,46.1 nfet_01v8
M$3819 89 154 2574 167 nfet_01v8 L=150000U W=140000U AS=21875000000P
+ AD=16800000000P PS=460000U PD=380000U
* device instance $3820 r0 *1 63.36,46.1 nfet_01v8
M$3820 92 154 1685 167 nfet_01v8 L=150000U W=140000U AS=21875000000P
+ AD=16800000000P PS=460000U PD=380000U
* device instance $3821 r0 *1 62.84,46.49 nfet_01v8
M$3821 3553 155 89 167 nfet_01v8 L=150000U W=140000U AS=16800000000P
+ AD=21875000000P PS=380000U PD=460000U
* device instance $3822 r0 *1 63.36,46.49 nfet_01v8
M$3822 4324 155 92 167 nfet_01v8 L=150000U W=140000U AS=16800000000P
+ AD=21875000000P PS=380000U PD=460000U
* device instance $3823 r0 *1 62.805,46.89 nfet_01v8
M$3823 167 2192 3553 167 nfet_01v8 L=150000U W=210000U AS=21875000000P
+ AD=40400000000P PS=460000U PD=560000U
* device instance $3824 r0 *1 63.395,46.89 nfet_01v8
M$3824 167 1725 4324 167 nfet_01v8 L=150000U W=210000U AS=21875000000P
+ AD=40400000000P PS=460000U PD=560000U
* device instance $3825 r0 *1 62.805,47.28 nfet_01v8
M$3825 2192 3553 167 167 nfet_01v8 L=150000U W=210000U AS=40400000000P
+ AD=21875000000P PS=560000U PD=460000U
* device instance $3826 r0 *1 63.395,47.28 nfet_01v8
M$3826 1725 4324 167 167 nfet_01v8 L=150000U W=210000U AS=40400000000P
+ AD=21875000000P PS=560000U PD=460000U
* device instance $3827 r0 *1 62.84,47.68 nfet_01v8
M$3827 90 155 2192 167 nfet_01v8 L=150000U W=140000U AS=21875000000P
+ AD=16800000000P PS=460000U PD=380000U
* device instance $3828 r0 *1 63.36,47.68 nfet_01v8
M$3828 91 155 1725 167 nfet_01v8 L=150000U W=140000U AS=21875000000P
+ AD=16800000000P PS=460000U PD=380000U
* device instance $3829 r0 *1 62.84,48.07 nfet_01v8
M$3829 2092 156 90 167 nfet_01v8 L=150000U W=140000U AS=16800000000P
+ AD=21875000000P PS=380000U PD=460000U
* device instance $3830 r0 *1 63.36,48.07 nfet_01v8
M$3830 603 156 91 167 nfet_01v8 L=150000U W=140000U AS=16800000000P
+ AD=21875000000P PS=380000U PD=460000U
* device instance $3831 r0 *1 62.805,48.47 nfet_01v8
M$3831 167 2185 2092 167 nfet_01v8 L=150000U W=210000U AS=21875000000P
+ AD=40400000000P PS=460000U PD=560000U
* device instance $3832 r0 *1 63.395,48.47 nfet_01v8
M$3832 167 726 603 167 nfet_01v8 L=150000U W=210000U AS=21875000000P
+ AD=40400000000P PS=460000U PD=560000U
* device instance $3833 r0 *1 62.805,48.86 nfet_01v8
M$3833 2185 2092 167 167 nfet_01v8 L=150000U W=210000U AS=40400000000P
+ AD=21875000000P PS=560000U PD=460000U
* device instance $3834 r0 *1 63.395,48.86 nfet_01v8
M$3834 726 603 167 167 nfet_01v8 L=150000U W=210000U AS=40400000000P
+ AD=21875000000P PS=560000U PD=460000U
* device instance $3835 r0 *1 62.84,49.26 nfet_01v8
M$3835 89 156 2185 167 nfet_01v8 L=150000U W=140000U AS=21875000000P
+ AD=16800000000P PS=460000U PD=380000U
* device instance $3836 r0 *1 63.36,49.26 nfet_01v8
M$3836 92 156 726 167 nfet_01v8 L=150000U W=140000U AS=21875000000P
+ AD=16800000000P PS=460000U PD=380000U
* device instance $3837 r0 *1 62.84,49.65 nfet_01v8
M$3837 2269 157 89 167 nfet_01v8 L=150000U W=140000U AS=16800000000P
+ AD=21875000000P PS=380000U PD=460000U
* device instance $3838 r0 *1 63.36,49.65 nfet_01v8
M$3838 1162 157 92 167 nfet_01v8 L=150000U W=140000U AS=16800000000P
+ AD=21875000000P PS=380000U PD=460000U
* device instance $3839 r0 *1 62.805,50.05 nfet_01v8
M$3839 167 2551 2269 167 nfet_01v8 L=150000U W=210000U AS=21875000000P
+ AD=40400000000P PS=460000U PD=560000U
* device instance $3840 r0 *1 63.395,50.05 nfet_01v8
M$3840 167 1722 1162 167 nfet_01v8 L=150000U W=210000U AS=21875000000P
+ AD=40400000000P PS=460000U PD=560000U
* device instance $3841 r0 *1 62.805,50.44 nfet_01v8
M$3841 2551 2269 167 167 nfet_01v8 L=150000U W=210000U AS=40400000000P
+ AD=21875000000P PS=560000U PD=460000U
* device instance $3842 r0 *1 63.395,50.44 nfet_01v8
M$3842 1722 1162 167 167 nfet_01v8 L=150000U W=210000U AS=40400000000P
+ AD=21875000000P PS=560000U PD=460000U
* device instance $3843 r0 *1 62.84,50.84 nfet_01v8
M$3843 90 157 2551 167 nfet_01v8 L=150000U W=140000U AS=21875000000P
+ AD=16800000000P PS=460000U PD=380000U
* device instance $3844 r0 *1 63.36,50.84 nfet_01v8
M$3844 91 157 1722 167 nfet_01v8 L=150000U W=140000U AS=21875000000P
+ AD=16800000000P PS=460000U PD=380000U
* device instance $3845 r0 *1 8.34,29.11 nfet_01v8
M$3845 2417 146 10 167 nfet_01v8 L=150000U W=140000U AS=16800000000P
+ AD=21875000000P PS=380000U PD=460000U
* device instance $3846 r0 *1 8.86,29.11 nfet_01v8
M$3846 1344 146 11 167 nfet_01v8 L=150000U W=140000U AS=16800000000P
+ AD=21875000000P PS=380000U PD=460000U
* device instance $3847 r0 *1 8.305,29.51 nfet_01v8
M$3847 167 2843 2417 167 nfet_01v8 L=150000U W=210000U AS=21875000000P
+ AD=40400000000P PS=460000U PD=560000U
* device instance $3848 r0 *1 8.895,29.51 nfet_01v8
M$3848 167 1931 1344 167 nfet_01v8 L=150000U W=210000U AS=21875000000P
+ AD=40400000000P PS=460000U PD=560000U
* device instance $3849 r0 *1 8.305,29.9 nfet_01v8
M$3849 2843 2417 167 167 nfet_01v8 L=150000U W=210000U AS=40400000000P
+ AD=21875000000P PS=560000U PD=460000U
* device instance $3850 r0 *1 8.895,29.9 nfet_01v8
M$3850 1931 1344 167 167 nfet_01v8 L=150000U W=210000U AS=40400000000P
+ AD=21875000000P PS=560000U PD=460000U
* device instance $3851 r0 *1 8.34,30.3 nfet_01v8
M$3851 9 146 2843 167 nfet_01v8 L=150000U W=140000U AS=21875000000P
+ AD=16800000000P PS=460000U PD=380000U
* device instance $3852 r0 *1 8.86,30.3 nfet_01v8
M$3852 12 146 1931 167 nfet_01v8 L=150000U W=140000U AS=21875000000P
+ AD=16800000000P PS=460000U PD=380000U
* device instance $3853 r0 *1 8.34,30.69 nfet_01v8
M$3853 3269 147 9 167 nfet_01v8 L=150000U W=140000U AS=16800000000P
+ AD=21875000000P PS=380000U PD=460000U
* device instance $3854 r0 *1 8.86,30.69 nfet_01v8
M$3854 4541 147 12 167 nfet_01v8 L=150000U W=140000U AS=16800000000P
+ AD=21875000000P PS=380000U PD=460000U
* device instance $3855 r0 *1 8.305,31.09 nfet_01v8
M$3855 167 2846 3269 167 nfet_01v8 L=150000U W=210000U AS=21875000000P
+ AD=40400000000P PS=460000U PD=560000U
* device instance $3856 r0 *1 8.895,31.09 nfet_01v8
M$3856 167 1929 4541 167 nfet_01v8 L=150000U W=210000U AS=21875000000P
+ AD=40400000000P PS=460000U PD=560000U
* device instance $3857 r0 *1 8.305,31.48 nfet_01v8
M$3857 2846 3269 167 167 nfet_01v8 L=150000U W=210000U AS=40400000000P
+ AD=21875000000P PS=560000U PD=460000U
* device instance $3858 r0 *1 8.895,31.48 nfet_01v8
M$3858 1929 4541 167 167 nfet_01v8 L=150000U W=210000U AS=40400000000P
+ AD=21875000000P PS=560000U PD=460000U
* device instance $3859 r0 *1 8.34,31.88 nfet_01v8
M$3859 10 147 2846 167 nfet_01v8 L=150000U W=140000U AS=21875000000P
+ AD=16800000000P PS=460000U PD=380000U
* device instance $3860 r0 *1 8.86,31.88 nfet_01v8
M$3860 11 147 1929 167 nfet_01v8 L=150000U W=140000U AS=21875000000P
+ AD=16800000000P PS=460000U PD=380000U
* device instance $3861 r0 *1 8.34,32.27 nfet_01v8
M$3861 2110 148 10 167 nfet_01v8 L=150000U W=140000U AS=16800000000P
+ AD=21875000000P PS=380000U PD=460000U
* device instance $3862 r0 *1 8.86,32.27 nfet_01v8
M$3862 668 148 11 167 nfet_01v8 L=150000U W=140000U AS=16800000000P
+ AD=21875000000P PS=380000U PD=460000U
* device instance $3863 r0 *1 8.305,32.67 nfet_01v8
M$3863 167 2225 2110 167 nfet_01v8 L=150000U W=210000U AS=21875000000P
+ AD=40400000000P PS=460000U PD=560000U
* device instance $3864 r0 *1 8.895,32.67 nfet_01v8
M$3864 167 858 668 167 nfet_01v8 L=150000U W=210000U AS=21875000000P
+ AD=40400000000P PS=460000U PD=560000U
* device instance $3865 r0 *1 8.305,33.06 nfet_01v8
M$3865 2225 2110 167 167 nfet_01v8 L=150000U W=210000U AS=40400000000P
+ AD=21875000000P PS=560000U PD=460000U
* device instance $3866 r0 *1 8.895,33.06 nfet_01v8
M$3866 858 668 167 167 nfet_01v8 L=150000U W=210000U AS=40400000000P
+ AD=21875000000P PS=560000U PD=460000U
* device instance $3867 r0 *1 8.34,33.46 nfet_01v8
M$3867 9 148 2225 167 nfet_01v8 L=150000U W=140000U AS=21875000000P
+ AD=16800000000P PS=460000U PD=380000U
* device instance $3868 r0 *1 8.86,33.46 nfet_01v8
M$3868 12 148 858 167 nfet_01v8 L=150000U W=140000U AS=21875000000P
+ AD=16800000000P PS=460000U PD=380000U
* device instance $3869 r0 *1 8.34,33.85 nfet_01v8
M$3869 2420 149 9 167 nfet_01v8 L=150000U W=140000U AS=16800000000P
+ AD=21875000000P PS=380000U PD=460000U
* device instance $3870 r0 *1 8.86,33.85 nfet_01v8
M$3870 1343 149 12 167 nfet_01v8 L=150000U W=140000U AS=16800000000P
+ AD=21875000000P PS=380000U PD=460000U
* device instance $3871 r0 *1 8.305,34.25 nfet_01v8
M$3871 167 2853 2420 167 nfet_01v8 L=150000U W=210000U AS=21875000000P
+ AD=40400000000P PS=460000U PD=560000U
* device instance $3872 r0 *1 8.895,34.25 nfet_01v8
M$3872 167 1930 1343 167 nfet_01v8 L=150000U W=210000U AS=21875000000P
+ AD=40400000000P PS=460000U PD=560000U
* device instance $3873 r0 *1 8.305,34.64 nfet_01v8
M$3873 2853 2420 167 167 nfet_01v8 L=150000U W=210000U AS=40400000000P
+ AD=21875000000P PS=560000U PD=460000U
* device instance $3874 r0 *1 8.895,34.64 nfet_01v8
M$3874 1930 1343 167 167 nfet_01v8 L=150000U W=210000U AS=40400000000P
+ AD=21875000000P PS=560000U PD=460000U
* device instance $3875 r0 *1 8.34,35.04 nfet_01v8
M$3875 10 149 2853 167 nfet_01v8 L=150000U W=140000U AS=21875000000P
+ AD=16800000000P PS=460000U PD=380000U
* device instance $3876 r0 *1 8.86,35.04 nfet_01v8
M$3876 11 149 1930 167 nfet_01v8 L=150000U W=140000U AS=21875000000P
+ AD=16800000000P PS=460000U PD=380000U
* device instance $3877 r0 *1 51.94,60.71 nfet_01v8
M$3877 3567 162 74 167 nfet_01v8 L=150000U W=140000U AS=16800000000P
+ AD=21875000000P PS=380000U PD=460000U
* device instance $3878 r0 *1 52.46,60.71 nfet_01v8
M$3878 1093 162 75 167 nfet_01v8 L=150000U W=140000U AS=16800000000P
+ AD=21875000000P PS=380000U PD=460000U
* device instance $3879 r0 *1 51.905,61.11 nfet_01v8
M$3879 167 2563 3567 167 nfet_01v8 L=150000U W=210000U AS=21875000000P
+ AD=40400000000P PS=460000U PD=560000U
* device instance $3880 r0 *1 52.495,61.11 nfet_01v8
M$3880 167 1640 1093 167 nfet_01v8 L=150000U W=210000U AS=21875000000P
+ AD=40400000000P PS=460000U PD=560000U
* device instance $3881 r0 *1 51.905,61.5 nfet_01v8
M$3881 2563 3567 167 167 nfet_01v8 L=150000U W=210000U AS=40400000000P
+ AD=21875000000P PS=560000U PD=460000U
* device instance $3882 r0 *1 52.495,61.5 nfet_01v8
M$3882 1640 1093 167 167 nfet_01v8 L=150000U W=210000U AS=40400000000P
+ AD=21875000000P PS=560000U PD=460000U
* device instance $3883 r0 *1 51.94,61.9 nfet_01v8
M$3883 73 162 2563 167 nfet_01v8 L=150000U W=140000U AS=21875000000P
+ AD=16800000000P PS=460000U PD=380000U
* device instance $3884 r0 *1 52.46,61.9 nfet_01v8
M$3884 76 162 1640 167 nfet_01v8 L=150000U W=140000U AS=21875000000P
+ AD=16800000000P PS=460000U PD=380000U
* device instance $3885 r0 *1 51.94,62.29 nfet_01v8
M$3885 3156 163 73 167 nfet_01v8 L=150000U W=140000U AS=16800000000P
+ AD=21875000000P PS=380000U PD=460000U
* device instance $3886 r0 *1 52.46,62.29 nfet_01v8
M$3886 4384 163 76 167 nfet_01v8 L=150000U W=140000U AS=16800000000P
+ AD=21875000000P PS=380000U PD=460000U
* device instance $3887 r0 *1 51.905,62.69 nfet_01v8
M$3887 167 2067 3156 167 nfet_01v8 L=150000U W=210000U AS=21875000000P
+ AD=40400000000P PS=460000U PD=560000U
* device instance $3888 r0 *1 52.495,62.69 nfet_01v8
M$3888 167 1753 4384 167 nfet_01v8 L=150000U W=210000U AS=21875000000P
+ AD=40400000000P PS=460000U PD=560000U
* device instance $3889 r0 *1 51.905,63.08 nfet_01v8
M$3889 2067 3156 167 167 nfet_01v8 L=150000U W=210000U AS=40400000000P
+ AD=21875000000P PS=560000U PD=460000U
* device instance $3890 r0 *1 52.495,63.08 nfet_01v8
M$3890 1753 4384 167 167 nfet_01v8 L=150000U W=210000U AS=40400000000P
+ AD=21875000000P PS=560000U PD=460000U
* device instance $3891 r0 *1 51.94,63.48 nfet_01v8
M$3891 74 163 2067 167 nfet_01v8 L=150000U W=140000U AS=21875000000P
+ AD=16800000000P PS=460000U PD=380000U
* device instance $3892 r0 *1 52.46,63.48 nfet_01v8
M$3892 75 163 1753 167 nfet_01v8 L=150000U W=140000U AS=21875000000P
+ AD=16800000000P PS=460000U PD=380000U
* device instance $3893 r0 *1 51.94,63.87 nfet_01v8
M$3893 2108 164 74 167 nfet_01v8 L=150000U W=140000U AS=16800000000P
+ AD=21875000000P PS=380000U PD=460000U
* device instance $3894 r0 *1 52.46,63.87 nfet_01v8
M$3894 666 164 75 167 nfet_01v8 L=150000U W=140000U AS=16800000000P
+ AD=21875000000P PS=380000U PD=460000U
* device instance $3895 r0 *1 51.905,64.27 nfet_01v8
M$3895 167 2220 2108 167 nfet_01v8 L=150000U W=210000U AS=21875000000P
+ AD=40400000000P PS=460000U PD=560000U
* device instance $3896 r0 *1 52.495,64.27 nfet_01v8
M$3896 167 855 666 167 nfet_01v8 L=150000U W=210000U AS=21875000000P
+ AD=40400000000P PS=460000U PD=560000U
* device instance $3897 r0 *1 51.905,64.66 nfet_01v8
M$3897 2220 2108 167 167 nfet_01v8 L=150000U W=210000U AS=40400000000P
+ AD=21875000000P PS=560000U PD=460000U
* device instance $3898 r0 *1 52.495,64.66 nfet_01v8
M$3898 855 666 167 167 nfet_01v8 L=150000U W=210000U AS=40400000000P
+ AD=21875000000P PS=560000U PD=460000U
* device instance $3899 r0 *1 51.94,65.06 nfet_01v8
M$3899 73 164 2220 167 nfet_01v8 L=150000U W=140000U AS=21875000000P
+ AD=16800000000P PS=460000U PD=380000U
* device instance $3900 r0 *1 52.46,65.06 nfet_01v8
M$3900 76 164 855 167 nfet_01v8 L=150000U W=140000U AS=21875000000P
+ AD=16800000000P PS=460000U PD=380000U
* device instance $3901 r0 *1 51.94,65.45 nfet_01v8
M$3901 3129 165 73 167 nfet_01v8 L=150000U W=140000U AS=16800000000P
+ AD=21875000000P PS=380000U PD=460000U
* device instance $3902 r0 *1 52.46,65.45 nfet_01v8
M$3902 1218 165 76 167 nfet_01v8 L=150000U W=140000U AS=16800000000P
+ AD=21875000000P PS=380000U PD=460000U
* device instance $3903 r0 *1 51.905,65.85 nfet_01v8
M$3903 167 2668 3129 167 nfet_01v8 L=150000U W=210000U AS=21875000000P
+ AD=40400000000P PS=460000U PD=560000U
* device instance $3904 r0 *1 52.495,65.85 nfet_01v8
M$3904 167 1789 1218 167 nfet_01v8 L=150000U W=210000U AS=21875000000P
+ AD=40400000000P PS=460000U PD=560000U
* device instance $3905 r0 *1 51.905,66.24 nfet_01v8
M$3905 2668 3129 167 167 nfet_01v8 L=150000U W=210000U AS=40400000000P
+ AD=21875000000P PS=560000U PD=460000U
* device instance $3906 r0 *1 52.495,66.24 nfet_01v8
M$3906 1789 1218 167 167 nfet_01v8 L=150000U W=210000U AS=40400000000P
+ AD=21875000000P PS=560000U PD=460000U
* device instance $3907 r0 *1 51.94,66.64 nfet_01v8
M$3907 74 165 2668 167 nfet_01v8 L=150000U W=140000U AS=21875000000P
+ AD=16800000000P PS=460000U PD=380000U
* device instance $3908 r0 *1 52.46,66.64 nfet_01v8
M$3908 75 165 1789 167 nfet_01v8 L=150000U W=140000U AS=21875000000P
+ AD=16800000000P PS=460000U PD=380000U
* device instance $3909 r0 *1 8.34,44.91 nfet_01v8
M$3909 3723 154 10 167 nfet_01v8 L=150000U W=140000U AS=16800000000P
+ AD=21875000000P PS=380000U PD=460000U
* device instance $3910 r0 *1 8.86,44.91 nfet_01v8
M$3910 1339 154 11 167 nfet_01v8 L=150000U W=140000U AS=16800000000P
+ AD=21875000000P PS=380000U PD=460000U
* device instance $3911 r0 *1 8.305,45.31 nfet_01v8
M$3911 167 3047 3723 167 nfet_01v8 L=150000U W=210000U AS=21875000000P
+ AD=40400000000P PS=460000U PD=560000U
* device instance $3912 r0 *1 8.895,45.31 nfet_01v8
M$3912 167 1921 1339 167 nfet_01v8 L=150000U W=210000U AS=21875000000P
+ AD=40400000000P PS=460000U PD=560000U
* device instance $3913 r0 *1 8.305,45.7 nfet_01v8
M$3913 3047 3723 167 167 nfet_01v8 L=150000U W=210000U AS=40400000000P
+ AD=21875000000P PS=560000U PD=460000U
* device instance $3914 r0 *1 8.895,45.7 nfet_01v8
M$3914 1921 1339 167 167 nfet_01v8 L=150000U W=210000U AS=40400000000P
+ AD=21875000000P PS=560000U PD=460000U
* device instance $3915 r0 *1 8.34,46.1 nfet_01v8
M$3915 9 154 3047 167 nfet_01v8 L=150000U W=140000U AS=21875000000P
+ AD=16800000000P PS=460000U PD=380000U
* device instance $3916 r0 *1 8.86,46.1 nfet_01v8
M$3916 12 154 1921 167 nfet_01v8 L=150000U W=140000U AS=21875000000P
+ AD=16800000000P PS=460000U PD=380000U
* device instance $3917 r0 *1 8.34,46.49 nfet_01v8
M$3917 3722 155 9 167 nfet_01v8 L=150000U W=140000U AS=16800000000P
+ AD=21875000000P PS=380000U PD=460000U
* device instance $3918 r0 *1 8.86,46.49 nfet_01v8
M$3918 4459 155 12 167 nfet_01v8 L=150000U W=140000U AS=16800000000P
+ AD=21875000000P PS=380000U PD=460000U
* device instance $3919 r0 *1 8.305,46.89 nfet_01v8
M$3919 167 2148 3722 167 nfet_01v8 L=150000U W=210000U AS=21875000000P
+ AD=40400000000P PS=460000U PD=560000U
* device instance $3920 r0 *1 8.895,46.89 nfet_01v8
M$3920 167 675 4459 167 nfet_01v8 L=150000U W=210000U AS=21875000000P
+ AD=40400000000P PS=460000U PD=560000U
* device instance $3921 r0 *1 8.305,47.28 nfet_01v8
M$3921 2148 3722 167 167 nfet_01v8 L=150000U W=210000U AS=40400000000P
+ AD=21875000000P PS=560000U PD=460000U
* device instance $3922 r0 *1 8.895,47.28 nfet_01v8
M$3922 675 4459 167 167 nfet_01v8 L=150000U W=210000U AS=40400000000P
+ AD=21875000000P PS=560000U PD=460000U
* device instance $3923 r0 *1 8.34,47.68 nfet_01v8
M$3923 10 155 2148 167 nfet_01v8 L=150000U W=140000U AS=21875000000P
+ AD=16800000000P PS=460000U PD=380000U
* device instance $3924 r0 *1 8.86,47.68 nfet_01v8
M$3924 11 155 675 167 nfet_01v8 L=150000U W=140000U AS=21875000000P
+ AD=16800000000P PS=460000U PD=380000U
* device instance $3925 r0 *1 8.34,48.07 nfet_01v8
M$3925 2521 156 10 167 nfet_01v8 L=150000U W=140000U AS=16800000000P
+ AD=21875000000P PS=380000U PD=460000U
* device instance $3926 r0 *1 8.86,48.07 nfet_01v8
M$3926 1324 156 11 167 nfet_01v8 L=150000U W=140000U AS=16800000000P
+ AD=21875000000P PS=380000U PD=460000U
* device instance $3927 r0 *1 8.305,48.47 nfet_01v8
M$3927 167 3079 2521 167 nfet_01v8 L=150000U W=210000U AS=21875000000P
+ AD=40400000000P PS=460000U PD=560000U
* device instance $3928 r0 *1 8.895,48.47 nfet_01v8
M$3928 167 1905 1324 167 nfet_01v8 L=150000U W=210000U AS=21875000000P
+ AD=40400000000P PS=460000U PD=560000U
* device instance $3929 r0 *1 8.305,48.86 nfet_01v8
M$3929 3079 2521 167 167 nfet_01v8 L=150000U W=210000U AS=40400000000P
+ AD=21875000000P PS=560000U PD=460000U
* device instance $3930 r0 *1 8.895,48.86 nfet_01v8
M$3930 1905 1324 167 167 nfet_01v8 L=150000U W=210000U AS=40400000000P
+ AD=21875000000P PS=560000U PD=460000U
* device instance $3931 r0 *1 8.34,49.26 nfet_01v8
M$3931 9 156 3079 167 nfet_01v8 L=150000U W=140000U AS=21875000000P
+ AD=16800000000P PS=460000U PD=380000U
* device instance $3932 r0 *1 8.86,49.26 nfet_01v8
M$3932 12 156 1905 167 nfet_01v8 L=150000U W=140000U AS=21875000000P
+ AD=16800000000P PS=460000U PD=380000U
* device instance $3933 r0 *1 8.34,49.65 nfet_01v8
M$3933 2544 157 9 167 nfet_01v8 L=150000U W=140000U AS=16800000000P
+ AD=21875000000P PS=380000U PD=460000U
* device instance $3934 r0 *1 8.86,49.65 nfet_01v8
M$3934 891 157 12 167 nfet_01v8 L=150000U W=140000U AS=16800000000P
+ AD=21875000000P PS=380000U PD=460000U
* device instance $3935 r0 *1 8.305,50.05 nfet_01v8
M$3935 167 3119 2544 167 nfet_01v8 L=150000U W=210000U AS=21875000000P
+ AD=40400000000P PS=460000U PD=560000U
* device instance $3936 r0 *1 8.895,50.05 nfet_01v8
M$3936 167 1406 891 167 nfet_01v8 L=150000U W=210000U AS=21875000000P
+ AD=40400000000P PS=460000U PD=560000U
* device instance $3937 r0 *1 8.305,50.44 nfet_01v8
M$3937 3119 2544 167 167 nfet_01v8 L=150000U W=210000U AS=40400000000P
+ AD=21875000000P PS=560000U PD=460000U
* device instance $3938 r0 *1 8.895,50.44 nfet_01v8
M$3938 1406 891 167 167 nfet_01v8 L=150000U W=210000U AS=40400000000P
+ AD=21875000000P PS=560000U PD=460000U
* device instance $3939 r0 *1 8.34,50.84 nfet_01v8
M$3939 10 157 3119 167 nfet_01v8 L=150000U W=140000U AS=21875000000P
+ AD=16800000000P PS=460000U PD=380000U
* device instance $3940 r0 *1 8.86,50.84 nfet_01v8
M$3940 11 157 1406 167 nfet_01v8 L=150000U W=140000U AS=21875000000P
+ AD=16800000000P PS=460000U PD=380000U
* device instance $3941 r0 *1 19.24,44.91 nfet_01v8
M$3941 2528 154 26 167 nfet_01v8 L=150000U W=140000U AS=16800000000P
+ AD=21875000000P PS=380000U PD=460000U
* device instance $3942 r0 *1 19.76,44.91 nfet_01v8
M$3942 920 154 27 167 nfet_01v8 L=150000U W=140000U AS=16800000000P
+ AD=21875000000P PS=380000U PD=460000U
* device instance $3943 r0 *1 19.205,45.31 nfet_01v8
M$3943 167 3091 2528 167 nfet_01v8 L=150000U W=210000U AS=21875000000P
+ AD=40400000000P PS=460000U PD=560000U
* device instance $3944 r0 *1 19.795,45.31 nfet_01v8
M$3944 167 1438 920 167 nfet_01v8 L=150000U W=210000U AS=21875000000P
+ AD=40400000000P PS=460000U PD=560000U
* device instance $3945 r0 *1 19.205,45.7 nfet_01v8
M$3945 3091 2528 167 167 nfet_01v8 L=150000U W=210000U AS=40400000000P
+ AD=21875000000P PS=560000U PD=460000U
* device instance $3946 r0 *1 19.795,45.7 nfet_01v8
M$3946 1438 920 167 167 nfet_01v8 L=150000U W=210000U AS=40400000000P
+ AD=21875000000P PS=560000U PD=460000U
* device instance $3947 r0 *1 19.24,46.1 nfet_01v8
M$3947 25 154 3091 167 nfet_01v8 L=150000U W=140000U AS=21875000000P
+ AD=16800000000P PS=460000U PD=380000U
* device instance $3948 r0 *1 19.76,46.1 nfet_01v8
M$3948 28 154 1438 167 nfet_01v8 L=150000U W=140000U AS=21875000000P
+ AD=16800000000P PS=460000U PD=380000U
* device instance $3949 r0 *1 19.24,46.49 nfet_01v8
M$3949 3749 155 25 167 nfet_01v8 L=150000U W=140000U AS=16800000000P
+ AD=21875000000P PS=380000U PD=460000U
* device instance $3950 r0 *1 19.76,46.49 nfet_01v8
M$3950 4454 155 28 167 nfet_01v8 L=150000U W=140000U AS=16800000000P
+ AD=21875000000P PS=380000U PD=460000U
* device instance $3951 r0 *1 19.205,46.89 nfet_01v8
M$3951 167 3103 3749 167 nfet_01v8 L=150000U W=210000U AS=21875000000P
+ AD=40400000000P PS=460000U PD=560000U
* device instance $3952 r0 *1 19.795,46.89 nfet_01v8
M$3952 167 1410 4454 167 nfet_01v8 L=150000U W=210000U AS=21875000000P
+ AD=40400000000P PS=460000U PD=560000U
* device instance $3953 r0 *1 19.205,47.28 nfet_01v8
M$3953 3103 3749 167 167 nfet_01v8 L=150000U W=210000U AS=40400000000P
+ AD=21875000000P PS=560000U PD=460000U
* device instance $3954 r0 *1 19.795,47.28 nfet_01v8
M$3954 1410 4454 167 167 nfet_01v8 L=150000U W=210000U AS=40400000000P
+ AD=21875000000P PS=560000U PD=460000U
* device instance $3955 r0 *1 19.24,47.68 nfet_01v8
M$3955 26 155 3103 167 nfet_01v8 L=150000U W=140000U AS=21875000000P
+ AD=16800000000P PS=460000U PD=380000U
* device instance $3956 r0 *1 19.76,47.68 nfet_01v8
M$3956 27 155 1410 167 nfet_01v8 L=150000U W=140000U AS=21875000000P
+ AD=16800000000P PS=460000U PD=380000U
* device instance $3957 r0 *1 19.24,48.07 nfet_01v8
M$3957 2530 156 26 167 nfet_01v8 L=150000U W=140000U AS=16800000000P
+ AD=21875000000P PS=380000U PD=460000U
* device instance $3958 r0 *1 19.76,48.07 nfet_01v8
M$3958 915 156 27 167 nfet_01v8 L=150000U W=140000U AS=16800000000P
+ AD=21875000000P PS=380000U PD=460000U
* device instance $3959 r0 *1 19.205,48.47 nfet_01v8
M$3959 167 3093 2530 167 nfet_01v8 L=150000U W=210000U AS=21875000000P
+ AD=40400000000P PS=460000U PD=560000U
* device instance $3960 r0 *1 19.795,48.47 nfet_01v8
M$3960 167 1432 915 167 nfet_01v8 L=150000U W=210000U AS=21875000000P
+ AD=40400000000P PS=460000U PD=560000U
* device instance $3961 r0 *1 19.205,48.86 nfet_01v8
M$3961 3093 2530 167 167 nfet_01v8 L=150000U W=210000U AS=40400000000P
+ AD=21875000000P PS=560000U PD=460000U
* device instance $3962 r0 *1 19.795,48.86 nfet_01v8
M$3962 1432 915 167 167 nfet_01v8 L=150000U W=210000U AS=40400000000P
+ AD=21875000000P PS=560000U PD=460000U
* device instance $3963 r0 *1 19.24,49.26 nfet_01v8
M$3963 25 156 3093 167 nfet_01v8 L=150000U W=140000U AS=21875000000P
+ AD=16800000000P PS=460000U PD=380000U
* device instance $3964 r0 *1 19.76,49.26 nfet_01v8
M$3964 28 156 1432 167 nfet_01v8 L=150000U W=140000U AS=21875000000P
+ AD=16800000000P PS=460000U PD=380000U
* device instance $3965 r0 *1 19.24,49.65 nfet_01v8
M$3965 3741 157 25 167 nfet_01v8 L=150000U W=140000U AS=16800000000P
+ AD=21875000000P PS=380000U PD=460000U
* device instance $3966 r0 *1 19.76,49.65 nfet_01v8
M$3966 917 157 28 167 nfet_01v8 L=150000U W=140000U AS=16800000000P
+ AD=21875000000P PS=380000U PD=460000U
* device instance $3967 r0 *1 19.205,50.05 nfet_01v8
M$3967 167 2956 3741 167 nfet_01v8 L=150000U W=210000U AS=21875000000P
+ AD=40400000000P PS=460000U PD=560000U
* device instance $3968 r0 *1 19.795,50.05 nfet_01v8
M$3968 167 1434 917 167 nfet_01v8 L=150000U W=210000U AS=21875000000P
+ AD=40400000000P PS=460000U PD=560000U
* device instance $3969 r0 *1 19.205,50.44 nfet_01v8
M$3969 2956 3741 167 167 nfet_01v8 L=150000U W=210000U AS=40400000000P
+ AD=21875000000P PS=560000U PD=460000U
* device instance $3970 r0 *1 19.795,50.44 nfet_01v8
M$3970 1434 917 167 167 nfet_01v8 L=150000U W=210000U AS=40400000000P
+ AD=21875000000P PS=560000U PD=460000U
* device instance $3971 r0 *1 19.24,50.84 nfet_01v8
M$3971 26 157 2956 167 nfet_01v8 L=150000U W=140000U AS=21875000000P
+ AD=16800000000P PS=460000U PD=380000U
* device instance $3972 r0 *1 19.76,50.84 nfet_01v8
M$3972 27 157 1434 167 nfet_01v8 L=150000U W=140000U AS=21875000000P
+ AD=16800000000P PS=460000U PD=380000U
* device instance $3973 r0 *1 30.14,44.91 nfet_01v8
M$3973 2385 154 42 167 nfet_01v8 L=150000U W=140000U AS=16800000000P
+ AD=21875000000P PS=380000U PD=460000U
* device instance $3974 r0 *1 30.66,44.91 nfet_01v8
M$3974 1263 154 43 167 nfet_01v8 L=150000U W=140000U AS=16800000000P
+ AD=21875000000P PS=380000U PD=460000U
* device instance $3975 r0 *1 30.105,45.31 nfet_01v8
M$3975 167 2787 2385 167 nfet_01v8 L=150000U W=210000U AS=21875000000P
+ AD=40400000000P PS=460000U PD=560000U
* device instance $3976 r0 *1 30.695,45.31 nfet_01v8
M$3976 167 1840 1263 167 nfet_01v8 L=150000U W=210000U AS=21875000000P
+ AD=40400000000P PS=460000U PD=560000U
* device instance $3977 r0 *1 30.105,45.7 nfet_01v8
M$3977 2787 2385 167 167 nfet_01v8 L=150000U W=210000U AS=40400000000P
+ AD=21875000000P PS=560000U PD=460000U
* device instance $3978 r0 *1 30.695,45.7 nfet_01v8
M$3978 1840 1263 167 167 nfet_01v8 L=150000U W=210000U AS=40400000000P
+ AD=21875000000P PS=560000U PD=460000U
* device instance $3979 r0 *1 30.14,46.1 nfet_01v8
M$3979 41 154 2787 167 nfet_01v8 L=150000U W=140000U AS=21875000000P
+ AD=16800000000P PS=460000U PD=380000U
* device instance $3980 r0 *1 30.66,46.1 nfet_01v8
M$3980 44 154 1840 167 nfet_01v8 L=150000U W=140000U AS=21875000000P
+ AD=16800000000P PS=460000U PD=380000U
* device instance $3981 r0 *1 30.14,46.49 nfet_01v8
M$3981 3620 155 41 167 nfet_01v8 L=150000U W=140000U AS=16800000000P
+ AD=21875000000P PS=380000U PD=460000U
* device instance $3982 r0 *1 30.66,46.49 nfet_01v8
M$3982 4393 155 44 167 nfet_01v8 L=150000U W=140000U AS=16800000000P
+ AD=21875000000P PS=380000U PD=460000U
* device instance $3983 r0 *1 30.105,46.89 nfet_01v8
M$3983 167 2790 3620 167 nfet_01v8 L=150000U W=210000U AS=21875000000P
+ AD=40400000000P PS=460000U PD=560000U
* device instance $3984 r0 *1 30.695,46.89 nfet_01v8
M$3984 167 711 4393 167 nfet_01v8 L=150000U W=210000U AS=21875000000P
+ AD=40400000000P PS=460000U PD=560000U
* device instance $3985 r0 *1 30.105,47.28 nfet_01v8
M$3985 2790 3620 167 167 nfet_01v8 L=150000U W=210000U AS=40400000000P
+ AD=21875000000P PS=560000U PD=460000U
* device instance $3986 r0 *1 30.695,47.28 nfet_01v8
M$3986 711 4393 167 167 nfet_01v8 L=150000U W=210000U AS=40400000000P
+ AD=21875000000P PS=560000U PD=460000U
* device instance $3987 r0 *1 30.14,47.68 nfet_01v8
M$3987 42 155 2790 167 nfet_01v8 L=150000U W=140000U AS=21875000000P
+ AD=16800000000P PS=460000U PD=380000U
* device instance $3988 r0 *1 30.66,47.68 nfet_01v8
M$3988 43 155 711 167 nfet_01v8 L=150000U W=140000U AS=21875000000P
+ AD=16800000000P PS=460000U PD=380000U
* device instance $3989 r0 *1 30.14,48.07 nfet_01v8
M$3989 2070 156 42 167 nfet_01v8 L=150000U W=140000U AS=16800000000P
+ AD=21875000000P PS=380000U PD=460000U
* device instance $3990 r0 *1 30.66,48.07 nfet_01v8
M$3990 1272 156 43 167 nfet_01v8 L=150000U W=140000U AS=16800000000P
+ AD=21875000000P PS=380000U PD=460000U
* device instance $3991 r0 *1 30.105,48.47 nfet_01v8
M$3991 167 2136 2070 167 nfet_01v8 L=150000U W=210000U AS=21875000000P
+ AD=40400000000P PS=460000U PD=560000U
* device instance $3992 r0 *1 30.695,48.47 nfet_01v8
M$3992 167 1849 1272 167 nfet_01v8 L=150000U W=210000U AS=21875000000P
+ AD=40400000000P PS=460000U PD=560000U
* device instance $3993 r0 *1 30.105,48.86 nfet_01v8
M$3993 2136 2070 167 167 nfet_01v8 L=150000U W=210000U AS=40400000000P
+ AD=21875000000P PS=560000U PD=460000U
* device instance $3994 r0 *1 30.695,48.86 nfet_01v8
M$3994 1849 1272 167 167 nfet_01v8 L=150000U W=210000U AS=40400000000P
+ AD=21875000000P PS=560000U PD=460000U
* device instance $3995 r0 *1 30.14,49.26 nfet_01v8
M$3995 41 156 2136 167 nfet_01v8 L=150000U W=140000U AS=21875000000P
+ AD=16800000000P PS=460000U PD=380000U
* device instance $3996 r0 *1 30.66,49.26 nfet_01v8
M$3996 44 156 1849 167 nfet_01v8 L=150000U W=140000U AS=21875000000P
+ AD=16800000000P PS=460000U PD=380000U
* device instance $3997 r0 *1 30.14,49.65 nfet_01v8
M$3997 2384 157 41 167 nfet_01v8 L=150000U W=140000U AS=16800000000P
+ AD=21875000000P PS=380000U PD=460000U
* device instance $3998 r0 *1 30.66,49.65 nfet_01v8
M$3998 1269 157 44 167 nfet_01v8 L=150000U W=140000U AS=16800000000P
+ AD=21875000000P PS=380000U PD=460000U
* device instance $3999 r0 *1 30.105,50.05 nfet_01v8
M$3999 167 2786 2384 167 nfet_01v8 L=150000U W=210000U AS=21875000000P
+ AD=40400000000P PS=460000U PD=560000U
* device instance $4000 r0 *1 30.695,50.05 nfet_01v8
M$4000 167 1846 1269 167 nfet_01v8 L=150000U W=210000U AS=21875000000P
+ AD=40400000000P PS=460000U PD=560000U
* device instance $4001 r0 *1 30.105,50.44 nfet_01v8
M$4001 2786 2384 167 167 nfet_01v8 L=150000U W=210000U AS=40400000000P
+ AD=21875000000P PS=560000U PD=460000U
* device instance $4002 r0 *1 30.695,50.44 nfet_01v8
M$4002 1846 1269 167 167 nfet_01v8 L=150000U W=210000U AS=40400000000P
+ AD=21875000000P PS=560000U PD=460000U
* device instance $4003 r0 *1 30.14,50.84 nfet_01v8
M$4003 42 157 2786 167 nfet_01v8 L=150000U W=140000U AS=21875000000P
+ AD=16800000000P PS=460000U PD=380000U
* device instance $4004 r0 *1 30.66,50.84 nfet_01v8
M$4004 43 157 1846 167 nfet_01v8 L=150000U W=140000U AS=21875000000P
+ AD=16800000000P PS=460000U PD=380000U
* device instance $4005 r0 *1 41.04,44.91 nfet_01v8
M$4005 3643 154 58 167 nfet_01v8 L=150000U W=140000U AS=16800000000P
+ AD=21875000000P PS=380000U PD=460000U
* device instance $4006 r0 *1 41.56,44.91 nfet_01v8
M$4006 1222 154 59 167 nfet_01v8 L=150000U W=140000U AS=16800000000P
+ AD=21875000000P PS=380000U PD=460000U
* device instance $4007 r0 *1 41.005,45.31 nfet_01v8
M$4007 167 2767 3643 167 nfet_01v8 L=150000U W=210000U AS=21875000000P
+ AD=40400000000P PS=460000U PD=560000U
* device instance $4008 r0 *1 41.595,45.31 nfet_01v8
M$4008 167 1793 1222 167 nfet_01v8 L=150000U W=210000U AS=21875000000P
+ AD=40400000000P PS=460000U PD=560000U
* device instance $4009 r0 *1 41.005,45.7 nfet_01v8
M$4009 2767 3643 167 167 nfet_01v8 L=150000U W=210000U AS=40400000000P
+ AD=21875000000P PS=560000U PD=460000U
* device instance $4010 r0 *1 41.595,45.7 nfet_01v8
M$4010 1793 1222 167 167 nfet_01v8 L=150000U W=210000U AS=40400000000P
+ AD=21875000000P PS=560000U PD=460000U
* device instance $4011 r0 *1 41.04,46.1 nfet_01v8
M$4011 57 154 2767 167 nfet_01v8 L=150000U W=140000U AS=21875000000P
+ AD=16800000000P PS=460000U PD=380000U
* device instance $4012 r0 *1 41.56,46.1 nfet_01v8
M$4012 60 154 1793 167 nfet_01v8 L=150000U W=140000U AS=21875000000P
+ AD=16800000000P PS=460000U PD=380000U
* device instance $4013 r0 *1 41.04,46.49 nfet_01v8
M$4013 3644 155 57 167 nfet_01v8 L=150000U W=140000U AS=16800000000P
+ AD=21875000000P PS=380000U PD=460000U
* device instance $4014 r0 *1 41.56,46.49 nfet_01v8
M$4014 4389 155 60 167 nfet_01v8 L=150000U W=140000U AS=16800000000P
+ AD=21875000000P PS=380000U PD=460000U
* device instance $4015 r0 *1 41.005,46.89 nfet_01v8
M$4015 167 2163 3644 167 nfet_01v8 L=150000U W=210000U AS=21875000000P
+ AD=40400000000P PS=460000U PD=560000U
* device instance $4016 r0 *1 41.595,46.89 nfet_01v8
M$4016 167 1761 4389 167 nfet_01v8 L=150000U W=210000U AS=21875000000P
+ AD=40400000000P PS=460000U PD=560000U
* device instance $4017 r0 *1 41.005,47.28 nfet_01v8
M$4017 2163 3644 167 167 nfet_01v8 L=150000U W=210000U AS=40400000000P
+ AD=21875000000P PS=560000U PD=460000U
* device instance $4018 r0 *1 41.595,47.28 nfet_01v8
M$4018 1761 4389 167 167 nfet_01v8 L=150000U W=210000U AS=40400000000P
+ AD=21875000000P PS=560000U PD=460000U
* device instance $4019 r0 *1 41.04,47.68 nfet_01v8
M$4019 58 155 2163 167 nfet_01v8 L=150000U W=140000U AS=21875000000P
+ AD=16800000000P PS=460000U PD=380000U
* device instance $4020 r0 *1 41.56,47.68 nfet_01v8
M$4020 59 155 1761 167 nfet_01v8 L=150000U W=140000U AS=21875000000P
+ AD=16800000000P PS=460000U PD=380000U
* device instance $4021 r0 *1 41.04,48.07 nfet_01v8
M$4021 3642 156 58 167 nfet_01v8 L=150000U W=140000U AS=16800000000P
+ AD=21875000000P PS=380000U PD=460000U
* device instance $4022 r0 *1 41.56,48.07 nfet_01v8
M$4022 1231 156 59 167 nfet_01v8 L=150000U W=140000U AS=16800000000P
+ AD=21875000000P PS=380000U PD=460000U
* device instance $4023 r0 *1 41.005,48.47 nfet_01v8
M$4023 167 2763 3642 167 nfet_01v8 L=150000U W=210000U AS=21875000000P
+ AD=40400000000P PS=460000U PD=560000U
* device instance $4024 r0 *1 41.595,48.47 nfet_01v8
M$4024 167 1803 1231 167 nfet_01v8 L=150000U W=210000U AS=21875000000P
+ AD=40400000000P PS=460000U PD=560000U
* device instance $4025 r0 *1 41.005,48.86 nfet_01v8
M$4025 2763 3642 167 167 nfet_01v8 L=150000U W=210000U AS=40400000000P
+ AD=21875000000P PS=560000U PD=460000U
* device instance $4026 r0 *1 41.595,48.86 nfet_01v8
M$4026 1803 1231 167 167 nfet_01v8 L=150000U W=210000U AS=40400000000P
+ AD=21875000000P PS=560000U PD=460000U
* device instance $4027 r0 *1 41.04,49.26 nfet_01v8
M$4027 57 156 2763 167 nfet_01v8 L=150000U W=140000U AS=21875000000P
+ AD=16800000000P PS=460000U PD=380000U
* device instance $4028 r0 *1 41.56,49.26 nfet_01v8
M$4028 60 156 1803 167 nfet_01v8 L=150000U W=140000U AS=21875000000P
+ AD=16800000000P PS=460000U PD=380000U
* device instance $4029 r0 *1 41.04,49.65 nfet_01v8
M$4029 3640 157 57 167 nfet_01v8 L=150000U W=140000U AS=16800000000P
+ AD=21875000000P PS=380000U PD=460000U
* device instance $4030 r0 *1 41.56,49.65 nfet_01v8
M$4030 1223 157 60 167 nfet_01v8 L=150000U W=140000U AS=16800000000P
+ AD=21875000000P PS=380000U PD=460000U
* device instance $4031 r0 *1 41.005,50.05 nfet_01v8
M$4031 167 2766 3640 167 nfet_01v8 L=150000U W=210000U AS=21875000000P
+ AD=40400000000P PS=460000U PD=560000U
* device instance $4032 r0 *1 41.595,50.05 nfet_01v8
M$4032 167 1794 1223 167 nfet_01v8 L=150000U W=210000U AS=21875000000P
+ AD=40400000000P PS=460000U PD=560000U
* device instance $4033 r0 *1 41.005,50.44 nfet_01v8
M$4033 2766 3640 167 167 nfet_01v8 L=150000U W=210000U AS=40400000000P
+ AD=21875000000P PS=560000U PD=460000U
* device instance $4034 r0 *1 41.595,50.44 nfet_01v8
M$4034 1794 1223 167 167 nfet_01v8 L=150000U W=210000U AS=40400000000P
+ AD=21875000000P PS=560000U PD=460000U
* device instance $4035 r0 *1 41.04,50.84 nfet_01v8
M$4035 58 157 2766 167 nfet_01v8 L=150000U W=140000U AS=21875000000P
+ AD=16800000000P PS=460000U PD=380000U
* device instance $4036 r0 *1 41.56,50.84 nfet_01v8
M$4036 59 157 1794 167 nfet_01v8 L=150000U W=140000U AS=21875000000P
+ AD=16800000000P PS=460000U PD=380000U
* device instance $4037 r0 *1 51.94,44.91 nfet_01v8
M$4037 2308 154 74 167 nfet_01v8 L=150000U W=140000U AS=16800000000P
+ AD=21875000000P PS=380000U PD=460000U
* device instance $4038 r0 *1 52.46,44.91 nfet_01v8
M$4038 1132 154 75 167 nfet_01v8 L=150000U W=140000U AS=16800000000P
+ AD=21875000000P PS=380000U PD=460000U
* device instance $4039 r0 *1 51.905,45.31 nfet_01v8
M$4039 167 2633 2308 167 nfet_01v8 L=150000U W=210000U AS=21875000000P
+ AD=40400000000P PS=460000U PD=560000U
* device instance $4040 r0 *1 52.495,45.31 nfet_01v8
M$4040 167 1688 1132 167 nfet_01v8 L=150000U W=210000U AS=21875000000P
+ AD=40400000000P PS=460000U PD=560000U
* device instance $4041 r0 *1 51.905,45.7 nfet_01v8
M$4041 2633 2308 167 167 nfet_01v8 L=150000U W=210000U AS=40400000000P
+ AD=21875000000P PS=560000U PD=460000U
* device instance $4042 r0 *1 52.495,45.7 nfet_01v8
M$4042 1688 1132 167 167 nfet_01v8 L=150000U W=210000U AS=40400000000P
+ AD=21875000000P PS=560000U PD=460000U
* device instance $4043 r0 *1 51.94,46.1 nfet_01v8
M$4043 73 154 2633 167 nfet_01v8 L=150000U W=140000U AS=21875000000P
+ AD=16800000000P PS=460000U PD=380000U
* device instance $4044 r0 *1 52.46,46.1 nfet_01v8
M$4044 76 154 1688 167 nfet_01v8 L=150000U W=140000U AS=21875000000P
+ AD=16800000000P PS=460000U PD=380000U
* device instance $4045 r0 *1 51.94,46.49 nfet_01v8
M$4045 3559 155 73 167 nfet_01v8 L=150000U W=140000U AS=16800000000P
+ AD=21875000000P PS=380000U PD=460000U
* device instance $4046 r0 *1 52.46,46.49 nfet_01v8
M$4046 4353 155 76 167 nfet_01v8 L=150000U W=140000U AS=16800000000P
+ AD=21875000000P PS=380000U PD=460000U
* device instance $4047 r0 *1 51.905,46.89 nfet_01v8
M$4047 167 2634 3559 167 nfet_01v8 L=150000U W=210000U AS=21875000000P
+ AD=40400000000P PS=460000U PD=560000U
* device instance $4048 r0 *1 52.495,46.89 nfet_01v8
M$4048 167 1686 4353 167 nfet_01v8 L=150000U W=210000U AS=21875000000P
+ AD=40400000000P PS=460000U PD=560000U
* device instance $4049 r0 *1 51.905,47.28 nfet_01v8
M$4049 2634 3559 167 167 nfet_01v8 L=150000U W=210000U AS=40400000000P
+ AD=21875000000P PS=560000U PD=460000U
* device instance $4050 r0 *1 52.495,47.28 nfet_01v8
M$4050 1686 4353 167 167 nfet_01v8 L=150000U W=210000U AS=40400000000P
+ AD=21875000000P PS=560000U PD=460000U
* device instance $4051 r0 *1 51.94,47.68 nfet_01v8
M$4051 74 155 2634 167 nfet_01v8 L=150000U W=140000U AS=21875000000P
+ AD=16800000000P PS=460000U PD=380000U
* device instance $4052 r0 *1 52.46,47.68 nfet_01v8
M$4052 75 155 1686 167 nfet_01v8 L=150000U W=140000U AS=21875000000P
+ AD=16800000000P PS=460000U PD=380000U
* device instance $4053 r0 *1 51.94,48.07 nfet_01v8
M$4053 3560 156 74 167 nfet_01v8 L=150000U W=140000U AS=16800000000P
+ AD=21875000000P PS=380000U PD=460000U
* device instance $4054 r0 *1 52.46,48.07 nfet_01v8
M$4054 619 156 75 167 nfet_01v8 L=150000U W=140000U AS=16800000000P
+ AD=21875000000P PS=380000U PD=460000U
* device instance $4055 r0 *1 51.905,48.47 nfet_01v8
M$4055 167 2637 3560 167 nfet_01v8 L=150000U W=210000U AS=21875000000P
+ AD=40400000000P PS=460000U PD=560000U
* device instance $4056 r0 *1 52.495,48.47 nfet_01v8
M$4056 167 761 619 167 nfet_01v8 L=150000U W=210000U AS=21875000000P
+ AD=40400000000P PS=460000U PD=560000U
* device instance $4057 r0 *1 51.905,48.86 nfet_01v8
M$4057 2637 3560 167 167 nfet_01v8 L=150000U W=210000U AS=40400000000P
+ AD=21875000000P PS=560000U PD=460000U
* device instance $4058 r0 *1 52.495,48.86 nfet_01v8
M$4058 761 619 167 167 nfet_01v8 L=150000U W=210000U AS=40400000000P
+ AD=21875000000P PS=560000U PD=460000U
* device instance $4059 r0 *1 51.94,49.26 nfet_01v8
M$4059 73 156 2637 167 nfet_01v8 L=150000U W=140000U AS=21875000000P
+ AD=16800000000P PS=460000U PD=380000U
* device instance $4060 r0 *1 52.46,49.26 nfet_01v8
M$4060 76 156 761 167 nfet_01v8 L=150000U W=140000U AS=21875000000P
+ AD=16800000000P PS=460000U PD=380000U
* device instance $4061 r0 *1 51.94,49.65 nfet_01v8
M$4061 3558 157 73 167 nfet_01v8 L=150000U W=140000U AS=16800000000P
+ AD=21875000000P PS=380000U PD=460000U
* device instance $4062 r0 *1 52.46,49.65 nfet_01v8
M$4062 1127 157 76 167 nfet_01v8 L=150000U W=140000U AS=16800000000P
+ AD=21875000000P PS=380000U PD=460000U
* device instance $4063 r0 *1 51.905,50.05 nfet_01v8
M$4063 167 2639 3558 167 nfet_01v8 L=150000U W=210000U AS=21875000000P
+ AD=40400000000P PS=460000U PD=560000U
* device instance $4064 r0 *1 52.495,50.05 nfet_01v8
M$4064 167 1682 1127 167 nfet_01v8 L=150000U W=210000U AS=21875000000P
+ AD=40400000000P PS=460000U PD=560000U
* device instance $4065 r0 *1 51.905,50.44 nfet_01v8
M$4065 2639 3558 167 167 nfet_01v8 L=150000U W=210000U AS=40400000000P
+ AD=21875000000P PS=560000U PD=460000U
* device instance $4066 r0 *1 52.495,50.44 nfet_01v8
M$4066 1682 1127 167 167 nfet_01v8 L=150000U W=210000U AS=40400000000P
+ AD=21875000000P PS=560000U PD=460000U
* device instance $4067 r0 *1 51.94,50.84 nfet_01v8
M$4067 74 157 2639 167 nfet_01v8 L=150000U W=140000U AS=21875000000P
+ AD=16800000000P PS=460000U PD=380000U
* device instance $4068 r0 *1 52.46,50.84 nfet_01v8
M$4068 75 157 1682 167 nfet_01v8 L=150000U W=140000U AS=21875000000P
+ AD=16800000000P PS=460000U PD=380000U
* device instance $4069 r0 *1 62.84,60.71 nfet_01v8
M$4069 3576 162 90 167 nfet_01v8 L=150000U W=140000U AS=16800000000P
+ AD=21875000000P PS=380000U PD=460000U
* device instance $4070 r0 *1 63.36,60.71 nfet_01v8
M$4070 1072 162 91 167 nfet_01v8 L=150000U W=140000U AS=16800000000P
+ AD=21875000000P PS=380000U PD=460000U
* device instance $4071 r0 *1 62.805,61.11 nfet_01v8
M$4071 167 2556 3576 167 nfet_01v8 L=150000U W=210000U AS=21875000000P
+ AD=40400000000P PS=460000U PD=560000U
* device instance $4072 r0 *1 63.395,61.11 nfet_01v8
M$4072 167 1617 1072 167 nfet_01v8 L=150000U W=210000U AS=21875000000P
+ AD=40400000000P PS=460000U PD=560000U
* device instance $4073 r0 *1 62.805,61.5 nfet_01v8
M$4073 2556 3576 167 167 nfet_01v8 L=150000U W=210000U AS=40400000000P
+ AD=21875000000P PS=560000U PD=460000U
* device instance $4074 r0 *1 63.395,61.5 nfet_01v8
M$4074 1617 1072 167 167 nfet_01v8 L=150000U W=210000U AS=40400000000P
+ AD=21875000000P PS=560000U PD=460000U
* device instance $4075 r0 *1 62.84,61.9 nfet_01v8
M$4075 89 162 2556 167 nfet_01v8 L=150000U W=140000U AS=21875000000P
+ AD=16800000000P PS=460000U PD=380000U
* device instance $4076 r0 *1 63.36,61.9 nfet_01v8
M$4076 92 162 1617 167 nfet_01v8 L=150000U W=140000U AS=21875000000P
+ AD=16800000000P PS=460000U PD=380000U
* device instance $4077 r0 *1 62.84,62.29 nfet_01v8
M$4077 3169 163 89 167 nfet_01v8 L=150000U W=140000U AS=16800000000P
+ AD=21875000000P PS=380000U PD=460000U
* device instance $4078 r0 *1 63.36,62.29 nfet_01v8
M$4078 4435 163 92 167 nfet_01v8 L=150000U W=140000U AS=16800000000P
+ AD=21875000000P PS=380000U PD=460000U
* device instance $4079 r0 *1 62.805,62.69 nfet_01v8
M$4079 167 2923 3169 167 nfet_01v8 L=150000U W=210000U AS=21875000000P
+ AD=40400000000P PS=460000U PD=560000U
* device instance $4080 r0 *1 63.395,62.69 nfet_01v8
M$4080 167 850 4435 167 nfet_01v8 L=150000U W=210000U AS=21875000000P
+ AD=40400000000P PS=460000U PD=560000U
* device instance $4081 r0 *1 62.805,63.08 nfet_01v8
M$4081 2923 3169 167 167 nfet_01v8 L=150000U W=210000U AS=40400000000P
+ AD=21875000000P PS=560000U PD=460000U
* device instance $4082 r0 *1 63.395,63.08 nfet_01v8
M$4082 850 4435 167 167 nfet_01v8 L=150000U W=210000U AS=40400000000P
+ AD=21875000000P PS=560000U PD=460000U
* device instance $4083 r0 *1 62.84,63.48 nfet_01v8
M$4083 90 163 2923 167 nfet_01v8 L=150000U W=140000U AS=21875000000P
+ AD=16800000000P PS=460000U PD=380000U
* device instance $4084 r0 *1 63.36,63.48 nfet_01v8
M$4084 91 163 850 167 nfet_01v8 L=150000U W=140000U AS=21875000000P
+ AD=16800000000P PS=460000U PD=380000U
* device instance $4085 r0 *1 62.84,63.87 nfet_01v8
M$4085 3168 164 90 167 nfet_01v8 L=150000U W=140000U AS=16800000000P
+ AD=21875000000P PS=380000U PD=460000U
* device instance $4086 r0 *1 63.36,63.87 nfet_01v8
M$4086 641 164 91 167 nfet_01v8 L=150000U W=140000U AS=16800000000P
+ AD=21875000000P PS=380000U PD=460000U
* device instance $4087 r0 *1 62.805,64.27 nfet_01v8
M$4087 167 2950 3168 167 nfet_01v8 L=150000U W=210000U AS=21875000000P
+ AD=40400000000P PS=460000U PD=560000U
* device instance $4088 r0 *1 63.395,64.27 nfet_01v8
M$4088 167 800 641 167 nfet_01v8 L=150000U W=210000U AS=21875000000P
+ AD=40400000000P PS=460000U PD=560000U
* device instance $4089 r0 *1 62.805,64.66 nfet_01v8
M$4089 2950 3168 167 167 nfet_01v8 L=150000U W=210000U AS=40400000000P
+ AD=21875000000P PS=560000U PD=460000U
* device instance $4090 r0 *1 63.395,64.66 nfet_01v8
M$4090 800 641 167 167 nfet_01v8 L=150000U W=210000U AS=40400000000P
+ AD=21875000000P PS=560000U PD=460000U
* device instance $4091 r0 *1 62.84,65.06 nfet_01v8
M$4091 89 164 2950 167 nfet_01v8 L=150000U W=140000U AS=21875000000P
+ AD=16800000000P PS=460000U PD=380000U
* device instance $4092 r0 *1 63.36,65.06 nfet_01v8
M$4092 92 164 800 167 nfet_01v8 L=150000U W=140000U AS=21875000000P
+ AD=16800000000P PS=460000U PD=380000U
* device instance $4093 r0 *1 62.84,65.45 nfet_01v8
M$4093 2458 165 89 167 nfet_01v8 L=150000U W=140000U AS=16800000000P
+ AD=21875000000P PS=380000U PD=460000U
* device instance $4094 r0 *1 63.36,65.45 nfet_01v8
M$4094 873 165 92 167 nfet_01v8 L=150000U W=140000U AS=16800000000P
+ AD=21875000000P PS=380000U PD=460000U
* device instance $4095 r0 *1 62.805,65.85 nfet_01v8
M$4095 167 2936 2458 167 nfet_01v8 L=150000U W=210000U AS=21875000000P
+ AD=40400000000P PS=460000U PD=560000U
* device instance $4096 r0 *1 63.395,65.85 nfet_01v8
M$4096 167 1381 873 167 nfet_01v8 L=150000U W=210000U AS=21875000000P
+ AD=40400000000P PS=460000U PD=560000U
* device instance $4097 r0 *1 62.805,66.24 nfet_01v8
M$4097 2936 2458 167 167 nfet_01v8 L=150000U W=210000U AS=40400000000P
+ AD=21875000000P PS=560000U PD=460000U
* device instance $4098 r0 *1 63.395,66.24 nfet_01v8
M$4098 1381 873 167 167 nfet_01v8 L=150000U W=210000U AS=40400000000P
+ AD=21875000000P PS=560000U PD=460000U
* device instance $4099 r0 *1 62.84,66.64 nfet_01v8
M$4099 90 165 2936 167 nfet_01v8 L=150000U W=140000U AS=21875000000P
+ AD=16800000000P PS=460000U PD=380000U
* device instance $4100 r0 *1 63.36,66.64 nfet_01v8
M$4100 91 165 1381 167 nfet_01v8 L=150000U W=140000U AS=21875000000P
+ AD=16800000000P PS=460000U PD=380000U
* device instance $4101 r0 *1 84.64,52.81 nfet_01v8
M$4101 2517 158 122 167 nfet_01v8 L=150000U W=140000U AS=16800000000P
+ AD=21875000000P PS=380000U PD=460000U
* device instance $4102 r0 *1 85.16,52.81 nfet_01v8
M$4102 1094 158 123 167 nfet_01v8 L=150000U W=140000U AS=16800000000P
+ AD=21875000000P PS=380000U PD=460000U
* device instance $4103 r0 *1 84.605,53.21 nfet_01v8
M$4103 167 3070 2517 167 nfet_01v8 L=150000U W=210000U AS=21875000000P
+ AD=40400000000P PS=460000U PD=560000U
* device instance $4104 r0 *1 85.195,53.21 nfet_01v8
M$4104 167 1641 1094 167 nfet_01v8 L=150000U W=210000U AS=21875000000P
+ AD=40400000000P PS=460000U PD=560000U
* device instance $4105 r0 *1 84.605,53.6 nfet_01v8
M$4105 3070 2517 167 167 nfet_01v8 L=150000U W=210000U AS=40400000000P
+ AD=21875000000P PS=560000U PD=460000U
* device instance $4106 r0 *1 85.195,53.6 nfet_01v8
M$4106 1641 1094 167 167 nfet_01v8 L=150000U W=210000U AS=40400000000P
+ AD=21875000000P PS=560000U PD=460000U
* device instance $4107 r0 *1 84.64,54 nfet_01v8
M$4107 121 158 3070 167 nfet_01v8 L=150000U W=140000U AS=21875000000P
+ AD=16800000000P PS=460000U PD=380000U
* device instance $4108 r0 *1 85.16,54 nfet_01v8
M$4108 124 158 1641 167 nfet_01v8 L=150000U W=140000U AS=21875000000P
+ AD=16800000000P PS=460000U PD=380000U
* device instance $4109 r0 *1 84.64,54.39 nfet_01v8
M$4109 3145 159 121 167 nfet_01v8 L=150000U W=140000U AS=16800000000P
+ AD=21875000000P PS=380000U PD=460000U
* device instance $4110 r0 *1 85.16,54.39 nfet_01v8
M$4110 4399 159 124 167 nfet_01v8 L=150000U W=140000U AS=16800000000P
+ AD=21875000000P PS=380000U PD=460000U
* device instance $4111 r0 *1 84.605,54.79 nfet_01v8
M$4111 167 2036 3145 167 nfet_01v8 L=150000U W=210000U AS=21875000000P
+ AD=40400000000P PS=460000U PD=560000U
* device instance $4112 r0 *1 85.195,54.79 nfet_01v8
M$4112 167 1923 4399 167 nfet_01v8 L=150000U W=210000U AS=21875000000P
+ AD=40400000000P PS=460000U PD=560000U
* device instance $4113 r0 *1 84.605,55.18 nfet_01v8
M$4113 2036 3145 167 167 nfet_01v8 L=150000U W=210000U AS=40400000000P
+ AD=21875000000P PS=560000U PD=460000U
* device instance $4114 r0 *1 85.195,55.18 nfet_01v8
M$4114 1923 4399 167 167 nfet_01v8 L=150000U W=210000U AS=40400000000P
+ AD=21875000000P PS=560000U PD=460000U
* device instance $4115 r0 *1 84.64,55.58 nfet_01v8
M$4115 122 159 2036 167 nfet_01v8 L=150000U W=140000U AS=21875000000P
+ AD=16800000000P PS=460000U PD=380000U
* device instance $4116 r0 *1 85.16,55.58 nfet_01v8
M$4116 123 159 1923 167 nfet_01v8 L=150000U W=140000U AS=21875000000P
+ AD=16800000000P PS=460000U PD=380000U
* device instance $4117 r0 *1 84.64,55.97 nfet_01v8
M$4117 2362 160 122 167 nfet_01v8 L=150000U W=140000U AS=16800000000P
+ AD=21875000000P PS=380000U PD=460000U
* device instance $4118 r0 *1 85.16,55.97 nfet_01v8
M$4118 1197 160 123 167 nfet_01v8 L=150000U W=140000U AS=16800000000P
+ AD=21875000000P PS=380000U PD=460000U
* device instance $4119 r0 *1 84.605,56.37 nfet_01v8
M$4119 167 2752 2362 167 nfet_01v8 L=150000U W=210000U AS=21875000000P
+ AD=40400000000P PS=460000U PD=560000U
* device instance $4120 r0 *1 85.195,56.37 nfet_01v8
M$4120 167 1766 1197 167 nfet_01v8 L=150000U W=210000U AS=21875000000P
+ AD=40400000000P PS=460000U PD=560000U
* device instance $4121 r0 *1 84.605,56.76 nfet_01v8
M$4121 2752 2362 167 167 nfet_01v8 L=150000U W=210000U AS=40400000000P
+ AD=21875000000P PS=560000U PD=460000U
* device instance $4122 r0 *1 85.195,56.76 nfet_01v8
M$4122 1766 1197 167 167 nfet_01v8 L=150000U W=210000U AS=40400000000P
+ AD=21875000000P PS=560000U PD=460000U
* device instance $4123 r0 *1 84.64,57.16 nfet_01v8
M$4123 121 160 2752 167 nfet_01v8 L=150000U W=140000U AS=21875000000P
+ AD=16800000000P PS=460000U PD=380000U
* device instance $4124 r0 *1 85.16,57.16 nfet_01v8
M$4124 124 160 1766 167 nfet_01v8 L=150000U W=140000U AS=21875000000P
+ AD=16800000000P PS=460000U PD=380000U
* device instance $4125 r0 *1 84.64,57.55 nfet_01v8
M$4125 2378 161 121 167 nfet_01v8 L=150000U W=140000U AS=16800000000P
+ AD=21875000000P PS=380000U PD=460000U
* device instance $4126 r0 *1 85.16,57.55 nfet_01v8
M$4126 1248 161 124 167 nfet_01v8 L=150000U W=140000U AS=16800000000P
+ AD=21875000000P PS=380000U PD=460000U
* device instance $4127 r0 *1 84.605,57.95 nfet_01v8
M$4127 167 2780 2378 167 nfet_01v8 L=150000U W=210000U AS=21875000000P
+ AD=40400000000P PS=460000U PD=560000U
* device instance $4128 r0 *1 85.195,57.95 nfet_01v8
M$4128 167 1820 1248 167 nfet_01v8 L=150000U W=210000U AS=21875000000P
+ AD=40400000000P PS=460000U PD=560000U
* device instance $4129 r0 *1 84.605,58.34 nfet_01v8
M$4129 2780 2378 167 167 nfet_01v8 L=150000U W=210000U AS=40400000000P
+ AD=21875000000P PS=560000U PD=460000U
* device instance $4130 r0 *1 85.195,58.34 nfet_01v8
M$4130 1820 1248 167 167 nfet_01v8 L=150000U W=210000U AS=40400000000P
+ AD=21875000000P PS=560000U PD=460000U
* device instance $4131 r0 *1 84.64,58.74 nfet_01v8
M$4131 122 161 2780 167 nfet_01v8 L=150000U W=140000U AS=21875000000P
+ AD=16800000000P PS=460000U PD=380000U
* device instance $4132 r0 *1 85.16,58.74 nfet_01v8
M$4132 123 161 1820 167 nfet_01v8 L=150000U W=140000U AS=21875000000P
+ AD=16800000000P PS=460000U PD=380000U
* device instance $4133 r0 *1 84.64,60.71 nfet_01v8
M$4133 3165 162 122 167 nfet_01v8 L=150000U W=140000U AS=16800000000P
+ AD=21875000000P PS=380000U PD=460000U
* device instance $4134 r0 *1 85.16,60.71 nfet_01v8
M$4134 1268 162 123 167 nfet_01v8 L=150000U W=140000U AS=16800000000P
+ AD=21875000000P PS=380000U PD=460000U
* device instance $4135 r0 *1 84.605,61.11 nfet_01v8
M$4135 167 2789 3165 167 nfet_01v8 L=150000U W=210000U AS=21875000000P
+ AD=40400000000P PS=460000U PD=560000U
* device instance $4136 r0 *1 85.195,61.11 nfet_01v8
M$4136 167 1845 1268 167 nfet_01v8 L=150000U W=210000U AS=21875000000P
+ AD=40400000000P PS=460000U PD=560000U
* device instance $4137 r0 *1 84.605,61.5 nfet_01v8
M$4137 2789 3165 167 167 nfet_01v8 L=150000U W=210000U AS=40400000000P
+ AD=21875000000P PS=560000U PD=460000U
* device instance $4138 r0 *1 85.195,61.5 nfet_01v8
M$4138 1845 1268 167 167 nfet_01v8 L=150000U W=210000U AS=40400000000P
+ AD=21875000000P PS=560000U PD=460000U
* device instance $4139 r0 *1 84.64,61.9 nfet_01v8
M$4139 121 162 2789 167 nfet_01v8 L=150000U W=140000U AS=21875000000P
+ AD=16800000000P PS=460000U PD=380000U
* device instance $4140 r0 *1 85.16,61.9 nfet_01v8
M$4140 124 162 1845 167 nfet_01v8 L=150000U W=140000U AS=21875000000P
+ AD=16800000000P PS=460000U PD=380000U
* device instance $4141 r0 *1 84.64,62.29 nfet_01v8
M$4141 3153 163 121 167 nfet_01v8 L=150000U W=140000U AS=16800000000P
+ AD=21875000000P PS=380000U PD=460000U
* device instance $4142 r0 *1 85.16,62.29 nfet_01v8
M$4142 4362 163 124 167 nfet_01v8 L=150000U W=140000U AS=16800000000P
+ AD=21875000000P PS=380000U PD=460000U
* device instance $4143 r0 *1 84.605,62.69 nfet_01v8
M$4143 167 2733 3153 167 nfet_01v8 L=150000U W=210000U AS=21875000000P
+ AD=40400000000P PS=460000U PD=560000U
* device instance $4144 r0 *1 85.195,62.69 nfet_01v8
M$4144 167 827 4362 167 nfet_01v8 L=150000U W=210000U AS=21875000000P
+ AD=40400000000P PS=460000U PD=560000U
* device instance $4145 r0 *1 84.605,63.08 nfet_01v8
M$4145 2733 3153 167 167 nfet_01v8 L=150000U W=210000U AS=40400000000P
+ AD=21875000000P PS=560000U PD=460000U
* device instance $4146 r0 *1 85.195,63.08 nfet_01v8
M$4146 827 4362 167 167 nfet_01v8 L=150000U W=210000U AS=40400000000P
+ AD=21875000000P PS=560000U PD=460000U
* device instance $4147 r0 *1 84.64,63.48 nfet_01v8
M$4147 122 163 2733 167 nfet_01v8 L=150000U W=140000U AS=21875000000P
+ AD=16800000000P PS=460000U PD=380000U
* device instance $4148 r0 *1 85.16,63.48 nfet_01v8
M$4148 123 163 827 167 nfet_01v8 L=150000U W=140000U AS=21875000000P
+ AD=16800000000P PS=460000U PD=380000U
* device instance $4149 r0 *1 84.64,63.87 nfet_01v8
M$4149 2091 164 122 167 nfet_01v8 L=150000U W=140000U AS=16800000000P
+ AD=21875000000P PS=380000U PD=460000U
* device instance $4150 r0 *1 85.16,63.87 nfet_01v8
M$4150 616 164 123 167 nfet_01v8 L=150000U W=140000U AS=16800000000P
+ AD=21875000000P PS=380000U PD=460000U
* device instance $4151 r0 *1 84.605,64.27 nfet_01v8
M$4151 167 2183 2091 167 nfet_01v8 L=150000U W=210000U AS=21875000000P
+ AD=40400000000P PS=460000U PD=560000U
* device instance $4152 r0 *1 85.195,64.27 nfet_01v8
M$4152 167 752 616 167 nfet_01v8 L=150000U W=210000U AS=21875000000P
+ AD=40400000000P PS=460000U PD=560000U
* device instance $4153 r0 *1 84.605,64.66 nfet_01v8
M$4153 2183 2091 167 167 nfet_01v8 L=150000U W=210000U AS=40400000000P
+ AD=21875000000P PS=560000U PD=460000U
* device instance $4154 r0 *1 85.195,64.66 nfet_01v8
M$4154 752 616 167 167 nfet_01v8 L=150000U W=210000U AS=40400000000P
+ AD=21875000000P PS=560000U PD=460000U
* device instance $4155 r0 *1 84.64,65.06 nfet_01v8
M$4155 121 164 2183 167 nfet_01v8 L=150000U W=140000U AS=21875000000P
+ AD=16800000000P PS=460000U PD=380000U
* device instance $4156 r0 *1 85.16,65.06 nfet_01v8
M$4156 124 164 752 167 nfet_01v8 L=150000U W=140000U AS=21875000000P
+ AD=16800000000P PS=460000U PD=380000U
* device instance $4157 r0 *1 84.64,65.45 nfet_01v8
M$4157 3126 165 121 167 nfet_01v8 L=150000U W=140000U AS=16800000000P
+ AD=21875000000P PS=380000U PD=460000U
* device instance $4158 r0 *1 85.16,65.45 nfet_01v8
M$4158 1128 165 124 167 nfet_01v8 L=150000U W=140000U AS=16800000000P
+ AD=21875000000P PS=380000U PD=460000U
* device instance $4159 r0 *1 84.605,65.85 nfet_01v8
M$4159 167 2722 3126 167 nfet_01v8 L=150000U W=210000U AS=21875000000P
+ AD=40400000000P PS=460000U PD=560000U
* device instance $4160 r0 *1 85.195,65.85 nfet_01v8
M$4160 167 1683 1128 167 nfet_01v8 L=150000U W=210000U AS=21875000000P
+ AD=40400000000P PS=460000U PD=560000U
* device instance $4161 r0 *1 84.605,66.24 nfet_01v8
M$4161 2722 3126 167 167 nfet_01v8 L=150000U W=210000U AS=40400000000P
+ AD=21875000000P PS=560000U PD=460000U
* device instance $4162 r0 *1 85.195,66.24 nfet_01v8
M$4162 1683 1128 167 167 nfet_01v8 L=150000U W=210000U AS=40400000000P
+ AD=21875000000P PS=560000U PD=460000U
* device instance $4163 r0 *1 84.64,66.64 nfet_01v8
M$4163 122 165 2722 167 nfet_01v8 L=150000U W=140000U AS=21875000000P
+ AD=16800000000P PS=460000U PD=380000U
* device instance $4164 r0 *1 85.16,66.64 nfet_01v8
M$4164 123 165 1683 167 nfet_01v8 L=150000U W=140000U AS=21875000000P
+ AD=16800000000P PS=460000U PD=380000U
* device instance $4165 r0 *1 19.24,13.31 nfet_01v8
M$4165 2375 138 26 167 nfet_01v8 L=150000U W=140000U AS=16800000000P
+ AD=21875000000P PS=380000U PD=460000U
* device instance $4166 r0 *1 19.76,13.31 nfet_01v8
M$4166 1319 138 27 167 nfet_01v8 L=150000U W=140000U AS=16800000000P
+ AD=21875000000P PS=380000U PD=460000U
* device instance $4167 r0 *1 19.205,13.71 nfet_01v8
M$4167 167 2776 2375 167 nfet_01v8 L=150000U W=210000U AS=21875000000P
+ AD=40400000000P PS=460000U PD=560000U
* device instance $4168 r0 *1 19.795,13.71 nfet_01v8
M$4168 167 1899 1319 167 nfet_01v8 L=150000U W=210000U AS=21875000000P
+ AD=40400000000P PS=460000U PD=560000U
* device instance $4169 r0 *1 19.205,14.1 nfet_01v8
M$4169 2776 2375 167 167 nfet_01v8 L=150000U W=210000U AS=40400000000P
+ AD=21875000000P PS=560000U PD=460000U
* device instance $4170 r0 *1 19.795,14.1 nfet_01v8
M$4170 1899 1319 167 167 nfet_01v8 L=150000U W=210000U AS=40400000000P
+ AD=21875000000P PS=560000U PD=460000U
* device instance $4171 r0 *1 19.24,14.5 nfet_01v8
M$4171 25 138 2776 167 nfet_01v8 L=150000U W=140000U AS=21875000000P
+ AD=16800000000P PS=460000U PD=380000U
* device instance $4172 r0 *1 19.76,14.5 nfet_01v8
M$4172 28 138 1899 167 nfet_01v8 L=150000U W=140000U AS=21875000000P
+ AD=16800000000P PS=460000U PD=380000U
* device instance $4173 r0 *1 19.24,14.89 nfet_01v8
M$4173 3295 139 25 167 nfet_01v8 L=150000U W=140000U AS=16800000000P
+ AD=21875000000P PS=380000U PD=460000U
* device instance $4174 r0 *1 19.76,14.89 nfet_01v8
M$4174 4484 139 28 167 nfet_01v8 L=150000U W=140000U AS=16800000000P
+ AD=21875000000P PS=380000U PD=460000U
* device instance $4175 r0 *1 19.205,15.29 nfet_01v8
M$4175 167 2734 3295 167 nfet_01v8 L=150000U W=210000U AS=21875000000P
+ AD=40400000000P PS=460000U PD=560000U
* device instance $4176 r0 *1 19.795,15.29 nfet_01v8
M$4176 167 792 4484 167 nfet_01v8 L=150000U W=210000U AS=21875000000P
+ AD=40400000000P PS=460000U PD=560000U
* device instance $4177 r0 *1 19.205,15.68 nfet_01v8
M$4177 2734 3295 167 167 nfet_01v8 L=150000U W=210000U AS=40400000000P
+ AD=21875000000P PS=560000U PD=460000U
* device instance $4178 r0 *1 19.795,15.68 nfet_01v8
M$4178 792 4484 167 167 nfet_01v8 L=150000U W=210000U AS=40400000000P
+ AD=21875000000P PS=560000U PD=460000U
* device instance $4179 r0 *1 19.24,16.08 nfet_01v8
M$4179 26 139 2734 167 nfet_01v8 L=150000U W=140000U AS=21875000000P
+ AD=16800000000P PS=460000U PD=380000U
* device instance $4180 r0 *1 19.76,16.08 nfet_01v8
M$4180 27 139 792 167 nfet_01v8 L=150000U W=140000U AS=21875000000P
+ AD=16800000000P PS=460000U PD=380000U
* device instance $4181 r0 *1 19.24,16.47 nfet_01v8
M$4181 2336 140 26 167 nfet_01v8 L=150000U W=140000U AS=16800000000P
+ AD=21875000000P PS=380000U PD=460000U
* device instance $4182 r0 *1 19.76,16.47 nfet_01v8
M$4182 636 140 27 167 nfet_01v8 L=150000U W=140000U AS=16800000000P
+ AD=21875000000P PS=380000U PD=460000U
* device instance $4183 r0 *1 19.205,16.87 nfet_01v8
M$4183 167 2692 2336 167 nfet_01v8 L=150000U W=210000U AS=21875000000P
+ AD=40400000000P PS=460000U PD=560000U
* device instance $4184 r0 *1 19.795,16.87 nfet_01v8
M$4184 167 788 636 167 nfet_01v8 L=150000U W=210000U AS=21875000000P
+ AD=40400000000P PS=460000U PD=560000U
* device instance $4185 r0 *1 19.205,17.26 nfet_01v8
M$4185 2692 2336 167 167 nfet_01v8 L=150000U W=210000U AS=40400000000P
+ AD=21875000000P PS=560000U PD=460000U
* device instance $4186 r0 *1 19.795,17.26 nfet_01v8
M$4186 788 636 167 167 nfet_01v8 L=150000U W=210000U AS=40400000000P
+ AD=21875000000P PS=560000U PD=460000U
* device instance $4187 r0 *1 19.24,17.66 nfet_01v8
M$4187 25 140 2692 167 nfet_01v8 L=150000U W=140000U AS=21875000000P
+ AD=16800000000P PS=460000U PD=380000U
* device instance $4188 r0 *1 19.76,17.66 nfet_01v8
M$4188 28 140 788 167 nfet_01v8 L=150000U W=140000U AS=21875000000P
+ AD=16800000000P PS=460000U PD=380000U
* device instance $4189 r0 *1 19.24,18.05 nfet_01v8
M$4189 3299 141 25 167 nfet_01v8 L=150000U W=140000U AS=16800000000P
+ AD=21875000000P PS=380000U PD=460000U
* device instance $4190 r0 *1 19.76,18.05 nfet_01v8
M$4190 1331 141 28 167 nfet_01v8 L=150000U W=140000U AS=16800000000P
+ AD=21875000000P PS=380000U PD=460000U
* device instance $4191 r0 *1 19.205,18.45 nfet_01v8
M$4191 167 2697 3299 167 nfet_01v8 L=150000U W=210000U AS=21875000000P
+ AD=40400000000P PS=460000U PD=560000U
* device instance $4192 r0 *1 19.795,18.45 nfet_01v8
M$4192 167 1912 1331 167 nfet_01v8 L=150000U W=210000U AS=21875000000P
+ AD=40400000000P PS=460000U PD=560000U
* device instance $4193 r0 *1 19.205,18.84 nfet_01v8
M$4193 2697 3299 167 167 nfet_01v8 L=150000U W=210000U AS=40400000000P
+ AD=21875000000P PS=560000U PD=460000U
* device instance $4194 r0 *1 19.795,18.84 nfet_01v8
M$4194 1912 1331 167 167 nfet_01v8 L=150000U W=210000U AS=40400000000P
+ AD=21875000000P PS=560000U PD=460000U
* device instance $4195 r0 *1 19.24,19.24 nfet_01v8
M$4195 26 141 2697 167 nfet_01v8 L=150000U W=140000U AS=21875000000P
+ AD=16800000000P PS=460000U PD=380000U
* device instance $4196 r0 *1 19.76,19.24 nfet_01v8
M$4196 27 141 1912 167 nfet_01v8 L=150000U W=140000U AS=21875000000P
+ AD=16800000000P PS=460000U PD=380000U
* device instance $4197 r0 *1 30.14,13.31 nfet_01v8
M$4197 3244 138 42 167 nfet_01v8 L=150000U W=140000U AS=16800000000P
+ AD=21875000000P PS=380000U PD=460000U
* device instance $4198 r0 *1 30.66,13.31 nfet_01v8
M$4198 1049 138 43 167 nfet_01v8 L=150000U W=140000U AS=16800000000P
+ AD=21875000000P PS=380000U PD=460000U
* device instance $4199 r0 *1 30.105,13.71 nfet_01v8
M$4199 167 3005 3244 167 nfet_01v8 L=150000U W=210000U AS=21875000000P
+ AD=40400000000P PS=460000U PD=560000U
* device instance $4200 r0 *1 30.695,13.71 nfet_01v8
M$4200 167 1592 1049 167 nfet_01v8 L=150000U W=210000U AS=21875000000P
+ AD=40400000000P PS=460000U PD=560000U
* device instance $4201 r0 *1 30.105,14.1 nfet_01v8
M$4201 3005 3244 167 167 nfet_01v8 L=150000U W=210000U AS=40400000000P
+ AD=21875000000P PS=560000U PD=460000U
* device instance $4202 r0 *1 30.695,14.1 nfet_01v8
M$4202 1592 1049 167 167 nfet_01v8 L=150000U W=210000U AS=40400000000P
+ AD=21875000000P PS=560000U PD=460000U
* device instance $4203 r0 *1 30.14,14.5 nfet_01v8
M$4203 41 138 3005 167 nfet_01v8 L=150000U W=140000U AS=21875000000P
+ AD=16800000000P PS=460000U PD=380000U
* device instance $4204 r0 *1 30.66,14.5 nfet_01v8
M$4204 44 138 1592 167 nfet_01v8 L=150000U W=140000U AS=21875000000P
+ AD=16800000000P PS=460000U PD=380000U
* device instance $4205 r0 *1 30.14,14.89 nfet_01v8
M$4205 3246 139 41 167 nfet_01v8 L=150000U W=140000U AS=16800000000P
+ AD=21875000000P PS=380000U PD=460000U
* device instance $4206 r0 *1 30.66,14.89 nfet_01v8
M$4206 4493 139 44 167 nfet_01v8 L=150000U W=140000U AS=16800000000P
+ AD=21875000000P PS=380000U PD=460000U
* device instance $4207 r0 *1 30.105,15.29 nfet_01v8
M$4207 167 2017 3246 167 nfet_01v8 L=150000U W=210000U AS=21875000000P
+ AD=40400000000P PS=460000U PD=560000U
* device instance $4208 r0 *1 30.695,15.29 nfet_01v8
M$4208 167 795 4493 167 nfet_01v8 L=150000U W=210000U AS=21875000000P
+ AD=40400000000P PS=460000U PD=560000U
* device instance $4209 r0 *1 30.105,15.68 nfet_01v8
M$4209 2017 3246 167 167 nfet_01v8 L=150000U W=210000U AS=40400000000P
+ AD=21875000000P PS=560000U PD=460000U
* device instance $4210 r0 *1 30.695,15.68 nfet_01v8
M$4210 795 4493 167 167 nfet_01v8 L=150000U W=210000U AS=40400000000P
+ AD=21875000000P PS=560000U PD=460000U
* device instance $4211 r0 *1 30.14,16.08 nfet_01v8
M$4211 42 139 2017 167 nfet_01v8 L=150000U W=140000U AS=21875000000P
+ AD=16800000000P PS=460000U PD=380000U
* device instance $4212 r0 *1 30.66,16.08 nfet_01v8
M$4212 43 139 795 167 nfet_01v8 L=150000U W=140000U AS=21875000000P
+ AD=16800000000P PS=460000U PD=380000U
* device instance $4213 r0 *1 30.14,16.47 nfet_01v8
M$4213 3247 140 42 167 nfet_01v8 L=150000U W=140000U AS=16800000000P
+ AD=21875000000P PS=380000U PD=460000U
* device instance $4214 r0 *1 30.66,16.47 nfet_01v8
M$4214 1051 140 43 167 nfet_01v8 L=150000U W=140000U AS=16800000000P
+ AD=21875000000P PS=380000U PD=460000U
* device instance $4215 r0 *1 30.105,16.87 nfet_01v8
M$4215 167 2999 3247 167 nfet_01v8 L=150000U W=210000U AS=21875000000P
+ AD=40400000000P PS=460000U PD=560000U
* device instance $4216 r0 *1 30.695,16.87 nfet_01v8
M$4216 167 1594 1051 167 nfet_01v8 L=150000U W=210000U AS=21875000000P
+ AD=40400000000P PS=460000U PD=560000U
* device instance $4217 r0 *1 30.105,17.26 nfet_01v8
M$4217 2999 3247 167 167 nfet_01v8 L=150000U W=210000U AS=40400000000P
+ AD=21875000000P PS=560000U PD=460000U
* device instance $4218 r0 *1 30.695,17.26 nfet_01v8
M$4218 1594 1051 167 167 nfet_01v8 L=150000U W=210000U AS=40400000000P
+ AD=21875000000P PS=560000U PD=460000U
* device instance $4219 r0 *1 30.14,17.66 nfet_01v8
M$4219 41 140 2999 167 nfet_01v8 L=150000U W=140000U AS=21875000000P
+ AD=16800000000P PS=460000U PD=380000U
* device instance $4220 r0 *1 30.66,17.66 nfet_01v8
M$4220 44 140 1594 167 nfet_01v8 L=150000U W=140000U AS=21875000000P
+ AD=16800000000P PS=460000U PD=380000U
* device instance $4221 r0 *1 30.14,18.05 nfet_01v8
M$4221 2491 141 41 167 nfet_01v8 L=150000U W=140000U AS=16800000000P
+ AD=21875000000P PS=380000U PD=460000U
* device instance $4222 r0 *1 30.66,18.05 nfet_01v8
M$4222 1052 141 44 167 nfet_01v8 L=150000U W=140000U AS=16800000000P
+ AD=21875000000P PS=380000U PD=460000U
* device instance $4223 r0 *1 30.105,18.45 nfet_01v8
M$4223 167 3002 2491 167 nfet_01v8 L=150000U W=210000U AS=21875000000P
+ AD=40400000000P PS=460000U PD=560000U
* device instance $4224 r0 *1 30.695,18.45 nfet_01v8
M$4224 167 1595 1052 167 nfet_01v8 L=150000U W=210000U AS=21875000000P
+ AD=40400000000P PS=460000U PD=560000U
* device instance $4225 r0 *1 30.105,18.84 nfet_01v8
M$4225 3002 2491 167 167 nfet_01v8 L=150000U W=210000U AS=40400000000P
+ AD=21875000000P PS=560000U PD=460000U
* device instance $4226 r0 *1 30.695,18.84 nfet_01v8
M$4226 1595 1052 167 167 nfet_01v8 L=150000U W=210000U AS=40400000000P
+ AD=21875000000P PS=560000U PD=460000U
* device instance $4227 r0 *1 30.14,19.24 nfet_01v8
M$4227 42 141 3002 167 nfet_01v8 L=150000U W=140000U AS=21875000000P
+ AD=16800000000P PS=460000U PD=380000U
* device instance $4228 r0 *1 30.66,19.24 nfet_01v8
M$4228 43 141 1595 167 nfet_01v8 L=150000U W=140000U AS=21875000000P
+ AD=16800000000P PS=460000U PD=380000U
* device instance $4229 r0 *1 41.04,13.31 nfet_01v8
M$4229 2498 138 58 167 nfet_01v8 L=150000U W=140000U AS=16800000000P
+ AD=21875000000P PS=380000U PD=460000U
* device instance $4230 r0 *1 41.56,13.31 nfet_01v8
M$4230 1013 138 59 167 nfet_01v8 L=150000U W=140000U AS=16800000000P
+ AD=21875000000P PS=380000U PD=460000U
* device instance $4231 r0 *1 41.005,13.71 nfet_01v8
M$4231 167 3018 2498 167 nfet_01v8 L=150000U W=210000U AS=21875000000P
+ AD=40400000000P PS=460000U PD=560000U
* device instance $4232 r0 *1 41.595,13.71 nfet_01v8
M$4232 167 1548 1013 167 nfet_01v8 L=150000U W=210000U AS=21875000000P
+ AD=40400000000P PS=460000U PD=560000U
* device instance $4233 r0 *1 41.005,14.1 nfet_01v8
M$4233 3018 2498 167 167 nfet_01v8 L=150000U W=210000U AS=40400000000P
+ AD=21875000000P PS=560000U PD=460000U
* device instance $4234 r0 *1 41.595,14.1 nfet_01v8
M$4234 1548 1013 167 167 nfet_01v8 L=150000U W=210000U AS=40400000000P
+ AD=21875000000P PS=560000U PD=460000U
* device instance $4235 r0 *1 41.04,14.5 nfet_01v8
M$4235 57 138 3018 167 nfet_01v8 L=150000U W=140000U AS=21875000000P
+ AD=16800000000P PS=460000U PD=380000U
* device instance $4236 r0 *1 41.56,14.5 nfet_01v8
M$4236 60 138 1548 167 nfet_01v8 L=150000U W=140000U AS=21875000000P
+ AD=16800000000P PS=460000U PD=380000U
* device instance $4237 r0 *1 41.04,14.89 nfet_01v8
M$4237 3200 139 57 167 nfet_01v8 L=150000U W=140000U AS=16800000000P
+ AD=21875000000P PS=380000U PD=460000U
* device instance $4238 r0 *1 41.56,14.89 nfet_01v8
M$4238 4495 139 60 167 nfet_01v8 L=150000U W=140000U AS=16800000000P
+ AD=21875000000P PS=380000U PD=460000U
* device instance $4239 r0 *1 41.005,15.29 nfet_01v8
M$4239 167 2029 3200 167 nfet_01v8 L=150000U W=210000U AS=21875000000P
+ AD=40400000000P PS=460000U PD=560000U
* device instance $4240 r0 *1 41.595,15.29 nfet_01v8
M$4240 167 866 4495 167 nfet_01v8 L=150000U W=210000U AS=21875000000P
+ AD=40400000000P PS=460000U PD=560000U
* device instance $4241 r0 *1 41.005,15.68 nfet_01v8
M$4241 2029 3200 167 167 nfet_01v8 L=150000U W=210000U AS=40400000000P
+ AD=21875000000P PS=560000U PD=460000U
* device instance $4242 r0 *1 41.595,15.68 nfet_01v8
M$4242 866 4495 167 167 nfet_01v8 L=150000U W=210000U AS=40400000000P
+ AD=21875000000P PS=560000U PD=460000U
* device instance $4243 r0 *1 41.04,16.08 nfet_01v8
M$4243 58 139 2029 167 nfet_01v8 L=150000U W=140000U AS=21875000000P
+ AD=16800000000P PS=460000U PD=380000U
* device instance $4244 r0 *1 41.56,16.08 nfet_01v8
M$4244 59 139 866 167 nfet_01v8 L=150000U W=140000U AS=21875000000P
+ AD=16800000000P PS=460000U PD=380000U
* device instance $4245 r0 *1 41.04,16.47 nfet_01v8
M$4245 3204 140 58 167 nfet_01v8 L=150000U W=140000U AS=16800000000P
+ AD=21875000000P PS=380000U PD=460000U
* device instance $4246 r0 *1 41.56,16.47 nfet_01v8
M$4246 1041 140 59 167 nfet_01v8 L=150000U W=140000U AS=16800000000P
+ AD=21875000000P PS=380000U PD=460000U
* device instance $4247 r0 *1 41.005,16.87 nfet_01v8
M$4247 167 3044 3204 167 nfet_01v8 L=150000U W=210000U AS=21875000000P
+ AD=40400000000P PS=460000U PD=560000U
* device instance $4248 r0 *1 41.595,16.87 nfet_01v8
M$4248 167 1582 1041 167 nfet_01v8 L=150000U W=210000U AS=21875000000P
+ AD=40400000000P PS=460000U PD=560000U
* device instance $4249 r0 *1 41.005,17.26 nfet_01v8
M$4249 3044 3204 167 167 nfet_01v8 L=150000U W=210000U AS=40400000000P
+ AD=21875000000P PS=560000U PD=460000U
* device instance $4250 r0 *1 41.595,17.26 nfet_01v8
M$4250 1582 1041 167 167 nfet_01v8 L=150000U W=210000U AS=40400000000P
+ AD=21875000000P PS=560000U PD=460000U
* device instance $4251 r0 *1 41.04,17.66 nfet_01v8
M$4251 57 140 3044 167 nfet_01v8 L=150000U W=140000U AS=21875000000P
+ AD=16800000000P PS=460000U PD=380000U
* device instance $4252 r0 *1 41.56,17.66 nfet_01v8
M$4252 60 140 1582 167 nfet_01v8 L=150000U W=140000U AS=21875000000P
+ AD=16800000000P PS=460000U PD=380000U
* device instance $4253 r0 *1 41.04,18.05 nfet_01v8
M$4253 3235 141 57 167 nfet_01v8 L=150000U W=140000U AS=16800000000P
+ AD=21875000000P PS=380000U PD=460000U
* device instance $4254 r0 *1 41.56,18.05 nfet_01v8
M$4254 1042 141 60 167 nfet_01v8 L=150000U W=140000U AS=16800000000P
+ AD=21875000000P PS=380000U PD=460000U
* device instance $4255 r0 *1 41.005,18.45 nfet_01v8
M$4255 167 3036 3235 167 nfet_01v8 L=150000U W=210000U AS=21875000000P
+ AD=40400000000P PS=460000U PD=560000U
* device instance $4256 r0 *1 41.595,18.45 nfet_01v8
M$4256 167 1583 1042 167 nfet_01v8 L=150000U W=210000U AS=21875000000P
+ AD=40400000000P PS=460000U PD=560000U
* device instance $4257 r0 *1 41.005,18.84 nfet_01v8
M$4257 3036 3235 167 167 nfet_01v8 L=150000U W=210000U AS=40400000000P
+ AD=21875000000P PS=560000U PD=460000U
* device instance $4258 r0 *1 41.595,18.84 nfet_01v8
M$4258 1583 1042 167 167 nfet_01v8 L=150000U W=210000U AS=40400000000P
+ AD=21875000000P PS=560000U PD=460000U
* device instance $4259 r0 *1 41.04,19.24 nfet_01v8
M$4259 58 141 3036 167 nfet_01v8 L=150000U W=140000U AS=21875000000P
+ AD=16800000000P PS=460000U PD=380000U
* device instance $4260 r0 *1 41.56,19.24 nfet_01v8
M$4260 59 141 1583 167 nfet_01v8 L=150000U W=140000U AS=21875000000P
+ AD=16800000000P PS=460000U PD=380000U
* device instance $4261 r0 *1 51.94,13.31 nfet_01v8
M$4261 2386 138 74 167 nfet_01v8 L=150000U W=140000U AS=16800000000P
+ AD=21875000000P PS=380000U PD=460000U
* device instance $4262 r0 *1 52.46,13.31 nfet_01v8
M$4262 1152 138 75 167 nfet_01v8 L=150000U W=140000U AS=16800000000P
+ AD=21875000000P PS=380000U PD=460000U
* device instance $4263 r0 *1 51.905,13.71 nfet_01v8
M$4263 167 2792 2386 167 nfet_01v8 L=150000U W=210000U AS=21875000000P
+ AD=40400000000P PS=460000U PD=560000U
* device instance $4264 r0 *1 52.495,13.71 nfet_01v8
M$4264 167 1710 1152 167 nfet_01v8 L=150000U W=210000U AS=21875000000P
+ AD=40400000000P PS=460000U PD=560000U
* device instance $4265 r0 *1 51.905,14.1 nfet_01v8
M$4265 2792 2386 167 167 nfet_01v8 L=150000U W=210000U AS=40400000000P
+ AD=21875000000P PS=560000U PD=460000U
* device instance $4266 r0 *1 52.495,14.1 nfet_01v8
M$4266 1710 1152 167 167 nfet_01v8 L=150000U W=210000U AS=40400000000P
+ AD=21875000000P PS=560000U PD=460000U
* device instance $4267 r0 *1 51.94,14.5 nfet_01v8
M$4267 73 138 2792 167 nfet_01v8 L=150000U W=140000U AS=21875000000P
+ AD=16800000000P PS=460000U PD=380000U
* device instance $4268 r0 *1 52.46,14.5 nfet_01v8
M$4268 76 138 1710 167 nfet_01v8 L=150000U W=140000U AS=21875000000P
+ AD=16800000000P PS=460000U PD=380000U
* device instance $4269 r0 *1 51.94,14.89 nfet_01v8
M$4269 3364 139 73 167 nfet_01v8 L=150000U W=140000U AS=16800000000P
+ AD=21875000000P PS=380000U PD=460000U
* device instance $4270 r0 *1 52.46,14.89 nfet_01v8
M$4270 4375 139 76 167 nfet_01v8 L=150000U W=140000U AS=16800000000P
+ AD=21875000000P PS=380000U PD=460000U
* device instance $4271 r0 *1 51.905,15.29 nfet_01v8
M$4271 167 2788 3364 167 nfet_01v8 L=150000U W=210000U AS=21875000000P
+ AD=40400000000P PS=460000U PD=560000U
* device instance $4272 r0 *1 52.495,15.29 nfet_01v8
M$4272 167 1712 4375 167 nfet_01v8 L=150000U W=210000U AS=21875000000P
+ AD=40400000000P PS=460000U PD=560000U
* device instance $4273 r0 *1 51.905,15.68 nfet_01v8
M$4273 2788 3364 167 167 nfet_01v8 L=150000U W=210000U AS=40400000000P
+ AD=21875000000P PS=560000U PD=460000U
* device instance $4274 r0 *1 52.495,15.68 nfet_01v8
M$4274 1712 4375 167 167 nfet_01v8 L=150000U W=210000U AS=40400000000P
+ AD=21875000000P PS=560000U PD=460000U
* device instance $4275 r0 *1 51.94,16.08 nfet_01v8
M$4275 74 139 2788 167 nfet_01v8 L=150000U W=140000U AS=21875000000P
+ AD=16800000000P PS=460000U PD=380000U
* device instance $4276 r0 *1 52.46,16.08 nfet_01v8
M$4276 75 139 1712 167 nfet_01v8 L=150000U W=140000U AS=21875000000P
+ AD=16800000000P PS=460000U PD=380000U
* device instance $4277 r0 *1 51.94,16.47 nfet_01v8
M$4277 2365 140 74 167 nfet_01v8 L=150000U W=140000U AS=16800000000P
+ AD=21875000000P PS=380000U PD=460000U
* device instance $4278 r0 *1 52.46,16.47 nfet_01v8
M$4278 1154 140 75 167 nfet_01v8 L=150000U W=140000U AS=16800000000P
+ AD=21875000000P PS=380000U PD=460000U
* device instance $4279 r0 *1 51.905,16.87 nfet_01v8
M$4279 167 2758 2365 167 nfet_01v8 L=150000U W=210000U AS=21875000000P
+ AD=40400000000P PS=460000U PD=560000U
* device instance $4280 r0 *1 52.495,16.87 nfet_01v8
M$4280 167 1713 1154 167 nfet_01v8 L=150000U W=210000U AS=21875000000P
+ AD=40400000000P PS=460000U PD=560000U
* device instance $4281 r0 *1 51.905,17.26 nfet_01v8
M$4281 2758 2365 167 167 nfet_01v8 L=150000U W=210000U AS=40400000000P
+ AD=21875000000P PS=560000U PD=460000U
* device instance $4282 r0 *1 52.495,17.26 nfet_01v8
M$4282 1713 1154 167 167 nfet_01v8 L=150000U W=210000U AS=40400000000P
+ AD=21875000000P PS=560000U PD=460000U
* device instance $4283 r0 *1 51.94,17.66 nfet_01v8
M$4283 73 140 2758 167 nfet_01v8 L=150000U W=140000U AS=21875000000P
+ AD=16800000000P PS=460000U PD=380000U
* device instance $4284 r0 *1 52.46,17.66 nfet_01v8
M$4284 76 140 1713 167 nfet_01v8 L=150000U W=140000U AS=21875000000P
+ AD=16800000000P PS=460000U PD=380000U
* device instance $4285 r0 *1 51.94,18.05 nfet_01v8
M$4285 3366 141 73 167 nfet_01v8 L=150000U W=140000U AS=16800000000P
+ AD=21875000000P PS=380000U PD=460000U
* device instance $4286 r0 *1 52.46,18.05 nfet_01v8
M$4286 1155 141 76 167 nfet_01v8 L=150000U W=140000U AS=16800000000P
+ AD=21875000000P PS=380000U PD=460000U
* device instance $4287 r0 *1 51.905,18.45 nfet_01v8
M$4287 167 2757 3366 167 nfet_01v8 L=150000U W=210000U AS=21875000000P
+ AD=40400000000P PS=460000U PD=560000U
* device instance $4288 r0 *1 52.495,18.45 nfet_01v8
M$4288 167 1714 1155 167 nfet_01v8 L=150000U W=210000U AS=21875000000P
+ AD=40400000000P PS=460000U PD=560000U
* device instance $4289 r0 *1 51.905,18.84 nfet_01v8
M$4289 2757 3366 167 167 nfet_01v8 L=150000U W=210000U AS=40400000000P
+ AD=21875000000P PS=560000U PD=460000U
* device instance $4290 r0 *1 52.495,18.84 nfet_01v8
M$4290 1714 1155 167 167 nfet_01v8 L=150000U W=210000U AS=40400000000P
+ AD=21875000000P PS=560000U PD=460000U
* device instance $4291 r0 *1 51.94,19.24 nfet_01v8
M$4291 74 141 2757 167 nfet_01v8 L=150000U W=140000U AS=21875000000P
+ AD=16800000000P PS=460000U PD=380000U
* device instance $4292 r0 *1 52.46,19.24 nfet_01v8
M$4292 75 141 1714 167 nfet_01v8 L=150000U W=140000U AS=21875000000P
+ AD=16800000000P PS=460000U PD=380000U
* device instance $4293 r0 *1 62.84,13.31 nfet_01v8
M$4293 3361 138 90 167 nfet_01v8 L=150000U W=140000U AS=16800000000P
+ AD=21875000000P PS=380000U PD=460000U
* device instance $4294 r0 *1 63.36,13.31 nfet_01v8
M$4294 1185 138 91 167 nfet_01v8 L=150000U W=140000U AS=16800000000P
+ AD=21875000000P PS=380000U PD=460000U
* device instance $4295 r0 *1 62.805,13.71 nfet_01v8
M$4295 167 2702 3361 167 nfet_01v8 L=150000U W=210000U AS=21875000000P
+ AD=40400000000P PS=460000U PD=560000U
* device instance $4296 r0 *1 63.395,13.71 nfet_01v8
M$4296 167 1749 1185 167 nfet_01v8 L=150000U W=210000U AS=21875000000P
+ AD=40400000000P PS=460000U PD=560000U
* device instance $4297 r0 *1 62.805,14.1 nfet_01v8
M$4297 2702 3361 167 167 nfet_01v8 L=150000U W=210000U AS=40400000000P
+ AD=21875000000P PS=560000U PD=460000U
* device instance $4298 r0 *1 63.395,14.1 nfet_01v8
M$4298 1749 1185 167 167 nfet_01v8 L=150000U W=210000U AS=40400000000P
+ AD=21875000000P PS=560000U PD=460000U
* device instance $4299 r0 *1 62.84,14.5 nfet_01v8
M$4299 89 138 2702 167 nfet_01v8 L=150000U W=140000U AS=21875000000P
+ AD=16800000000P PS=460000U PD=380000U
* device instance $4300 r0 *1 63.36,14.5 nfet_01v8
M$4300 92 138 1749 167 nfet_01v8 L=150000U W=140000U AS=21875000000P
+ AD=16800000000P PS=460000U PD=380000U
* device instance $4301 r0 *1 62.84,14.89 nfet_01v8
M$4301 3358 139 89 167 nfet_01v8 L=150000U W=140000U AS=16800000000P
+ AD=21875000000P PS=380000U PD=460000U
* device instance $4302 r0 *1 63.36,14.89 nfet_01v8
M$4302 4368 139 92 167 nfet_01v8 L=150000U W=140000U AS=16800000000P
+ AD=21875000000P PS=380000U PD=460000U
* device instance $4303 r0 *1 62.805,15.29 nfet_01v8
M$4303 167 1990 3358 167 nfet_01v8 L=150000U W=210000U AS=21875000000P
+ AD=40400000000P PS=460000U PD=560000U
* device instance $4304 r0 *1 63.395,15.29 nfet_01v8
M$4304 167 817 4368 167 nfet_01v8 L=150000U W=210000U AS=21875000000P
+ AD=40400000000P PS=460000U PD=560000U
* device instance $4305 r0 *1 62.805,15.68 nfet_01v8
M$4305 1990 3358 167 167 nfet_01v8 L=150000U W=210000U AS=40400000000P
+ AD=21875000000P PS=560000U PD=460000U
* device instance $4306 r0 *1 63.395,15.68 nfet_01v8
M$4306 817 4368 167 167 nfet_01v8 L=150000U W=210000U AS=40400000000P
+ AD=21875000000P PS=560000U PD=460000U
* device instance $4307 r0 *1 62.84,16.08 nfet_01v8
M$4307 90 139 1990 167 nfet_01v8 L=150000U W=140000U AS=21875000000P
+ AD=16800000000P PS=460000U PD=380000U
* device instance $4308 r0 *1 63.36,16.08 nfet_01v8
M$4308 91 139 817 167 nfet_01v8 L=150000U W=140000U AS=21875000000P
+ AD=16800000000P PS=460000U PD=380000U
* device instance $4309 r0 *1 62.84,16.47 nfet_01v8
M$4309 3360 140 90 167 nfet_01v8 L=150000U W=140000U AS=16800000000P
+ AD=21875000000P PS=380000U PD=460000U
* device instance $4310 r0 *1 63.36,16.47 nfet_01v8
M$4310 672 140 91 167 nfet_01v8 L=150000U W=140000U AS=16800000000P
+ AD=21875000000P PS=380000U PD=460000U
* device instance $4311 r0 *1 62.805,16.87 nfet_01v8
M$4311 167 2754 3360 167 nfet_01v8 L=150000U W=210000U AS=21875000000P
+ AD=40400000000P PS=460000U PD=560000U
* device instance $4312 r0 *1 63.395,16.87 nfet_01v8
M$4312 167 870 672 167 nfet_01v8 L=150000U W=210000U AS=21875000000P
+ AD=40400000000P PS=460000U PD=560000U
* device instance $4313 r0 *1 62.805,17.26 nfet_01v8
M$4313 2754 3360 167 167 nfet_01v8 L=150000U W=210000U AS=40400000000P
+ AD=21875000000P PS=560000U PD=460000U
* device instance $4314 r0 *1 63.395,17.26 nfet_01v8
M$4314 870 672 167 167 nfet_01v8 L=150000U W=210000U AS=40400000000P
+ AD=21875000000P PS=560000U PD=460000U
* device instance $4315 r0 *1 62.84,17.66 nfet_01v8
M$4315 89 140 2754 167 nfet_01v8 L=150000U W=140000U AS=21875000000P
+ AD=16800000000P PS=460000U PD=380000U
* device instance $4316 r0 *1 63.36,17.66 nfet_01v8
M$4316 92 140 870 167 nfet_01v8 L=150000U W=140000U AS=21875000000P
+ AD=16800000000P PS=460000U PD=380000U
* device instance $4317 r0 *1 62.84,18.05 nfet_01v8
M$4317 2340 141 89 167 nfet_01v8 L=150000U W=140000U AS=16800000000P
+ AD=21875000000P PS=380000U PD=460000U
* device instance $4318 r0 *1 63.36,18.05 nfet_01v8
M$4318 1176 141 92 167 nfet_01v8 L=150000U W=140000U AS=16800000000P
+ AD=21875000000P PS=380000U PD=460000U
* device instance $4319 r0 *1 62.805,18.45 nfet_01v8
M$4319 167 2707 2340 167 nfet_01v8 L=150000U W=210000U AS=21875000000P
+ AD=40400000000P PS=460000U PD=560000U
* device instance $4320 r0 *1 63.395,18.45 nfet_01v8
M$4320 167 1739 1176 167 nfet_01v8 L=150000U W=210000U AS=21875000000P
+ AD=40400000000P PS=460000U PD=560000U
* device instance $4321 r0 *1 62.805,18.84 nfet_01v8
M$4321 2707 2340 167 167 nfet_01v8 L=150000U W=210000U AS=40400000000P
+ AD=21875000000P PS=560000U PD=460000U
* device instance $4322 r0 *1 63.395,18.84 nfet_01v8
M$4322 1739 1176 167 167 nfet_01v8 L=150000U W=210000U AS=40400000000P
+ AD=21875000000P PS=560000U PD=460000U
* device instance $4323 r0 *1 62.84,19.24 nfet_01v8
M$4323 90 141 2707 167 nfet_01v8 L=150000U W=140000U AS=21875000000P
+ AD=16800000000P PS=460000U PD=380000U
* device instance $4324 r0 *1 63.36,19.24 nfet_01v8
M$4324 91 141 1739 167 nfet_01v8 L=150000U W=140000U AS=21875000000P
+ AD=16800000000P PS=460000U PD=380000U
* device instance $4325 r0 *1 73.74,13.31 nfet_01v8
M$4325 3372 138 106 167 nfet_01v8 L=150000U W=140000U AS=16800000000P
+ AD=21875000000P PS=380000U PD=460000U
* device instance $4326 r0 *1 74.26,13.31 nfet_01v8
M$4326 1119 138 107 167 nfet_01v8 L=150000U W=140000U AS=16800000000P
+ AD=21875000000P PS=380000U PD=460000U
* device instance $4327 r0 *1 73.705,13.71 nfet_01v8
M$4327 167 3025 3372 167 nfet_01v8 L=150000U W=210000U AS=21875000000P
+ AD=40400000000P PS=460000U PD=560000U
* device instance $4328 r0 *1 74.295,13.71 nfet_01v8
M$4328 167 1674 1119 167 nfet_01v8 L=150000U W=210000U AS=21875000000P
+ AD=40400000000P PS=460000U PD=560000U
* device instance $4329 r0 *1 73.705,14.1 nfet_01v8
M$4329 3025 3372 167 167 nfet_01v8 L=150000U W=210000U AS=40400000000P
+ AD=21875000000P PS=560000U PD=460000U
* device instance $4330 r0 *1 74.295,14.1 nfet_01v8
M$4330 1674 1119 167 167 nfet_01v8 L=150000U W=210000U AS=40400000000P
+ AD=21875000000P PS=560000U PD=460000U
* device instance $4331 r0 *1 73.74,14.5 nfet_01v8
M$4331 105 138 3025 167 nfet_01v8 L=150000U W=140000U AS=21875000000P
+ AD=16800000000P PS=460000U PD=380000U
* device instance $4332 r0 *1 74.26,14.5 nfet_01v8
M$4332 108 138 1674 167 nfet_01v8 L=150000U W=140000U AS=21875000000P
+ AD=16800000000P PS=460000U PD=380000U
* device instance $4333 r0 *1 73.74,14.89 nfet_01v8
M$4333 3402 139 105 167 nfet_01v8 L=150000U W=140000U AS=16800000000P
+ AD=21875000000P PS=380000U PD=460000U
* device instance $4334 r0 *1 74.26,14.89 nfet_01v8
M$4334 4347 139 108 167 nfet_01v8 L=150000U W=140000U AS=16800000000P
+ AD=21875000000P PS=380000U PD=460000U
* device instance $4335 r0 *1 73.705,15.29 nfet_01v8
M$4335 167 2032 3402 167 nfet_01v8 L=150000U W=210000U AS=21875000000P
+ AD=40400000000P PS=460000U PD=560000U
* device instance $4336 r0 *1 74.295,15.29 nfet_01v8
M$4336 167 702 4347 167 nfet_01v8 L=150000U W=210000U AS=21875000000P
+ AD=40400000000P PS=460000U PD=560000U
* device instance $4337 r0 *1 73.705,15.68 nfet_01v8
M$4337 2032 3402 167 167 nfet_01v8 L=150000U W=210000U AS=40400000000P
+ AD=21875000000P PS=560000U PD=460000U
* device instance $4338 r0 *1 74.295,15.68 nfet_01v8
M$4338 702 4347 167 167 nfet_01v8 L=150000U W=210000U AS=40400000000P
+ AD=21875000000P PS=560000U PD=460000U
* device instance $4339 r0 *1 73.74,16.08 nfet_01v8
M$4339 106 139 2032 167 nfet_01v8 L=150000U W=140000U AS=21875000000P
+ AD=16800000000P PS=460000U PD=380000U
* device instance $4340 r0 *1 74.26,16.08 nfet_01v8
M$4340 107 139 702 167 nfet_01v8 L=150000U W=140000U AS=21875000000P
+ AD=16800000000P PS=460000U PD=380000U
* device instance $4341 r0 *1 73.74,16.47 nfet_01v8
M$4341 2072 140 106 167 nfet_01v8 L=150000U W=140000U AS=16800000000P
+ AD=21875000000P PS=380000U PD=460000U
* device instance $4342 r0 *1 74.26,16.47 nfet_01v8
M$4342 611 140 107 167 nfet_01v8 L=150000U W=140000U AS=16800000000P
+ AD=21875000000P PS=380000U PD=460000U
* device instance $4343 r0 *1 73.705,16.87 nfet_01v8
M$4343 167 2140 2072 167 nfet_01v8 L=150000U W=210000U AS=21875000000P
+ AD=40400000000P PS=460000U PD=560000U
* device instance $4344 r0 *1 74.295,16.87 nfet_01v8
M$4344 167 744 611 167 nfet_01v8 L=150000U W=210000U AS=21875000000P
+ AD=40400000000P PS=460000U PD=560000U
* device instance $4345 r0 *1 73.705,17.26 nfet_01v8
M$4345 2140 2072 167 167 nfet_01v8 L=150000U W=210000U AS=40400000000P
+ AD=21875000000P PS=560000U PD=460000U
* device instance $4346 r0 *1 74.295,17.26 nfet_01v8
M$4346 744 611 167 167 nfet_01v8 L=150000U W=210000U AS=40400000000P
+ AD=21875000000P PS=560000U PD=460000U
* device instance $4347 r0 *1 73.74,17.66 nfet_01v8
M$4347 105 140 2140 167 nfet_01v8 L=150000U W=140000U AS=21875000000P
+ AD=16800000000P PS=460000U PD=380000U
* device instance $4348 r0 *1 74.26,17.66 nfet_01v8
M$4348 108 140 744 167 nfet_01v8 L=150000U W=140000U AS=21875000000P
+ AD=16800000000P PS=460000U PD=380000U
* device instance $4349 r0 *1 73.74,18.05 nfet_01v8
M$4349 2459 141 105 167 nfet_01v8 L=150000U W=140000U AS=16800000000P
+ AD=21875000000P PS=380000U PD=460000U
* device instance $4350 r0 *1 74.26,18.05 nfet_01v8
M$4350 1116 141 108 167 nfet_01v8 L=150000U W=140000U AS=16800000000P
+ AD=21875000000P PS=380000U PD=460000U
* device instance $4351 r0 *1 73.705,18.45 nfet_01v8
M$4351 167 2938 2459 167 nfet_01v8 L=150000U W=210000U AS=21875000000P
+ AD=40400000000P PS=460000U PD=560000U
* device instance $4352 r0 *1 74.295,18.45 nfet_01v8
M$4352 167 1670 1116 167 nfet_01v8 L=150000U W=210000U AS=21875000000P
+ AD=40400000000P PS=460000U PD=560000U
* device instance $4353 r0 *1 73.705,18.84 nfet_01v8
M$4353 2938 2459 167 167 nfet_01v8 L=150000U W=210000U AS=40400000000P
+ AD=21875000000P PS=560000U PD=460000U
* device instance $4354 r0 *1 74.295,18.84 nfet_01v8
M$4354 1670 1116 167 167 nfet_01v8 L=150000U W=210000U AS=40400000000P
+ AD=21875000000P PS=560000U PD=460000U
* device instance $4355 r0 *1 73.74,19.24 nfet_01v8
M$4355 106 141 2938 167 nfet_01v8 L=150000U W=140000U AS=21875000000P
+ AD=16800000000P PS=460000U PD=380000U
* device instance $4356 r0 *1 74.26,19.24 nfet_01v8
M$4356 107 141 1670 167 nfet_01v8 L=150000U W=140000U AS=21875000000P
+ AD=16800000000P PS=460000U PD=380000U
* device instance $4357 r0 *1 8.34,5.41 nfet_01v8
M$4357 2542 134 10 167 nfet_01v8 L=150000U W=140000U AS=16800000000P
+ AD=21875000000P PS=380000U PD=460000U
* device instance $4358 r0 *1 8.86,5.41 nfet_01v8
M$4358 1023 134 11 167 nfet_01v8 L=150000U W=140000U AS=16800000000P
+ AD=21875000000P PS=380000U PD=460000U
* device instance $4359 r0 *1 8.305,5.81 nfet_01v8
M$4359 167 3117 2542 167 nfet_01v8 L=150000U W=210000U AS=21875000000P
+ AD=40400000000P PS=460000U PD=560000U
* device instance $4360 r0 *1 8.895,5.81 nfet_01v8
M$4360 167 1560 1023 167 nfet_01v8 L=150000U W=210000U AS=21875000000P
+ AD=40400000000P PS=460000U PD=560000U
* device instance $4361 r0 *1 8.305,6.2 nfet_01v8
M$4361 3117 2542 167 167 nfet_01v8 L=150000U W=210000U AS=40400000000P
+ AD=21875000000P PS=560000U PD=460000U
* device instance $4362 r0 *1 8.895,6.2 nfet_01v8
M$4362 1560 1023 167 167 nfet_01v8 L=150000U W=210000U AS=40400000000P
+ AD=21875000000P PS=560000U PD=460000U
* device instance $4363 r0 *1 8.34,6.6 nfet_01v8
M$4363 9 134 3117 167 nfet_01v8 L=150000U W=140000U AS=21875000000P
+ AD=16800000000P PS=460000U PD=380000U
* device instance $4364 r0 *1 8.86,6.6 nfet_01v8
M$4364 12 134 1560 167 nfet_01v8 L=150000U W=140000U AS=21875000000P
+ AD=16800000000P PS=460000U PD=380000U
* device instance $4365 r0 *1 8.34,6.99 nfet_01v8
M$4365 3215 135 9 167 nfet_01v8 L=150000U W=140000U AS=16800000000P
+ AD=21875000000P PS=380000U PD=460000U
* device instance $4366 r0 *1 8.86,6.99 nfet_01v8
M$4366 4502 135 12 167 nfet_01v8 L=150000U W=140000U AS=16800000000P
+ AD=21875000000P PS=380000U PD=460000U
* device instance $4367 r0 *1 8.305,7.39 nfet_01v8
M$4367 167 2050 3215 167 nfet_01v8 L=150000U W=210000U AS=21875000000P
+ AD=40400000000P PS=460000U PD=560000U
* device instance $4368 r0 *1 8.895,7.39 nfet_01v8
M$4368 167 1556 4502 167 nfet_01v8 L=150000U W=210000U AS=21875000000P
+ AD=40400000000P PS=460000U PD=560000U
* device instance $4369 r0 *1 8.305,7.78 nfet_01v8
M$4369 2050 3215 167 167 nfet_01v8 L=150000U W=210000U AS=40400000000P
+ AD=21875000000P PS=560000U PD=460000U
* device instance $4370 r0 *1 8.895,7.78 nfet_01v8
M$4370 1556 4502 167 167 nfet_01v8 L=150000U W=210000U AS=40400000000P
+ AD=21875000000P PS=560000U PD=460000U
* device instance $4371 r0 *1 8.34,8.18 nfet_01v8
M$4371 10 135 2050 167 nfet_01v8 L=150000U W=140000U AS=21875000000P
+ AD=16800000000P PS=460000U PD=380000U
* device instance $4372 r0 *1 8.86,8.18 nfet_01v8
M$4372 11 135 1556 167 nfet_01v8 L=150000U W=140000U AS=21875000000P
+ AD=16800000000P PS=460000U PD=380000U
* device instance $4373 r0 *1 8.34,8.57 nfet_01v8
M$4373 2520 136 10 167 nfet_01v8 L=150000U W=140000U AS=16800000000P
+ AD=21875000000P PS=380000U PD=460000U
* device instance $4374 r0 *1 8.86,8.57 nfet_01v8
M$4374 1020 136 11 167 nfet_01v8 L=150000U W=140000U AS=16800000000P
+ AD=21875000000P PS=380000U PD=460000U
* device instance $4375 r0 *1 8.305,8.97 nfet_01v8
M$4375 167 3076 2520 167 nfet_01v8 L=150000U W=210000U AS=21875000000P
+ AD=40400000000P PS=460000U PD=560000U
* device instance $4376 r0 *1 8.895,8.97 nfet_01v8
M$4376 167 1555 1020 167 nfet_01v8 L=150000U W=210000U AS=21875000000P
+ AD=40400000000P PS=460000U PD=560000U
* device instance $4377 r0 *1 8.305,9.36 nfet_01v8
M$4377 3076 2520 167 167 nfet_01v8 L=150000U W=210000U AS=40400000000P
+ AD=21875000000P PS=560000U PD=460000U
* device instance $4378 r0 *1 8.895,9.36 nfet_01v8
M$4378 1555 1020 167 167 nfet_01v8 L=150000U W=210000U AS=40400000000P
+ AD=21875000000P PS=560000U PD=460000U
* device instance $4379 r0 *1 8.34,9.76 nfet_01v8
M$4379 9 136 3076 167 nfet_01v8 L=150000U W=140000U AS=21875000000P
+ AD=16800000000P PS=460000U PD=380000U
* device instance $4380 r0 *1 8.86,9.76 nfet_01v8
M$4380 12 136 1555 167 nfet_01v8 L=150000U W=140000U AS=21875000000P
+ AD=16800000000P PS=460000U PD=380000U
* device instance $4381 r0 *1 8.34,10.15 nfet_01v8
M$4381 2346 137 9 167 nfet_01v8 L=150000U W=140000U AS=16800000000P
+ AD=21875000000P PS=380000U PD=460000U
* device instance $4382 r0 *1 8.86,10.15 nfet_01v8
M$4382 1302 137 12 167 nfet_01v8 L=150000U W=140000U AS=16800000000P
+ AD=21875000000P PS=380000U PD=460000U
* device instance $4383 r0 *1 8.305,10.55 nfet_01v8
M$4383 167 2719 2346 167 nfet_01v8 L=150000U W=210000U AS=21875000000P
+ AD=40400000000P PS=460000U PD=560000U
* device instance $4384 r0 *1 8.895,10.55 nfet_01v8
M$4384 167 1880 1302 167 nfet_01v8 L=150000U W=210000U AS=21875000000P
+ AD=40400000000P PS=460000U PD=560000U
* device instance $4385 r0 *1 8.305,10.94 nfet_01v8
M$4385 2719 2346 167 167 nfet_01v8 L=150000U W=210000U AS=40400000000P
+ AD=21875000000P PS=560000U PD=460000U
* device instance $4386 r0 *1 8.895,10.94 nfet_01v8
M$4386 1880 1302 167 167 nfet_01v8 L=150000U W=210000U AS=40400000000P
+ AD=21875000000P PS=560000U PD=460000U
* device instance $4387 r0 *1 8.34,11.34 nfet_01v8
M$4387 10 137 2719 167 nfet_01v8 L=150000U W=140000U AS=21875000000P
+ AD=16800000000P PS=460000U PD=380000U
* device instance $4388 r0 *1 8.86,11.34 nfet_01v8
M$4388 11 137 1880 167 nfet_01v8 L=150000U W=140000U AS=21875000000P
+ AD=16800000000P PS=460000U PD=380000U
* device instance $4389 r0 *1 19.24,5.41 nfet_01v8
M$4389 2471 134 26 167 nfet_01v8 L=150000U W=140000U AS=16800000000P
+ AD=21875000000P PS=380000U PD=460000U
* device instance $4390 r0 *1 19.76,5.41 nfet_01v8
M$4390 1001 134 27 167 nfet_01v8 L=150000U W=140000U AS=16800000000P
+ AD=21875000000P PS=380000U PD=460000U
* device instance $4391 r0 *1 19.205,5.81 nfet_01v8
M$4391 167 2966 2471 167 nfet_01v8 L=150000U W=210000U AS=21875000000P
+ AD=40400000000P PS=460000U PD=560000U
* device instance $4392 r0 *1 19.795,5.81 nfet_01v8
M$4392 167 1536 1001 167 nfet_01v8 L=150000U W=210000U AS=21875000000P
+ AD=40400000000P PS=460000U PD=560000U
* device instance $4393 r0 *1 19.205,6.2 nfet_01v8
M$4393 2966 2471 167 167 nfet_01v8 L=150000U W=210000U AS=40400000000P
+ AD=21875000000P PS=560000U PD=460000U
* device instance $4394 r0 *1 19.795,6.2 nfet_01v8
M$4394 1536 1001 167 167 nfet_01v8 L=150000U W=210000U AS=40400000000P
+ AD=21875000000P PS=560000U PD=460000U
* device instance $4395 r0 *1 19.24,6.6 nfet_01v8
M$4395 25 134 2966 167 nfet_01v8 L=150000U W=140000U AS=21875000000P
+ AD=16800000000P PS=460000U PD=380000U
* device instance $4396 r0 *1 19.76,6.6 nfet_01v8
M$4396 28 134 1536 167 nfet_01v8 L=150000U W=140000U AS=21875000000P
+ AD=16800000000P PS=460000U PD=380000U
* device instance $4397 r0 *1 19.24,6.99 nfet_01v8
M$4397 3188 135 25 167 nfet_01v8 L=150000U W=140000U AS=16800000000P
+ AD=21875000000P PS=380000U PD=460000U
* device instance $4398 r0 *1 19.76,6.99 nfet_01v8
M$4398 4492 135 28 167 nfet_01v8 L=150000U W=140000U AS=16800000000P
+ AD=21875000000P PS=380000U PD=460000U
* device instance $4399 r0 *1 19.205,7.39 nfet_01v8
M$4399 167 2141 3188 167 nfet_01v8 L=150000U W=210000U AS=21875000000P
+ AD=40400000000P PS=460000U PD=560000U
* device instance $4400 r0 *1 19.795,7.39 nfet_01v8
M$4400 167 824 4492 167 nfet_01v8 L=150000U W=210000U AS=21875000000P
+ AD=40400000000P PS=460000U PD=560000U
* device instance $4401 r0 *1 19.205,7.78 nfet_01v8
M$4401 2141 3188 167 167 nfet_01v8 L=150000U W=210000U AS=40400000000P
+ AD=21875000000P PS=560000U PD=460000U
* device instance $4402 r0 *1 19.795,7.78 nfet_01v8
M$4402 824 4492 167 167 nfet_01v8 L=150000U W=210000U AS=40400000000P
+ AD=21875000000P PS=560000U PD=460000U
* device instance $4403 r0 *1 19.24,8.18 nfet_01v8
M$4403 26 135 2141 167 nfet_01v8 L=150000U W=140000U AS=21875000000P
+ AD=16800000000P PS=460000U PD=380000U
* device instance $4404 r0 *1 19.76,8.18 nfet_01v8
M$4404 27 135 824 167 nfet_01v8 L=150000U W=140000U AS=21875000000P
+ AD=16800000000P PS=460000U PD=380000U
* device instance $4405 r0 *1 19.24,8.57 nfet_01v8
M$4405 3189 136 26 167 nfet_01v8 L=150000U W=140000U AS=16800000000P
+ AD=21875000000P PS=380000U PD=460000U
* device instance $4406 r0 *1 19.76,8.57 nfet_01v8
M$4406 651 136 27 167 nfet_01v8 L=150000U W=140000U AS=16800000000P
+ AD=21875000000P PS=380000U PD=460000U
* device instance $4407 r0 *1 19.205,8.97 nfet_01v8
M$4407 167 2247 3189 167 nfet_01v8 L=150000U W=210000U AS=21875000000P
+ AD=40400000000P PS=460000U PD=560000U
* device instance $4408 r0 *1 19.795,8.97 nfet_01v8
M$4408 167 821 651 167 nfet_01v8 L=150000U W=210000U AS=21875000000P
+ AD=40400000000P PS=460000U PD=560000U
* device instance $4409 r0 *1 19.205,9.36 nfet_01v8
M$4409 2247 3189 167 167 nfet_01v8 L=150000U W=210000U AS=40400000000P
+ AD=21875000000P PS=560000U PD=460000U
* device instance $4410 r0 *1 19.795,9.36 nfet_01v8
M$4410 821 651 167 167 nfet_01v8 L=150000U W=210000U AS=40400000000P
+ AD=21875000000P PS=560000U PD=460000U
* device instance $4411 r0 *1 19.24,9.76 nfet_01v8
M$4411 25 136 2247 167 nfet_01v8 L=150000U W=140000U AS=21875000000P
+ AD=16800000000P PS=460000U PD=380000U
* device instance $4412 r0 *1 19.76,9.76 nfet_01v8
M$4412 28 136 821 167 nfet_01v8 L=150000U W=140000U AS=21875000000P
+ AD=16800000000P PS=460000U PD=380000U
* device instance $4413 r0 *1 19.24,10.15 nfet_01v8
M$4413 2343 137 25 167 nfet_01v8 L=150000U W=140000U AS=16800000000P
+ AD=21875000000P PS=380000U PD=460000U
* device instance $4414 r0 *1 19.76,10.15 nfet_01v8
M$4414 1303 137 28 167 nfet_01v8 L=150000U W=140000U AS=16800000000P
+ AD=21875000000P PS=380000U PD=460000U
* device instance $4415 r0 *1 19.205,10.55 nfet_01v8
M$4415 167 2713 2343 167 nfet_01v8 L=150000U W=210000U AS=21875000000P
+ AD=40400000000P PS=460000U PD=560000U
* device instance $4416 r0 *1 19.795,10.55 nfet_01v8
M$4416 167 1881 1303 167 nfet_01v8 L=150000U W=210000U AS=21875000000P
+ AD=40400000000P PS=460000U PD=560000U
* device instance $4417 r0 *1 19.205,10.94 nfet_01v8
M$4417 2713 2343 167 167 nfet_01v8 L=150000U W=210000U AS=40400000000P
+ AD=21875000000P PS=560000U PD=460000U
* device instance $4418 r0 *1 19.795,10.94 nfet_01v8
M$4418 1881 1303 167 167 nfet_01v8 L=150000U W=210000U AS=40400000000P
+ AD=21875000000P PS=560000U PD=460000U
* device instance $4419 r0 *1 19.24,11.34 nfet_01v8
M$4419 26 137 2713 167 nfet_01v8 L=150000U W=140000U AS=21875000000P
+ AD=16800000000P PS=460000U PD=380000U
* device instance $4420 r0 *1 19.76,11.34 nfet_01v8
M$4420 27 137 1881 167 nfet_01v8 L=150000U W=140000U AS=21875000000P
+ AD=16800000000P PS=460000U PD=380000U
* device instance $4421 r0 *1 30.14,5.41 nfet_01v8
M$4421 2477 134 42 167 nfet_01v8 L=150000U W=140000U AS=16800000000P
+ AD=21875000000P PS=380000U PD=460000U
* device instance $4422 r0 *1 30.66,5.41 nfet_01v8
M$4422 1040 134 43 167 nfet_01v8 L=150000U W=140000U AS=16800000000P
+ AD=21875000000P PS=380000U PD=460000U
* device instance $4423 r0 *1 30.105,5.81 nfet_01v8
M$4423 167 2977 2477 167 nfet_01v8 L=150000U W=210000U AS=21875000000P
+ AD=40400000000P PS=460000U PD=560000U
* device instance $4424 r0 *1 30.695,5.81 nfet_01v8
M$4424 167 1581 1040 167 nfet_01v8 L=150000U W=210000U AS=21875000000P
+ AD=40400000000P PS=460000U PD=560000U
* device instance $4425 r0 *1 30.105,6.2 nfet_01v8
M$4425 2977 2477 167 167 nfet_01v8 L=150000U W=210000U AS=40400000000P
+ AD=21875000000P PS=560000U PD=460000U
* device instance $4426 r0 *1 30.695,6.2 nfet_01v8
M$4426 1581 1040 167 167 nfet_01v8 L=150000U W=210000U AS=40400000000P
+ AD=21875000000P PS=560000U PD=460000U
* device instance $4427 r0 *1 30.14,6.6 nfet_01v8
M$4427 41 134 2977 167 nfet_01v8 L=150000U W=140000U AS=21875000000P
+ AD=16800000000P PS=460000U PD=380000U
* device instance $4428 r0 *1 30.66,6.6 nfet_01v8
M$4428 44 134 1581 167 nfet_01v8 L=150000U W=140000U AS=21875000000P
+ AD=16800000000P PS=460000U PD=380000U
* device instance $4429 r0 *1 30.14,6.99 nfet_01v8
M$4429 3257 135 41 167 nfet_01v8 L=150000U W=140000U AS=16800000000P
+ AD=21875000000P PS=380000U PD=460000U
* device instance $4430 r0 *1 30.66,6.99 nfet_01v8
M$4430 4307 135 44 167 nfet_01v8 L=150000U W=140000U AS=16800000000P
+ AD=21875000000P PS=380000U PD=460000U
* device instance $4431 r0 *1 30.105,7.39 nfet_01v8
M$4431 167 2932 3257 167 nfet_01v8 L=150000U W=210000U AS=21875000000P
+ AD=40400000000P PS=460000U PD=560000U
* device instance $4432 r0 *1 30.695,7.39 nfet_01v8
M$4432 167 1570 4307 167 nfet_01v8 L=150000U W=210000U AS=21875000000P
+ AD=40400000000P PS=460000U PD=560000U
* device instance $4433 r0 *1 30.105,7.78 nfet_01v8
M$4433 2932 3257 167 167 nfet_01v8 L=150000U W=210000U AS=40400000000P
+ AD=21875000000P PS=560000U PD=460000U
* device instance $4434 r0 *1 30.695,7.78 nfet_01v8
M$4434 1570 4307 167 167 nfet_01v8 L=150000U W=210000U AS=40400000000P
+ AD=21875000000P PS=560000U PD=460000U
* device instance $4435 r0 *1 30.14,8.18 nfet_01v8
M$4435 42 135 2932 167 nfet_01v8 L=150000U W=140000U AS=21875000000P
+ AD=16800000000P PS=460000U PD=380000U
* device instance $4436 r0 *1 30.66,8.18 nfet_01v8
M$4436 43 135 1570 167 nfet_01v8 L=150000U W=140000U AS=21875000000P
+ AD=16800000000P PS=460000U PD=380000U
* device instance $4437 r0 *1 30.14,8.57 nfet_01v8
M$4437 3258 136 42 167 nfet_01v8 L=150000U W=140000U AS=16800000000P
+ AD=21875000000P PS=380000U PD=460000U
* device instance $4438 r0 *1 30.66,8.57 nfet_01v8
M$4438 617 136 43 167 nfet_01v8 L=150000U W=140000U AS=16800000000P
+ AD=21875000000P PS=380000U PD=460000U
* device instance $4439 r0 *1 30.105,8.97 nfet_01v8
M$4439 167 2980 3258 167 nfet_01v8 L=150000U W=210000U AS=21875000000P
+ AD=40400000000P PS=460000U PD=560000U
* device instance $4440 r0 *1 30.695,8.97 nfet_01v8
M$4440 167 753 617 167 nfet_01v8 L=150000U W=210000U AS=21875000000P
+ AD=40400000000P PS=460000U PD=560000U
* device instance $4441 r0 *1 30.105,9.36 nfet_01v8
M$4441 2980 3258 167 167 nfet_01v8 L=150000U W=210000U AS=40400000000P
+ AD=21875000000P PS=560000U PD=460000U
* device instance $4442 r0 *1 30.695,9.36 nfet_01v8
M$4442 753 617 167 167 nfet_01v8 L=150000U W=210000U AS=40400000000P
+ AD=21875000000P PS=560000U PD=460000U
* device instance $4443 r0 *1 30.14,9.76 nfet_01v8
M$4443 41 136 2980 167 nfet_01v8 L=150000U W=140000U AS=21875000000P
+ AD=16800000000P PS=460000U PD=380000U
* device instance $4444 r0 *1 30.66,9.76 nfet_01v8
M$4444 44 136 753 167 nfet_01v8 L=150000U W=140000U AS=21875000000P
+ AD=16800000000P PS=460000U PD=380000U
* device instance $4445 r0 *1 30.14,10.15 nfet_01v8
M$4445 3196 137 41 167 nfet_01v8 L=150000U W=140000U AS=16800000000P
+ AD=21875000000P PS=380000U PD=460000U
* device instance $4446 r0 *1 30.66,10.15 nfet_01v8
M$4446 1012 137 44 167 nfet_01v8 L=150000U W=140000U AS=16800000000P
+ AD=21875000000P PS=380000U PD=460000U
* device instance $4447 r0 *1 30.105,10.55 nfet_01v8
M$4447 167 3030 3196 167 nfet_01v8 L=150000U W=210000U AS=21875000000P
+ AD=40400000000P PS=460000U PD=560000U
* device instance $4448 r0 *1 30.695,10.55 nfet_01v8
M$4448 167 1547 1012 167 nfet_01v8 L=150000U W=210000U AS=21875000000P
+ AD=40400000000P PS=460000U PD=560000U
* device instance $4449 r0 *1 30.105,10.94 nfet_01v8
M$4449 3030 3196 167 167 nfet_01v8 L=150000U W=210000U AS=40400000000P
+ AD=21875000000P PS=560000U PD=460000U
* device instance $4450 r0 *1 30.695,10.94 nfet_01v8
M$4450 1547 1012 167 167 nfet_01v8 L=150000U W=210000U AS=40400000000P
+ AD=21875000000P PS=560000U PD=460000U
* device instance $4451 r0 *1 30.14,11.34 nfet_01v8
M$4451 42 137 3030 167 nfet_01v8 L=150000U W=140000U AS=21875000000P
+ AD=16800000000P PS=460000U PD=380000U
* device instance $4452 r0 *1 30.66,11.34 nfet_01v8
M$4452 43 137 1547 167 nfet_01v8 L=150000U W=140000U AS=21875000000P
+ AD=16800000000P PS=460000U PD=380000U
* device instance $4453 r0 *1 41.04,5.41 nfet_01v8
M$4453 3233 134 58 167 nfet_01v8 L=150000U W=140000U AS=16800000000P
+ AD=21875000000P PS=380000U PD=460000U
* device instance $4454 r0 *1 41.56,5.41 nfet_01v8
M$4454 1002 134 59 167 nfet_01v8 L=150000U W=140000U AS=16800000000P
+ AD=21875000000P PS=380000U PD=460000U
* device instance $4455 r0 *1 41.005,5.81 nfet_01v8
M$4455 167 3052 3233 167 nfet_01v8 L=150000U W=210000U AS=21875000000P
+ AD=40400000000P PS=460000U PD=560000U
* device instance $4456 r0 *1 41.595,5.81 nfet_01v8
M$4456 167 1537 1002 167 nfet_01v8 L=150000U W=210000U AS=21875000000P
+ AD=40400000000P PS=460000U PD=560000U
* device instance $4457 r0 *1 41.005,6.2 nfet_01v8
M$4457 3052 3233 167 167 nfet_01v8 L=150000U W=210000U AS=40400000000P
+ AD=21875000000P PS=560000U PD=460000U
* device instance $4458 r0 *1 41.595,6.2 nfet_01v8
M$4458 1537 1002 167 167 nfet_01v8 L=150000U W=210000U AS=40400000000P
+ AD=21875000000P PS=560000U PD=460000U
* device instance $4459 r0 *1 41.04,6.6 nfet_01v8
M$4459 57 134 3052 167 nfet_01v8 L=150000U W=140000U AS=21875000000P
+ AD=16800000000P PS=460000U PD=380000U
* device instance $4460 r0 *1 41.56,6.6 nfet_01v8
M$4460 60 134 1537 167 nfet_01v8 L=150000U W=140000U AS=21875000000P
+ AD=16800000000P PS=460000U PD=380000U
* device instance $4461 r0 *1 41.04,6.99 nfet_01v8
M$4461 3234 135 57 167 nfet_01v8 L=150000U W=140000U AS=16800000000P
+ AD=21875000000P PS=380000U PD=460000U
* device instance $4462 r0 *1 41.56,6.99 nfet_01v8
M$4462 4302 135 60 167 nfet_01v8 L=150000U W=140000U AS=16800000000P
+ AD=21875000000P PS=380000U PD=460000U
* device instance $4463 r0 *1 41.005,7.39 nfet_01v8
M$4463 167 2145 3234 167 nfet_01v8 L=150000U W=210000U AS=21875000000P
+ AD=40400000000P PS=460000U PD=560000U
* device instance $4464 r0 *1 41.595,7.39 nfet_01v8
M$4464 167 775 4302 167 nfet_01v8 L=150000U W=210000U AS=21875000000P
+ AD=40400000000P PS=460000U PD=560000U
* device instance $4465 r0 *1 41.005,7.78 nfet_01v8
M$4465 2145 3234 167 167 nfet_01v8 L=150000U W=210000U AS=40400000000P
+ AD=21875000000P PS=560000U PD=460000U
* device instance $4466 r0 *1 41.595,7.78 nfet_01v8
M$4466 775 4302 167 167 nfet_01v8 L=150000U W=210000U AS=40400000000P
+ AD=21875000000P PS=560000U PD=460000U
* device instance $4467 r0 *1 41.04,8.18 nfet_01v8
M$4467 58 135 2145 167 nfet_01v8 L=150000U W=140000U AS=21875000000P
+ AD=16800000000P PS=460000U PD=380000U
* device instance $4468 r0 *1 41.56,8.18 nfet_01v8
M$4468 59 135 775 167 nfet_01v8 L=150000U W=140000U AS=21875000000P
+ AD=16800000000P PS=460000U PD=380000U
* device instance $4469 r0 *1 41.04,8.57 nfet_01v8
M$4469 2518 136 58 167 nfet_01v8 L=150000U W=140000U AS=16800000000P
+ AD=21875000000P PS=380000U PD=460000U
* device instance $4470 r0 *1 41.56,8.57 nfet_01v8
M$4470 629 136 59 167 nfet_01v8 L=150000U W=140000U AS=16800000000P
+ AD=21875000000P PS=380000U PD=460000U
* device instance $4471 r0 *1 41.005,8.97 nfet_01v8
M$4471 167 3071 2518 167 nfet_01v8 L=150000U W=210000U AS=21875000000P
+ AD=40400000000P PS=460000U PD=560000U
* device instance $4472 r0 *1 41.595,8.97 nfet_01v8
M$4472 167 777 629 167 nfet_01v8 L=150000U W=210000U AS=21875000000P
+ AD=40400000000P PS=460000U PD=560000U
* device instance $4473 r0 *1 41.005,9.36 nfet_01v8
M$4473 3071 2518 167 167 nfet_01v8 L=150000U W=210000U AS=40400000000P
+ AD=21875000000P PS=560000U PD=460000U
* device instance $4474 r0 *1 41.595,9.36 nfet_01v8
M$4474 777 629 167 167 nfet_01v8 L=150000U W=210000U AS=40400000000P
+ AD=21875000000P PS=560000U PD=460000U
* device instance $4475 r0 *1 41.04,9.76 nfet_01v8
M$4475 57 136 3071 167 nfet_01v8 L=150000U W=140000U AS=21875000000P
+ AD=16800000000P PS=460000U PD=380000U
* device instance $4476 r0 *1 41.56,9.76 nfet_01v8
M$4476 60 136 777 167 nfet_01v8 L=150000U W=140000U AS=21875000000P
+ AD=16800000000P PS=460000U PD=380000U
* device instance $4477 r0 *1 41.04,10.15 nfet_01v8
M$4477 3195 137 57 167 nfet_01v8 L=150000U W=140000U AS=16800000000P
+ AD=21875000000P PS=380000U PD=460000U
* device instance $4478 r0 *1 41.56,10.15 nfet_01v8
M$4478 1010 137 60 167 nfet_01v8 L=150000U W=140000U AS=16800000000P
+ AD=21875000000P PS=380000U PD=460000U
* device instance $4479 r0 *1 41.005,10.55 nfet_01v8
M$4479 167 3026 3195 167 nfet_01v8 L=150000U W=210000U AS=21875000000P
+ AD=40400000000P PS=460000U PD=560000U
* device instance $4480 r0 *1 41.595,10.55 nfet_01v8
M$4480 167 1545 1010 167 nfet_01v8 L=150000U W=210000U AS=21875000000P
+ AD=40400000000P PS=460000U PD=560000U
* device instance $4481 r0 *1 41.005,10.94 nfet_01v8
M$4481 3026 3195 167 167 nfet_01v8 L=150000U W=210000U AS=40400000000P
+ AD=21875000000P PS=560000U PD=460000U
* device instance $4482 r0 *1 41.595,10.94 nfet_01v8
M$4482 1545 1010 167 167 nfet_01v8 L=150000U W=210000U AS=40400000000P
+ AD=21875000000P PS=560000U PD=460000U
* device instance $4483 r0 *1 41.04,11.34 nfet_01v8
M$4483 58 137 3026 167 nfet_01v8 L=150000U W=140000U AS=21875000000P
+ AD=16800000000P PS=460000U PD=380000U
* device instance $4484 r0 *1 41.56,11.34 nfet_01v8
M$4484 59 137 1545 167 nfet_01v8 L=150000U W=140000U AS=21875000000P
+ AD=16800000000P PS=460000U PD=380000U
* device instance $4485 r0 *1 51.94,5.41 nfet_01v8
M$4485 3330 134 74 167 nfet_01v8 L=150000U W=140000U AS=16800000000P
+ AD=21875000000P PS=380000U PD=460000U
* device instance $4486 r0 *1 52.46,5.41 nfet_01v8
M$4486 1163 134 75 167 nfet_01v8 L=150000U W=140000U AS=16800000000P
+ AD=21875000000P PS=380000U PD=460000U
* device instance $4487 r0 *1 51.905,5.81 nfet_01v8
M$4487 167 2761 3330 167 nfet_01v8 L=150000U W=210000U AS=21875000000P
+ AD=40400000000P PS=460000U PD=560000U
* device instance $4488 r0 *1 52.495,5.81 nfet_01v8
M$4488 167 1723 1163 167 nfet_01v8 L=150000U W=210000U AS=21875000000P
+ AD=40400000000P PS=460000U PD=560000U
* device instance $4489 r0 *1 51.905,6.2 nfet_01v8
M$4489 2761 3330 167 167 nfet_01v8 L=150000U W=210000U AS=40400000000P
+ AD=21875000000P PS=560000U PD=460000U
* device instance $4490 r0 *1 52.495,6.2 nfet_01v8
M$4490 1723 1163 167 167 nfet_01v8 L=150000U W=210000U AS=40400000000P
+ AD=21875000000P PS=560000U PD=460000U
* device instance $4491 r0 *1 51.94,6.6 nfet_01v8
M$4491 73 134 2761 167 nfet_01v8 L=150000U W=140000U AS=21875000000P
+ AD=16800000000P PS=460000U PD=380000U
* device instance $4492 r0 *1 52.46,6.6 nfet_01v8
M$4492 76 134 1723 167 nfet_01v8 L=150000U W=140000U AS=21875000000P
+ AD=16800000000P PS=460000U PD=380000U
* device instance $4493 r0 *1 51.94,6.99 nfet_01v8
M$4493 3331 135 73 167 nfet_01v8 L=150000U W=140000U AS=16800000000P
+ AD=21875000000P PS=380000U PD=460000U
* device instance $4494 r0 *1 52.46,6.99 nfet_01v8
M$4494 4325 135 76 167 nfet_01v8 L=150000U W=140000U AS=16800000000P
+ AD=21875000000P PS=380000U PD=460000U
* device instance $4495 r0 *1 51.905,7.39 nfet_01v8
M$4495 167 2187 3331 167 nfet_01v8 L=150000U W=210000U AS=21875000000P
+ AD=40400000000P PS=460000U PD=560000U
* device instance $4496 r0 *1 52.495,7.39 nfet_01v8
M$4496 167 733 4325 167 nfet_01v8 L=150000U W=210000U AS=21875000000P
+ AD=40400000000P PS=460000U PD=560000U
* device instance $4497 r0 *1 51.905,7.78 nfet_01v8
M$4497 2187 3331 167 167 nfet_01v8 L=150000U W=210000U AS=40400000000P
+ AD=21875000000P PS=560000U PD=460000U
* device instance $4498 r0 *1 52.495,7.78 nfet_01v8
M$4498 733 4325 167 167 nfet_01v8 L=150000U W=210000U AS=40400000000P
+ AD=21875000000P PS=560000U PD=460000U
* device instance $4499 r0 *1 51.94,8.18 nfet_01v8
M$4499 74 135 2187 167 nfet_01v8 L=150000U W=140000U AS=21875000000P
+ AD=16800000000P PS=460000U PD=380000U
* device instance $4500 r0 *1 52.46,8.18 nfet_01v8
M$4500 75 135 733 167 nfet_01v8 L=150000U W=140000U AS=21875000000P
+ AD=16800000000P PS=460000U PD=380000U
* device instance $4501 r0 *1 51.94,8.57 nfet_01v8
M$4501 3332 136 74 167 nfet_01v8 L=150000U W=140000U AS=16800000000P
+ AD=21875000000P PS=380000U PD=460000U
* device instance $4502 r0 *1 52.46,8.57 nfet_01v8
M$4502 1084 136 75 167 nfet_01v8 L=150000U W=140000U AS=16800000000P
+ AD=21875000000P PS=380000U PD=460000U
* device instance $4503 r0 *1 51.905,8.97 nfet_01v8
M$4503 167 2199 3332 167 nfet_01v8 L=150000U W=210000U AS=21875000000P
+ AD=40400000000P PS=460000U PD=560000U
* device instance $4504 r0 *1 52.495,8.97 nfet_01v8
M$4504 167 1630 1084 167 nfet_01v8 L=150000U W=210000U AS=21875000000P
+ AD=40400000000P PS=460000U PD=560000U
* device instance $4505 r0 *1 51.905,9.36 nfet_01v8
M$4505 2199 3332 167 167 nfet_01v8 L=150000U W=210000U AS=40400000000P
+ AD=21875000000P PS=560000U PD=460000U
* device instance $4506 r0 *1 52.495,9.36 nfet_01v8
M$4506 1630 1084 167 167 nfet_01v8 L=150000U W=210000U AS=40400000000P
+ AD=21875000000P PS=560000U PD=460000U
* device instance $4507 r0 *1 51.94,9.76 nfet_01v8
M$4507 73 136 2199 167 nfet_01v8 L=150000U W=140000U AS=21875000000P
+ AD=16800000000P PS=460000U PD=380000U
* device instance $4508 r0 *1 52.46,9.76 nfet_01v8
M$4508 76 136 1630 167 nfet_01v8 L=150000U W=140000U AS=21875000000P
+ AD=16800000000P PS=460000U PD=380000U
* device instance $4509 r0 *1 51.94,10.15 nfet_01v8
M$4509 2337 137 73 167 nfet_01v8 L=150000U W=140000U AS=16800000000P
+ AD=21875000000P PS=380000U PD=460000U
* device instance $4510 r0 *1 52.46,10.15 nfet_01v8
M$4510 1170 137 76 167 nfet_01v8 L=150000U W=140000U AS=16800000000P
+ AD=21875000000P PS=380000U PD=460000U
* device instance $4511 r0 *1 51.905,10.55 nfet_01v8
M$4511 167 2694 2337 167 nfet_01v8 L=150000U W=210000U AS=21875000000P
+ AD=40400000000P PS=460000U PD=560000U
* device instance $4512 r0 *1 52.495,10.55 nfet_01v8
M$4512 167 1732 1170 167 nfet_01v8 L=150000U W=210000U AS=21875000000P
+ AD=40400000000P PS=460000U PD=560000U
* device instance $4513 r0 *1 51.905,10.94 nfet_01v8
M$4513 2694 2337 167 167 nfet_01v8 L=150000U W=210000U AS=40400000000P
+ AD=21875000000P PS=560000U PD=460000U
* device instance $4514 r0 *1 52.495,10.94 nfet_01v8
M$4514 1732 1170 167 167 nfet_01v8 L=150000U W=210000U AS=40400000000P
+ AD=21875000000P PS=560000U PD=460000U
* device instance $4515 r0 *1 51.94,11.34 nfet_01v8
M$4515 74 137 2694 167 nfet_01v8 L=150000U W=140000U AS=21875000000P
+ AD=16800000000P PS=460000U PD=380000U
* device instance $4516 r0 *1 52.46,11.34 nfet_01v8
M$4516 75 137 1732 167 nfet_01v8 L=150000U W=140000U AS=21875000000P
+ AD=16800000000P PS=460000U PD=380000U
* device instance $4517 r0 *1 62.84,5.41 nfet_01v8
M$4517 3349 134 90 167 nfet_01v8 L=150000U W=140000U AS=16800000000P
+ AD=21875000000P PS=380000U PD=460000U
* device instance $4518 r0 *1 63.36,5.41 nfet_01v8
M$4518 1089 134 91 167 nfet_01v8 L=150000U W=140000U AS=16800000000P
+ AD=21875000000P PS=380000U PD=460000U
* device instance $4519 r0 *1 62.805,5.81 nfet_01v8
M$4519 167 3069 3349 167 nfet_01v8 L=150000U W=210000U AS=21875000000P
+ AD=40400000000P PS=460000U PD=560000U
* device instance $4520 r0 *1 63.395,5.81 nfet_01v8
M$4520 167 1635 1089 167 nfet_01v8 L=150000U W=210000U AS=21875000000P
+ AD=40400000000P PS=460000U PD=560000U
* device instance $4521 r0 *1 62.805,6.2 nfet_01v8
M$4521 3069 3349 167 167 nfet_01v8 L=150000U W=210000U AS=40400000000P
+ AD=21875000000P PS=560000U PD=460000U
* device instance $4522 r0 *1 63.395,6.2 nfet_01v8
M$4522 1635 1089 167 167 nfet_01v8 L=150000U W=210000U AS=40400000000P
+ AD=21875000000P PS=560000U PD=460000U
* device instance $4523 r0 *1 62.84,6.6 nfet_01v8
M$4523 89 134 3069 167 nfet_01v8 L=150000U W=140000U AS=21875000000P
+ AD=16800000000P PS=460000U PD=380000U
* device instance $4524 r0 *1 63.36,6.6 nfet_01v8
M$4524 92 134 1635 167 nfet_01v8 L=150000U W=140000U AS=21875000000P
+ AD=16800000000P PS=460000U PD=380000U
* device instance $4525 r0 *1 62.84,6.99 nfet_01v8
M$4525 3350 135 89 167 nfet_01v8 L=150000U W=140000U AS=16800000000P
+ AD=21875000000P PS=380000U PD=460000U
* device instance $4526 r0 *1 63.36,6.99 nfet_01v8
M$4526 4327 135 92 167 nfet_01v8 L=150000U W=140000U AS=16800000000P
+ AD=21875000000P PS=380000U PD=460000U
* device instance $4527 r0 *1 62.805,7.39 nfet_01v8
M$4527 167 2266 3350 167 nfet_01v8 L=150000U W=210000U AS=21875000000P
+ AD=40400000000P PS=460000U PD=560000U
* device instance $4528 r0 *1 63.395,7.39 nfet_01v8
M$4528 167 709 4327 167 nfet_01v8 L=150000U W=210000U AS=21875000000P
+ AD=40400000000P PS=460000U PD=560000U
* device instance $4529 r0 *1 62.805,7.78 nfet_01v8
M$4529 2266 3350 167 167 nfet_01v8 L=150000U W=210000U AS=40400000000P
+ AD=21875000000P PS=560000U PD=460000U
* device instance $4530 r0 *1 63.395,7.78 nfet_01v8
M$4530 709 4327 167 167 nfet_01v8 L=150000U W=210000U AS=40400000000P
+ AD=21875000000P PS=560000U PD=460000U
* device instance $4531 r0 *1 62.84,8.18 nfet_01v8
M$4531 90 135 2266 167 nfet_01v8 L=150000U W=140000U AS=21875000000P
+ AD=16800000000P PS=460000U PD=380000U
* device instance $4532 r0 *1 63.36,8.18 nfet_01v8
M$4532 91 135 709 167 nfet_01v8 L=150000U W=140000U AS=21875000000P
+ AD=16800000000P PS=460000U PD=380000U
* device instance $4533 r0 *1 62.84,8.57 nfet_01v8
M$4533 3355 136 90 167 nfet_01v8 L=150000U W=140000U AS=16800000000P
+ AD=21875000000P PS=380000U PD=460000U
* device instance $4534 r0 *1 63.36,8.57 nfet_01v8
M$4534 1085 136 91 167 nfet_01v8 L=150000U W=140000U AS=16800000000P
+ AD=21875000000P PS=380000U PD=460000U
* device instance $4535 r0 *1 62.805,8.97 nfet_01v8
M$4535 167 3089 3355 167 nfet_01v8 L=150000U W=210000U AS=21875000000P
+ AD=40400000000P PS=460000U PD=560000U
* device instance $4536 r0 *1 63.395,8.97 nfet_01v8
M$4536 167 1631 1085 167 nfet_01v8 L=150000U W=210000U AS=21875000000P
+ AD=40400000000P PS=460000U PD=560000U
* device instance $4537 r0 *1 62.805,9.36 nfet_01v8
M$4537 3089 3355 167 167 nfet_01v8 L=150000U W=210000U AS=40400000000P
+ AD=21875000000P PS=560000U PD=460000U
* device instance $4538 r0 *1 63.395,9.36 nfet_01v8
M$4538 1631 1085 167 167 nfet_01v8 L=150000U W=210000U AS=40400000000P
+ AD=21875000000P PS=560000U PD=460000U
* device instance $4539 r0 *1 62.84,9.76 nfet_01v8
M$4539 89 136 3089 167 nfet_01v8 L=150000U W=140000U AS=21875000000P
+ AD=16800000000P PS=460000U PD=380000U
* device instance $4540 r0 *1 63.36,9.76 nfet_01v8
M$4540 92 136 1631 167 nfet_01v8 L=150000U W=140000U AS=21875000000P
+ AD=16800000000P PS=460000U PD=380000U
* device instance $4541 r0 *1 62.84,10.15 nfet_01v8
M$4541 3459 137 89 167 nfet_01v8 L=150000U W=140000U AS=16800000000P
+ AD=21875000000P PS=380000U PD=460000U
* device instance $4542 r0 *1 63.36,10.15 nfet_01v8
M$4542 1171 137 92 167 nfet_01v8 L=150000U W=140000U AS=16800000000P
+ AD=21875000000P PS=380000U PD=460000U
* device instance $4543 r0 *1 62.805,10.55 nfet_01v8
M$4543 167 2690 3459 167 nfet_01v8 L=150000U W=210000U AS=21875000000P
+ AD=40400000000P PS=460000U PD=560000U
* device instance $4544 r0 *1 63.395,10.55 nfet_01v8
M$4544 167 1733 1171 167 nfet_01v8 L=150000U W=210000U AS=21875000000P
+ AD=40400000000P PS=460000U PD=560000U
* device instance $4545 r0 *1 62.805,10.94 nfet_01v8
M$4545 2690 3459 167 167 nfet_01v8 L=150000U W=210000U AS=40400000000P
+ AD=21875000000P PS=560000U PD=460000U
* device instance $4546 r0 *1 63.395,10.94 nfet_01v8
M$4546 1733 1171 167 167 nfet_01v8 L=150000U W=210000U AS=40400000000P
+ AD=21875000000P PS=560000U PD=460000U
* device instance $4547 r0 *1 62.84,11.34 nfet_01v8
M$4547 90 137 2690 167 nfet_01v8 L=150000U W=140000U AS=21875000000P
+ AD=16800000000P PS=460000U PD=380000U
* device instance $4548 r0 *1 63.36,11.34 nfet_01v8
M$4548 91 137 1733 167 nfet_01v8 L=150000U W=140000U AS=21875000000P
+ AD=16800000000P PS=460000U PD=380000U
* device instance $4549 r0 *1 73.74,5.41 nfet_01v8
M$4549 2508 134 106 167 nfet_01v8 L=150000U W=140000U AS=16800000000P
+ AD=21875000000P PS=380000U PD=460000U
* device instance $4550 r0 *1 74.26,5.41 nfet_01v8
M$4550 1097 134 107 167 nfet_01v8 L=150000U W=140000U AS=16800000000P
+ AD=21875000000P PS=380000U PD=460000U
* device instance $4551 r0 *1 73.705,5.81 nfet_01v8
M$4551 167 3045 2508 167 nfet_01v8 L=150000U W=210000U AS=21875000000P
+ AD=40400000000P PS=460000U PD=560000U
* device instance $4552 r0 *1 74.295,5.81 nfet_01v8
M$4552 167 1645 1097 167 nfet_01v8 L=150000U W=210000U AS=21875000000P
+ AD=40400000000P PS=460000U PD=560000U
* device instance $4553 r0 *1 73.705,6.2 nfet_01v8
M$4553 3045 2508 167 167 nfet_01v8 L=150000U W=210000U AS=40400000000P
+ AD=21875000000P PS=560000U PD=460000U
* device instance $4554 r0 *1 74.295,6.2 nfet_01v8
M$4554 1645 1097 167 167 nfet_01v8 L=150000U W=210000U AS=40400000000P
+ AD=21875000000P PS=560000U PD=460000U
* device instance $4555 r0 *1 73.74,6.6 nfet_01v8
M$4555 105 134 3045 167 nfet_01v8 L=150000U W=140000U AS=21875000000P
+ AD=16800000000P PS=460000U PD=380000U
* device instance $4556 r0 *1 74.26,6.6 nfet_01v8
M$4556 108 134 1645 167 nfet_01v8 L=150000U W=140000U AS=21875000000P
+ AD=16800000000P PS=460000U PD=380000U
* device instance $4557 r0 *1 73.74,6.99 nfet_01v8
M$4557 3376 135 105 167 nfet_01v8 L=150000U W=140000U AS=16800000000P
+ AD=21875000000P PS=380000U PD=460000U
* device instance $4558 r0 *1 74.26,6.99 nfet_01v8
M$4558 4334 135 108 167 nfet_01v8 L=150000U W=140000U AS=16800000000P
+ AD=21875000000P PS=380000U PD=460000U
* device instance $4559 r0 *1 73.705,7.39 nfet_01v8
M$4559 167 2184 3376 167 nfet_01v8 L=150000U W=210000U AS=21875000000P
+ AD=40400000000P PS=460000U PD=560000U
* device instance $4560 r0 *1 74.295,7.39 nfet_01v8
M$4560 167 1646 4334 167 nfet_01v8 L=150000U W=210000U AS=21875000000P
+ AD=40400000000P PS=460000U PD=560000U
* device instance $4561 r0 *1 73.705,7.78 nfet_01v8
M$4561 2184 3376 167 167 nfet_01v8 L=150000U W=210000U AS=40400000000P
+ AD=21875000000P PS=560000U PD=460000U
* device instance $4562 r0 *1 74.295,7.78 nfet_01v8
M$4562 1646 4334 167 167 nfet_01v8 L=150000U W=210000U AS=40400000000P
+ AD=21875000000P PS=560000U PD=460000U
* device instance $4563 r0 *1 73.74,8.18 nfet_01v8
M$4563 106 135 2184 167 nfet_01v8 L=150000U W=140000U AS=21875000000P
+ AD=16800000000P PS=460000U PD=380000U
* device instance $4564 r0 *1 74.26,8.18 nfet_01v8
M$4564 107 135 1646 167 nfet_01v8 L=150000U W=140000U AS=21875000000P
+ AD=16800000000P PS=460000U PD=380000U
* device instance $4565 r0 *1 73.74,8.57 nfet_01v8
M$4565 2506 136 106 167 nfet_01v8 L=150000U W=140000U AS=16800000000P
+ AD=21875000000P PS=380000U PD=460000U
* device instance $4566 r0 *1 74.26,8.57 nfet_01v8
M$4566 1098 136 107 167 nfet_01v8 L=150000U W=140000U AS=16800000000P
+ AD=21875000000P PS=380000U PD=460000U
* device instance $4567 r0 *1 73.705,8.97 nfet_01v8
M$4567 167 3040 2506 167 nfet_01v8 L=150000U W=210000U AS=21875000000P
+ AD=40400000000P PS=460000U PD=560000U
* device instance $4568 r0 *1 74.295,8.97 nfet_01v8
M$4568 167 1647 1098 167 nfet_01v8 L=150000U W=210000U AS=21875000000P
+ AD=40400000000P PS=460000U PD=560000U
* device instance $4569 r0 *1 73.705,9.36 nfet_01v8
M$4569 3040 2506 167 167 nfet_01v8 L=150000U W=210000U AS=40400000000P
+ AD=21875000000P PS=560000U PD=460000U
* device instance $4570 r0 *1 74.295,9.36 nfet_01v8
M$4570 1647 1098 167 167 nfet_01v8 L=150000U W=210000U AS=40400000000P
+ AD=21875000000P PS=560000U PD=460000U
* device instance $4571 r0 *1 73.74,9.76 nfet_01v8
M$4571 105 136 3040 167 nfet_01v8 L=150000U W=140000U AS=21875000000P
+ AD=16800000000P PS=460000U PD=380000U
* device instance $4572 r0 *1 74.26,9.76 nfet_01v8
M$4572 108 136 1647 167 nfet_01v8 L=150000U W=140000U AS=21875000000P
+ AD=16800000000P PS=460000U PD=380000U
* device instance $4573 r0 *1 73.74,10.15 nfet_01v8
M$4573 2529 137 105 167 nfet_01v8 L=150000U W=140000U AS=16800000000P
+ AD=21875000000P PS=380000U PD=460000U
* device instance $4574 r0 *1 74.26,10.15 nfet_01v8
M$4574 1064 137 108 167 nfet_01v8 L=150000U W=140000U AS=16800000000P
+ AD=21875000000P PS=380000U PD=460000U
* device instance $4575 r0 *1 73.705,10.55 nfet_01v8
M$4575 167 3092 2529 167 nfet_01v8 L=150000U W=210000U AS=21875000000P
+ AD=40400000000P PS=460000U PD=560000U
* device instance $4576 r0 *1 74.295,10.55 nfet_01v8
M$4576 167 1608 1064 167 nfet_01v8 L=150000U W=210000U AS=21875000000P
+ AD=40400000000P PS=460000U PD=560000U
* device instance $4577 r0 *1 73.705,10.94 nfet_01v8
M$4577 3092 2529 167 167 nfet_01v8 L=150000U W=210000U AS=40400000000P
+ AD=21875000000P PS=560000U PD=460000U
* device instance $4578 r0 *1 74.295,10.94 nfet_01v8
M$4578 1608 1064 167 167 nfet_01v8 L=150000U W=210000U AS=40400000000P
+ AD=21875000000P PS=560000U PD=460000U
* device instance $4579 r0 *1 73.74,11.34 nfet_01v8
M$4579 106 137 3092 167 nfet_01v8 L=150000U W=140000U AS=21875000000P
+ AD=16800000000P PS=460000U PD=380000U
* device instance $4580 r0 *1 74.26,11.34 nfet_01v8
M$4580 107 137 1608 167 nfet_01v8 L=150000U W=140000U AS=21875000000P
+ AD=16800000000P PS=460000U PD=380000U
* device instance $4581 r0 *1 84.64,5.41 nfet_01v8
M$4581 3387 134 122 167 nfet_01v8 L=150000U W=140000U AS=16800000000P
+ AD=21875000000P PS=380000U PD=460000U
* device instance $4582 r0 *1 85.16,5.41 nfet_01v8
M$4582 1106 134 123 167 nfet_01v8 L=150000U W=140000U AS=16800000000P
+ AD=21875000000P PS=380000U PD=460000U
* device instance $4583 r0 *1 84.605,5.81 nfet_01v8
M$4583 167 3009 3387 167 nfet_01v8 L=150000U W=210000U AS=21875000000P
+ AD=40400000000P PS=460000U PD=560000U
* device instance $4584 r0 *1 85.195,5.81 nfet_01v8
M$4584 167 1658 1106 167 nfet_01v8 L=150000U W=210000U AS=21875000000P
+ AD=40400000000P PS=460000U PD=560000U
* device instance $4585 r0 *1 84.605,6.2 nfet_01v8
M$4585 3009 3387 167 167 nfet_01v8 L=150000U W=210000U AS=40400000000P
+ AD=21875000000P PS=560000U PD=460000U
* device instance $4586 r0 *1 85.195,6.2 nfet_01v8
M$4586 1658 1106 167 167 nfet_01v8 L=150000U W=210000U AS=40400000000P
+ AD=21875000000P PS=560000U PD=460000U
* device instance $4587 r0 *1 84.64,6.6 nfet_01v8
M$4587 121 134 3009 167 nfet_01v8 L=150000U W=140000U AS=21875000000P
+ AD=16800000000P PS=460000U PD=380000U
* device instance $4588 r0 *1 85.16,6.6 nfet_01v8
M$4588 124 134 1658 167 nfet_01v8 L=150000U W=140000U AS=21875000000P
+ AD=16800000000P PS=460000U PD=380000U
* device instance $4589 r0 *1 84.64,6.99 nfet_01v8
M$4589 3384 135 121 167 nfet_01v8 L=150000U W=140000U AS=16800000000P
+ AD=21875000000P PS=380000U PD=460000U
* device instance $4590 r0 *1 85.16,6.99 nfet_01v8
M$4590 4341 135 124 167 nfet_01v8 L=150000U W=140000U AS=16800000000P
+ AD=21875000000P PS=380000U PD=460000U
* device instance $4591 r0 *1 84.605,7.39 nfet_01v8
M$4591 167 3011 3384 167 nfet_01v8 L=150000U W=210000U AS=21875000000P
+ AD=40400000000P PS=460000U PD=560000U
* device instance $4592 r0 *1 85.195,7.39 nfet_01v8
M$4592 167 1654 4341 167 nfet_01v8 L=150000U W=210000U AS=21875000000P
+ AD=40400000000P PS=460000U PD=560000U
* device instance $4593 r0 *1 84.605,7.78 nfet_01v8
M$4593 3011 3384 167 167 nfet_01v8 L=150000U W=210000U AS=40400000000P
+ AD=21875000000P PS=560000U PD=460000U
* device instance $4594 r0 *1 85.195,7.78 nfet_01v8
M$4594 1654 4341 167 167 nfet_01v8 L=150000U W=210000U AS=40400000000P
+ AD=21875000000P PS=560000U PD=460000U
* device instance $4595 r0 *1 84.64,8.18 nfet_01v8
M$4595 122 135 3011 167 nfet_01v8 L=150000U W=140000U AS=21875000000P
+ AD=16800000000P PS=460000U PD=380000U
* device instance $4596 r0 *1 85.16,8.18 nfet_01v8
M$4596 123 135 1654 167 nfet_01v8 L=150000U W=140000U AS=21875000000P
+ AD=16800000000P PS=460000U PD=380000U
* device instance $4597 r0 *1 84.64,8.57 nfet_01v8
M$4597 2494 136 122 167 nfet_01v8 L=150000U W=140000U AS=16800000000P
+ AD=21875000000P PS=380000U PD=460000U
* device instance $4598 r0 *1 85.16,8.57 nfet_01v8
M$4598 1104 136 123 167 nfet_01v8 L=150000U W=140000U AS=16800000000P
+ AD=21875000000P PS=380000U PD=460000U
* device instance $4599 r0 *1 84.605,8.97 nfet_01v8
M$4599 167 3010 2494 167 nfet_01v8 L=150000U W=210000U AS=21875000000P
+ AD=40400000000P PS=460000U PD=560000U
* device instance $4600 r0 *1 85.195,8.97 nfet_01v8
M$4600 167 1656 1104 167 nfet_01v8 L=150000U W=210000U AS=21875000000P
+ AD=40400000000P PS=460000U PD=560000U
* device instance $4601 r0 *1 84.605,9.36 nfet_01v8
M$4601 3010 2494 167 167 nfet_01v8 L=150000U W=210000U AS=40400000000P
+ AD=21875000000P PS=560000U PD=460000U
* device instance $4602 r0 *1 85.195,9.36 nfet_01v8
M$4602 1656 1104 167 167 nfet_01v8 L=150000U W=210000U AS=40400000000P
+ AD=21875000000P PS=560000U PD=460000U
* device instance $4603 r0 *1 84.64,9.76 nfet_01v8
M$4603 121 136 3010 167 nfet_01v8 L=150000U W=140000U AS=21875000000P
+ AD=16800000000P PS=460000U PD=380000U
* device instance $4604 r0 *1 85.16,9.76 nfet_01v8
M$4604 124 136 1656 167 nfet_01v8 L=150000U W=140000U AS=21875000000P
+ AD=16800000000P PS=460000U PD=380000U
* device instance $4605 r0 *1 84.64,10.15 nfet_01v8
M$4605 3379 137 121 167 nfet_01v8 L=150000U W=140000U AS=16800000000P
+ AD=21875000000P PS=380000U PD=460000U
* device instance $4606 r0 *1 85.16,10.15 nfet_01v8
M$4606 1059 137 124 167 nfet_01v8 L=150000U W=140000U AS=16800000000P
+ AD=21875000000P PS=380000U PD=460000U
* device instance $4607 r0 *1 84.605,10.55 nfet_01v8
M$4607 167 3061 3379 167 nfet_01v8 L=150000U W=210000U AS=21875000000P
+ AD=40400000000P PS=460000U PD=560000U
* device instance $4608 r0 *1 85.195,10.55 nfet_01v8
M$4608 167 1603 1059 167 nfet_01v8 L=150000U W=210000U AS=21875000000P
+ AD=40400000000P PS=460000U PD=560000U
* device instance $4609 r0 *1 84.605,10.94 nfet_01v8
M$4609 3061 3379 167 167 nfet_01v8 L=150000U W=210000U AS=40400000000P
+ AD=21875000000P PS=560000U PD=460000U
* device instance $4610 r0 *1 85.195,10.94 nfet_01v8
M$4610 1603 1059 167 167 nfet_01v8 L=150000U W=210000U AS=40400000000P
+ AD=21875000000P PS=560000U PD=460000U
* device instance $4611 r0 *1 84.64,11.34 nfet_01v8
M$4611 122 137 3061 167 nfet_01v8 L=150000U W=140000U AS=21875000000P
+ AD=16800000000P PS=460000U PD=380000U
* device instance $4612 r0 *1 85.16,11.34 nfet_01v8
M$4612 123 137 1603 167 nfet_01v8 L=150000U W=140000U AS=21875000000P
+ AD=16800000000P PS=460000U PD=380000U
* device instance $4613 r0 *1 84.64,13.31 nfet_01v8
M$4613 2479 138 122 167 nfet_01v8 L=150000U W=140000U AS=16800000000P
+ AD=21875000000P PS=380000U PD=460000U
* device instance $4614 r0 *1 85.16,13.31 nfet_01v8
M$4614 1111 138 123 167 nfet_01v8 L=150000U W=140000U AS=16800000000P
+ AD=21875000000P PS=380000U PD=460000U
* device instance $4615 r0 *1 84.605,13.71 nfet_01v8
M$4615 167 2982 2479 167 nfet_01v8 L=150000U W=210000U AS=21875000000P
+ AD=40400000000P PS=460000U PD=560000U
* device instance $4616 r0 *1 85.195,13.71 nfet_01v8
M$4616 167 1664 1111 167 nfet_01v8 L=150000U W=210000U AS=21875000000P
+ AD=40400000000P PS=460000U PD=560000U
* device instance $4617 r0 *1 84.605,14.1 nfet_01v8
M$4617 2982 2479 167 167 nfet_01v8 L=150000U W=210000U AS=40400000000P
+ AD=21875000000P PS=560000U PD=460000U
* device instance $4618 r0 *1 85.195,14.1 nfet_01v8
M$4618 1664 1111 167 167 nfet_01v8 L=150000U W=210000U AS=40400000000P
+ AD=21875000000P PS=560000U PD=460000U
* device instance $4619 r0 *1 84.64,14.5 nfet_01v8
M$4619 121 138 2982 167 nfet_01v8 L=150000U W=140000U AS=21875000000P
+ AD=16800000000P PS=460000U PD=380000U
* device instance $4620 r0 *1 85.16,14.5 nfet_01v8
M$4620 124 138 1664 167 nfet_01v8 L=150000U W=140000U AS=21875000000P
+ AD=16800000000P PS=460000U PD=380000U
* device instance $4621 r0 *1 84.64,14.89 nfet_01v8
M$4621 3394 139 121 167 nfet_01v8 L=150000U W=140000U AS=16800000000P
+ AD=21875000000P PS=380000U PD=460000U
* device instance $4622 r0 *1 85.16,14.89 nfet_01v8
M$4622 4322 139 124 167 nfet_01v8 L=150000U W=140000U AS=16800000000P
+ AD=21875000000P PS=380000U PD=460000U
* device instance $4623 r0 *1 84.605,15.29 nfet_01v8
M$4623 167 2235 3394 167 nfet_01v8 L=150000U W=210000U AS=21875000000P
+ AD=40400000000P PS=460000U PD=560000U
* device instance $4624 r0 *1 85.195,15.29 nfet_01v8
M$4624 167 718 4322 167 nfet_01v8 L=150000U W=210000U AS=21875000000P
+ AD=40400000000P PS=460000U PD=560000U
* device instance $4625 r0 *1 84.605,15.68 nfet_01v8
M$4625 2235 3394 167 167 nfet_01v8 L=150000U W=210000U AS=40400000000P
+ AD=21875000000P PS=560000U PD=460000U
* device instance $4626 r0 *1 85.195,15.68 nfet_01v8
M$4626 718 4322 167 167 nfet_01v8 L=150000U W=210000U AS=40400000000P
+ AD=21875000000P PS=560000U PD=460000U
* device instance $4627 r0 *1 84.64,16.08 nfet_01v8
M$4627 122 139 2235 167 nfet_01v8 L=150000U W=140000U AS=21875000000P
+ AD=16800000000P PS=460000U PD=380000U
* device instance $4628 r0 *1 85.16,16.08 nfet_01v8
M$4628 123 139 718 167 nfet_01v8 L=150000U W=140000U AS=21875000000P
+ AD=16800000000P PS=460000U PD=380000U
* device instance $4629 r0 *1 84.64,16.47 nfet_01v8
M$4629 2115 140 122 167 nfet_01v8 L=150000U W=140000U AS=16800000000P
+ AD=21875000000P PS=380000U PD=460000U
* device instance $4630 r0 *1 85.16,16.47 nfet_01v8
M$4630 598 140 123 167 nfet_01v8 L=150000U W=140000U AS=16800000000P
+ AD=21875000000P PS=380000U PD=460000U
* device instance $4631 r0 *1 84.605,16.87 nfet_01v8
M$4631 167 2238 2115 167 nfet_01v8 L=150000U W=210000U AS=21875000000P
+ AD=40400000000P PS=460000U PD=560000U
* device instance $4632 r0 *1 85.195,16.87 nfet_01v8
M$4632 167 716 598 167 nfet_01v8 L=150000U W=210000U AS=21875000000P
+ AD=40400000000P PS=460000U PD=560000U
* device instance $4633 r0 *1 84.605,17.26 nfet_01v8
M$4633 2238 2115 167 167 nfet_01v8 L=150000U W=210000U AS=40400000000P
+ AD=21875000000P PS=560000U PD=460000U
* device instance $4634 r0 *1 85.195,17.26 nfet_01v8
M$4634 716 598 167 167 nfet_01v8 L=150000U W=210000U AS=40400000000P
+ AD=21875000000P PS=560000U PD=460000U
* device instance $4635 r0 *1 84.64,17.66 nfet_01v8
M$4635 121 140 2238 167 nfet_01v8 L=150000U W=140000U AS=21875000000P
+ AD=16800000000P PS=460000U PD=380000U
* device instance $4636 r0 *1 85.16,17.66 nfet_01v8
M$4636 124 140 716 167 nfet_01v8 L=150000U W=140000U AS=21875000000P
+ AD=16800000000P PS=460000U PD=380000U
* device instance $4637 r0 *1 84.64,18.05 nfet_01v8
M$4637 3406 141 121 167 nfet_01v8 L=150000U W=140000U AS=16800000000P
+ AD=21875000000P PS=380000U PD=460000U
* device instance $4638 r0 *1 85.16,18.05 nfet_01v8
M$4638 1078 141 124 167 nfet_01v8 L=150000U W=140000U AS=16800000000P
+ AD=21875000000P PS=380000U PD=460000U
* device instance $4639 r0 *1 84.605,18.45 nfet_01v8
M$4639 167 2975 3406 167 nfet_01v8 L=150000U W=210000U AS=21875000000P
+ AD=40400000000P PS=460000U PD=560000U
* device instance $4640 r0 *1 85.195,18.45 nfet_01v8
M$4640 167 1623 1078 167 nfet_01v8 L=150000U W=210000U AS=21875000000P
+ AD=40400000000P PS=460000U PD=560000U
* device instance $4641 r0 *1 84.605,18.84 nfet_01v8
M$4641 2975 3406 167 167 nfet_01v8 L=150000U W=210000U AS=40400000000P
+ AD=21875000000P PS=560000U PD=460000U
* device instance $4642 r0 *1 85.195,18.84 nfet_01v8
M$4642 1623 1078 167 167 nfet_01v8 L=150000U W=210000U AS=40400000000P
+ AD=21875000000P PS=560000U PD=460000U
* device instance $4643 r0 *1 84.64,19.24 nfet_01v8
M$4643 122 141 2975 167 nfet_01v8 L=150000U W=140000U AS=21875000000P
+ AD=16800000000P PS=460000U PD=380000U
* device instance $4644 r0 *1 85.16,19.24 nfet_01v8
M$4644 123 141 1623 167 nfet_01v8 L=150000U W=140000U AS=21875000000P
+ AD=16800000000P PS=460000U PD=380000U
* device instance $4645 r0 *1 19.24,29.11 nfet_01v8
M$4645 3291 146 26 167 nfet_01v8 L=150000U W=140000U AS=16800000000P
+ AD=21875000000P PS=380000U PD=460000U
* device instance $4646 r0 *1 19.76,29.11 nfet_01v8
M$4646 1364 146 27 167 nfet_01v8 L=150000U W=140000U AS=16800000000P
+ AD=21875000000P PS=380000U PD=460000U
* device instance $4647 r0 *1 19.205,29.51 nfet_01v8
M$4647 167 2850 3291 167 nfet_01v8 L=150000U W=210000U AS=21875000000P
+ AD=40400000000P PS=460000U PD=560000U
* device instance $4648 r0 *1 19.795,29.51 nfet_01v8
M$4648 167 1955 1364 167 nfet_01v8 L=150000U W=210000U AS=21875000000P
+ AD=40400000000P PS=460000U PD=560000U
* device instance $4649 r0 *1 19.205,29.9 nfet_01v8
M$4649 2850 3291 167 167 nfet_01v8 L=150000U W=210000U AS=40400000000P
+ AD=21875000000P PS=560000U PD=460000U
* device instance $4650 r0 *1 19.795,29.9 nfet_01v8
M$4650 1955 1364 167 167 nfet_01v8 L=150000U W=210000U AS=40400000000P
+ AD=21875000000P PS=560000U PD=460000U
* device instance $4651 r0 *1 19.24,30.3 nfet_01v8
M$4651 25 146 2850 167 nfet_01v8 L=150000U W=140000U AS=21875000000P
+ AD=16800000000P PS=460000U PD=380000U
* device instance $4652 r0 *1 19.76,30.3 nfet_01v8
M$4652 28 146 1955 167 nfet_01v8 L=150000U W=140000U AS=21875000000P
+ AD=16800000000P PS=460000U PD=380000U
* device instance $4653 r0 *1 19.24,30.69 nfet_01v8
M$4653 3290 147 25 167 nfet_01v8 L=150000U W=140000U AS=16800000000P
+ AD=21875000000P PS=380000U PD=460000U
* device instance $4654 r0 *1 19.76,30.69 nfet_01v8
M$4654 4517 147 28 167 nfet_01v8 L=150000U W=140000U AS=16800000000P
+ AD=21875000000P PS=380000U PD=460000U
* device instance $4655 r0 *1 19.205,31.09 nfet_01v8
M$4655 167 1973 3290 167 nfet_01v8 L=150000U W=210000U AS=21875000000P
+ AD=40400000000P PS=460000U PD=560000U
* device instance $4656 r0 *1 19.795,31.09 nfet_01v8
M$4656 167 1961 4517 167 nfet_01v8 L=150000U W=210000U AS=21875000000P
+ AD=40400000000P PS=460000U PD=560000U
* device instance $4657 r0 *1 19.205,31.48 nfet_01v8
M$4657 1973 3290 167 167 nfet_01v8 L=150000U W=210000U AS=40400000000P
+ AD=21875000000P PS=560000U PD=460000U
* device instance $4658 r0 *1 19.795,31.48 nfet_01v8
M$4658 1961 4517 167 167 nfet_01v8 L=150000U W=210000U AS=40400000000P
+ AD=21875000000P PS=560000U PD=460000U
* device instance $4659 r0 *1 19.24,31.88 nfet_01v8
M$4659 26 147 1973 167 nfet_01v8 L=150000U W=140000U AS=21875000000P
+ AD=16800000000P PS=460000U PD=380000U
* device instance $4660 r0 *1 19.76,31.88 nfet_01v8
M$4660 27 147 1961 167 nfet_01v8 L=150000U W=140000U AS=21875000000P
+ AD=16800000000P PS=460000U PD=380000U
* device instance $4661 r0 *1 19.24,32.27 nfet_01v8
M$4661 2409 148 26 167 nfet_01v8 L=150000U W=140000U AS=16800000000P
+ AD=21875000000P PS=380000U PD=460000U
* device instance $4662 r0 *1 19.76,32.27 nfet_01v8
M$4662 1211 148 27 167 nfet_01v8 L=150000U W=140000U AS=16800000000P
+ AD=21875000000P PS=380000U PD=460000U
* device instance $4663 r0 *1 19.205,32.67 nfet_01v8
M$4663 167 2827 2409 167 nfet_01v8 L=150000U W=210000U AS=21875000000P
+ AD=40400000000P PS=460000U PD=560000U
* device instance $4664 r0 *1 19.795,32.67 nfet_01v8
M$4664 167 1781 1211 167 nfet_01v8 L=150000U W=210000U AS=21875000000P
+ AD=40400000000P PS=460000U PD=560000U
* device instance $4665 r0 *1 19.205,33.06 nfet_01v8
M$4665 2827 2409 167 167 nfet_01v8 L=150000U W=210000U AS=40400000000P
+ AD=21875000000P PS=560000U PD=460000U
* device instance $4666 r0 *1 19.795,33.06 nfet_01v8
M$4666 1781 1211 167 167 nfet_01v8 L=150000U W=210000U AS=40400000000P
+ AD=21875000000P PS=560000U PD=460000U
* device instance $4667 r0 *1 19.24,33.46 nfet_01v8
M$4667 25 148 2827 167 nfet_01v8 L=150000U W=140000U AS=21875000000P
+ AD=16800000000P PS=460000U PD=380000U
* device instance $4668 r0 *1 19.76,33.46 nfet_01v8
M$4668 28 148 1781 167 nfet_01v8 L=150000U W=140000U AS=21875000000P
+ AD=16800000000P PS=460000U PD=380000U
* device instance $4669 r0 *1 19.24,33.85 nfet_01v8
M$4669 3284 149 25 167 nfet_01v8 L=150000U W=140000U AS=16800000000P
+ AD=21875000000P PS=380000U PD=460000U
* device instance $4670 r0 *1 19.76,33.85 nfet_01v8
M$4670 1212 149 28 167 nfet_01v8 L=150000U W=140000U AS=16800000000P
+ AD=21875000000P PS=380000U PD=460000U
* device instance $4671 r0 *1 19.205,34.25 nfet_01v8
M$4671 167 2828 3284 167 nfet_01v8 L=150000U W=210000U AS=21875000000P
+ AD=40400000000P PS=460000U PD=560000U
* device instance $4672 r0 *1 19.795,34.25 nfet_01v8
M$4672 167 1782 1212 167 nfet_01v8 L=150000U W=210000U AS=21875000000P
+ AD=40400000000P PS=460000U PD=560000U
* device instance $4673 r0 *1 19.205,34.64 nfet_01v8
M$4673 2828 3284 167 167 nfet_01v8 L=150000U W=210000U AS=40400000000P
+ AD=21875000000P PS=560000U PD=460000U
* device instance $4674 r0 *1 19.795,34.64 nfet_01v8
M$4674 1782 1212 167 167 nfet_01v8 L=150000U W=210000U AS=40400000000P
+ AD=21875000000P PS=560000U PD=460000U
* device instance $4675 r0 *1 19.24,35.04 nfet_01v8
M$4675 26 149 2828 167 nfet_01v8 L=150000U W=140000U AS=21875000000P
+ AD=16800000000P PS=460000U PD=380000U
* device instance $4676 r0 *1 19.76,35.04 nfet_01v8
M$4676 27 149 1782 167 nfet_01v8 L=150000U W=140000U AS=21875000000P
+ AD=16800000000P PS=460000U PD=380000U
* device instance $4677 r0 *1 30.14,29.11 nfet_01v8
M$4677 3652 146 42 167 nfet_01v8 L=150000U W=140000U AS=16800000000P
+ AD=21875000000P PS=380000U PD=460000U
* device instance $4678 r0 *1 30.66,29.11 nfet_01v8
M$4678 1270 146 43 167 nfet_01v8 L=150000U W=140000U AS=16800000000P
+ AD=21875000000P PS=380000U PD=460000U
* device instance $4679 r0 *1 30.105,29.51 nfet_01v8
M$4679 167 2881 3652 167 nfet_01v8 L=150000U W=210000U AS=21875000000P
+ AD=40400000000P PS=460000U PD=560000U
* device instance $4680 r0 *1 30.695,29.51 nfet_01v8
M$4680 167 1847 1270 167 nfet_01v8 L=150000U W=210000U AS=21875000000P
+ AD=40400000000P PS=460000U PD=560000U
* device instance $4681 r0 *1 30.105,29.9 nfet_01v8
M$4681 2881 3652 167 167 nfet_01v8 L=150000U W=210000U AS=40400000000P
+ AD=21875000000P PS=560000U PD=460000U
* device instance $4682 r0 *1 30.695,29.9 nfet_01v8
M$4682 1847 1270 167 167 nfet_01v8 L=150000U W=210000U AS=40400000000P
+ AD=21875000000P PS=560000U PD=460000U
* device instance $4683 r0 *1 30.14,30.3 nfet_01v8
M$4683 41 146 2881 167 nfet_01v8 L=150000U W=140000U AS=21875000000P
+ AD=16800000000P PS=460000U PD=380000U
* device instance $4684 r0 *1 30.66,30.3 nfet_01v8
M$4684 44 146 1847 167 nfet_01v8 L=150000U W=140000U AS=21875000000P
+ AD=16800000000P PS=460000U PD=380000U
* device instance $4685 r0 *1 30.14,30.69 nfet_01v8
M$4685 3650 147 41 167 nfet_01v8 L=150000U W=140000U AS=16800000000P
+ AD=21875000000P PS=380000U PD=460000U
* device instance $4686 r0 *1 30.66,30.69 nfet_01v8
M$4686 4414 147 44 167 nfet_01v8 L=150000U W=140000U AS=16800000000P
+ AD=21875000000P PS=380000U PD=460000U
* device instance $4687 r0 *1 30.105,31.09 nfet_01v8
M$4687 167 1998 3650 167 nfet_01v8 L=150000U W=210000U AS=21875000000P
+ AD=40400000000P PS=460000U PD=560000U
* device instance $4688 r0 *1 30.695,31.09 nfet_01v8
M$4688 167 734 4414 167 nfet_01v8 L=150000U W=210000U AS=21875000000P
+ AD=40400000000P PS=460000U PD=560000U
* device instance $4689 r0 *1 30.105,31.48 nfet_01v8
M$4689 1998 3650 167 167 nfet_01v8 L=150000U W=210000U AS=40400000000P
+ AD=21875000000P PS=560000U PD=460000U
* device instance $4690 r0 *1 30.695,31.48 nfet_01v8
M$4690 734 4414 167 167 nfet_01v8 L=150000U W=210000U AS=40400000000P
+ AD=21875000000P PS=560000U PD=460000U
* device instance $4691 r0 *1 30.14,31.88 nfet_01v8
M$4691 42 147 1998 167 nfet_01v8 L=150000U W=140000U AS=21875000000P
+ AD=16800000000P PS=460000U PD=380000U
* device instance $4692 r0 *1 30.66,31.88 nfet_01v8
M$4692 43 147 734 167 nfet_01v8 L=150000U W=140000U AS=21875000000P
+ AD=16800000000P PS=460000U PD=380000U
* device instance $4693 r0 *1 30.14,32.27 nfet_01v8
M$4693 2093 148 42 167 nfet_01v8 L=150000U W=140000U AS=16800000000P
+ AD=21875000000P PS=380000U PD=460000U
* device instance $4694 r0 *1 30.66,32.27 nfet_01v8
M$4694 607 148 43 167 nfet_01v8 L=150000U W=140000U AS=16800000000P
+ AD=21875000000P PS=380000U PD=460000U
* device instance $4695 r0 *1 30.105,32.67 nfet_01v8
M$4695 167 2186 2093 167 nfet_01v8 L=150000U W=210000U AS=21875000000P
+ AD=40400000000P PS=460000U PD=560000U
* device instance $4696 r0 *1 30.695,32.67 nfet_01v8
M$4696 167 731 607 167 nfet_01v8 L=150000U W=210000U AS=21875000000P
+ AD=40400000000P PS=460000U PD=560000U
* device instance $4697 r0 *1 30.105,33.06 nfet_01v8
M$4697 2186 2093 167 167 nfet_01v8 L=150000U W=210000U AS=40400000000P
+ AD=21875000000P PS=560000U PD=460000U
* device instance $4698 r0 *1 30.695,33.06 nfet_01v8
M$4698 731 607 167 167 nfet_01v8 L=150000U W=210000U AS=40400000000P
+ AD=21875000000P PS=560000U PD=460000U
* device instance $4699 r0 *1 30.14,33.46 nfet_01v8
M$4699 41 148 2186 167 nfet_01v8 L=150000U W=140000U AS=21875000000P
+ AD=16800000000P PS=460000U PD=380000U
* device instance $4700 r0 *1 30.66,33.46 nfet_01v8
M$4700 44 148 731 167 nfet_01v8 L=150000U W=140000U AS=21875000000P
+ AD=16800000000P PS=460000U PD=380000U
* device instance $4701 r0 *1 30.14,33.85 nfet_01v8
M$4701 3651 149 41 167 nfet_01v8 L=150000U W=140000U AS=16800000000P
+ AD=21875000000P PS=380000U PD=460000U
* device instance $4702 r0 *1 30.66,33.85 nfet_01v8
M$4702 1266 149 44 167 nfet_01v8 L=150000U W=140000U AS=16800000000P
+ AD=21875000000P PS=380000U PD=460000U
* device instance $4703 r0 *1 30.105,34.25 nfet_01v8
M$4703 167 2880 3651 167 nfet_01v8 L=150000U W=210000U AS=21875000000P
+ AD=40400000000P PS=460000U PD=560000U
* device instance $4704 r0 *1 30.695,34.25 nfet_01v8
M$4704 167 1843 1266 167 nfet_01v8 L=150000U W=210000U AS=21875000000P
+ AD=40400000000P PS=460000U PD=560000U
* device instance $4705 r0 *1 30.105,34.64 nfet_01v8
M$4705 2880 3651 167 167 nfet_01v8 L=150000U W=210000U AS=40400000000P
+ AD=21875000000P PS=560000U PD=460000U
* device instance $4706 r0 *1 30.695,34.64 nfet_01v8
M$4706 1843 1266 167 167 nfet_01v8 L=150000U W=210000U AS=40400000000P
+ AD=21875000000P PS=560000U PD=460000U
* device instance $4707 r0 *1 30.14,35.04 nfet_01v8
M$4707 42 149 2880 167 nfet_01v8 L=150000U W=140000U AS=21875000000P
+ AD=16800000000P PS=460000U PD=380000U
* device instance $4708 r0 *1 30.66,35.04 nfet_01v8
M$4708 43 149 1843 167 nfet_01v8 L=150000U W=140000U AS=21875000000P
+ AD=16800000000P PS=460000U PD=380000U
* device instance $4709 r0 *1 41.04,29.11 nfet_01v8
M$4709 3684 146 58 167 nfet_01v8 L=150000U W=140000U AS=16800000000P
+ AD=21875000000P PS=380000U PD=460000U
* device instance $4710 r0 *1 41.56,29.11 nfet_01v8
M$4710 1274 146 59 167 nfet_01v8 L=150000U W=140000U AS=16800000000P
+ AD=21875000000P PS=380000U PD=460000U
* device instance $4711 r0 *1 41.005,29.51 nfet_01v8
M$4711 167 2741 3684 167 nfet_01v8 L=150000U W=210000U AS=21875000000P
+ AD=40400000000P PS=460000U PD=560000U
* device instance $4712 r0 *1 41.595,29.51 nfet_01v8
M$4712 167 1851 1274 167 nfet_01v8 L=150000U W=210000U AS=21875000000P
+ AD=40400000000P PS=460000U PD=560000U
* device instance $4713 r0 *1 41.005,29.9 nfet_01v8
M$4713 2741 3684 167 167 nfet_01v8 L=150000U W=210000U AS=40400000000P
+ AD=21875000000P PS=560000U PD=460000U
* device instance $4714 r0 *1 41.595,29.9 nfet_01v8
M$4714 1851 1274 167 167 nfet_01v8 L=150000U W=210000U AS=40400000000P
+ AD=21875000000P PS=560000U PD=460000U
* device instance $4715 r0 *1 41.04,30.3 nfet_01v8
M$4715 57 146 2741 167 nfet_01v8 L=150000U W=140000U AS=21875000000P
+ AD=16800000000P PS=460000U PD=380000U
* device instance $4716 r0 *1 41.56,30.3 nfet_01v8
M$4716 60 146 1851 167 nfet_01v8 L=150000U W=140000U AS=21875000000P
+ AD=16800000000P PS=460000U PD=380000U
* device instance $4717 r0 *1 41.04,30.69 nfet_01v8
M$4717 3685 147 57 167 nfet_01v8 L=150000U W=140000U AS=16800000000P
+ AD=21875000000P PS=380000U PD=460000U
* device instance $4718 r0 *1 41.56,30.69 nfet_01v8
M$4718 4526 147 60 167 nfet_01v8 L=150000U W=140000U AS=16800000000P
+ AD=21875000000P PS=380000U PD=460000U
* device instance $4719 r0 *1 41.005,31.09 nfet_01v8
M$4719 167 2004 3685 167 nfet_01v8 L=150000U W=210000U AS=21875000000P
+ AD=40400000000P PS=460000U PD=560000U
* device instance $4720 r0 *1 41.595,31.09 nfet_01v8
M$4720 167 743 4526 167 nfet_01v8 L=150000U W=210000U AS=21875000000P
+ AD=40400000000P PS=460000U PD=560000U
* device instance $4721 r0 *1 41.005,31.48 nfet_01v8
M$4721 2004 3685 167 167 nfet_01v8 L=150000U W=210000U AS=40400000000P
+ AD=21875000000P PS=560000U PD=460000U
* device instance $4722 r0 *1 41.595,31.48 nfet_01v8
M$4722 743 4526 167 167 nfet_01v8 L=150000U W=210000U AS=40400000000P
+ AD=21875000000P PS=560000U PD=460000U
* device instance $4723 r0 *1 41.04,31.88 nfet_01v8
M$4723 58 147 2004 167 nfet_01v8 L=150000U W=140000U AS=21875000000P
+ AD=16800000000P PS=460000U PD=380000U
* device instance $4724 r0 *1 41.56,31.88 nfet_01v8
M$4724 59 147 743 167 nfet_01v8 L=150000U W=140000U AS=21875000000P
+ AD=16800000000P PS=460000U PD=380000U
* device instance $4725 r0 *1 41.04,32.27 nfet_01v8
M$4725 3682 148 58 167 nfet_01v8 L=150000U W=140000U AS=16800000000P
+ AD=21875000000P PS=380000U PD=460000U
* device instance $4726 r0 *1 41.56,32.27 nfet_01v8
M$4726 1275 148 59 167 nfet_01v8 L=150000U W=140000U AS=16800000000P
+ AD=21875000000P PS=380000U PD=460000U
* device instance $4727 r0 *1 41.005,32.67 nfet_01v8
M$4727 167 2202 3682 167 nfet_01v8 L=150000U W=210000U AS=21875000000P
+ AD=40400000000P PS=460000U PD=560000U
* device instance $4728 r0 *1 41.595,32.67 nfet_01v8
M$4728 167 1852 1275 167 nfet_01v8 L=150000U W=210000U AS=21875000000P
+ AD=40400000000P PS=460000U PD=560000U
* device instance $4729 r0 *1 41.005,33.06 nfet_01v8
M$4729 2202 3682 167 167 nfet_01v8 L=150000U W=210000U AS=40400000000P
+ AD=21875000000P PS=560000U PD=460000U
* device instance $4730 r0 *1 41.595,33.06 nfet_01v8
M$4730 1852 1275 167 167 nfet_01v8 L=150000U W=210000U AS=40400000000P
+ AD=21875000000P PS=560000U PD=460000U
* device instance $4731 r0 *1 41.04,33.46 nfet_01v8
M$4731 57 148 2202 167 nfet_01v8 L=150000U W=140000U AS=21875000000P
+ AD=16800000000P PS=460000U PD=380000U
* device instance $4732 r0 *1 41.56,33.46 nfet_01v8
M$4732 60 148 1852 167 nfet_01v8 L=150000U W=140000U AS=21875000000P
+ AD=16800000000P PS=460000U PD=380000U
* device instance $4733 r0 *1 41.04,33.85 nfet_01v8
M$4733 2357 149 57 167 nfet_01v8 L=150000U W=140000U AS=16800000000P
+ AD=21875000000P PS=380000U PD=460000U
* device instance $4734 r0 *1 41.56,33.85 nfet_01v8
M$4734 1276 149 60 167 nfet_01v8 L=150000U W=140000U AS=16800000000P
+ AD=21875000000P PS=380000U PD=460000U
* device instance $4735 r0 *1 41.005,34.25 nfet_01v8
M$4735 167 2742 2357 167 nfet_01v8 L=150000U W=210000U AS=21875000000P
+ AD=40400000000P PS=460000U PD=560000U
* device instance $4736 r0 *1 41.595,34.25 nfet_01v8
M$4736 167 1853 1276 167 nfet_01v8 L=150000U W=210000U AS=21875000000P
+ AD=40400000000P PS=460000U PD=560000U
* device instance $4737 r0 *1 41.005,34.64 nfet_01v8
M$4737 2742 2357 167 167 nfet_01v8 L=150000U W=210000U AS=40400000000P
+ AD=21875000000P PS=560000U PD=460000U
* device instance $4738 r0 *1 41.595,34.64 nfet_01v8
M$4738 1853 1276 167 167 nfet_01v8 L=150000U W=210000U AS=40400000000P
+ AD=21875000000P PS=560000U PD=460000U
* device instance $4739 r0 *1 41.04,35.04 nfet_01v8
M$4739 58 149 2742 167 nfet_01v8 L=150000U W=140000U AS=21875000000P
+ AD=16800000000P PS=460000U PD=380000U
* device instance $4740 r0 *1 41.56,35.04 nfet_01v8
M$4740 59 149 1853 167 nfet_01v8 L=150000U W=140000U AS=21875000000P
+ AD=16800000000P PS=460000U PD=380000U
* device instance $4741 r0 *1 51.94,29.11 nfet_01v8
M$4741 3483 146 74 167 nfet_01v8 L=150000U W=140000U AS=16800000000P
+ AD=21875000000P PS=380000U PD=460000U
* device instance $4742 r0 *1 52.46,29.11 nfet_01v8
M$4742 1137 146 75 167 nfet_01v8 L=150000U W=140000U AS=16800000000P
+ AD=21875000000P PS=380000U PD=460000U
* device instance $4743 r0 *1 51.905,29.51 nfet_01v8
M$4743 167 2899 3483 167 nfet_01v8 L=150000U W=210000U AS=21875000000P
+ AD=40400000000P PS=460000U PD=560000U
* device instance $4744 r0 *1 52.495,29.51 nfet_01v8
M$4744 167 1694 1137 167 nfet_01v8 L=150000U W=210000U AS=21875000000P
+ AD=40400000000P PS=460000U PD=560000U
* device instance $4745 r0 *1 51.905,29.9 nfet_01v8
M$4745 2899 3483 167 167 nfet_01v8 L=150000U W=210000U AS=40400000000P
+ AD=21875000000P PS=560000U PD=460000U
* device instance $4746 r0 *1 52.495,29.9 nfet_01v8
M$4746 1694 1137 167 167 nfet_01v8 L=150000U W=210000U AS=40400000000P
+ AD=21875000000P PS=560000U PD=460000U
* device instance $4747 r0 *1 51.94,30.3 nfet_01v8
M$4747 73 146 2899 167 nfet_01v8 L=150000U W=140000U AS=21875000000P
+ AD=16800000000P PS=460000U PD=380000U
* device instance $4748 r0 *1 52.46,30.3 nfet_01v8
M$4748 76 146 1694 167 nfet_01v8 L=150000U W=140000U AS=21875000000P
+ AD=16800000000P PS=460000U PD=380000U
* device instance $4749 r0 *1 51.94,30.69 nfet_01v8
M$4749 3473 147 73 167 nfet_01v8 L=150000U W=140000U AS=16800000000P
+ AD=21875000000P PS=380000U PD=460000U
* device instance $4750 r0 *1 52.46,30.69 nfet_01v8
M$4750 4354 147 76 167 nfet_01v8 L=150000U W=140000U AS=16800000000P
+ AD=21875000000P PS=380000U PD=460000U
* device instance $4751 r0 *1 51.905,31.09 nfet_01v8
M$4751 167 2254 3473 167 nfet_01v8 L=150000U W=210000U AS=21875000000P
+ AD=40400000000P PS=460000U PD=560000U
* device instance $4752 r0 *1 52.495,31.09 nfet_01v8
M$4752 167 862 4354 167 nfet_01v8 L=150000U W=210000U AS=21875000000P
+ AD=40400000000P PS=460000U PD=560000U
* device instance $4753 r0 *1 51.905,31.48 nfet_01v8
M$4753 2254 3473 167 167 nfet_01v8 L=150000U W=210000U AS=40400000000P
+ AD=21875000000P PS=560000U PD=460000U
* device instance $4754 r0 *1 52.495,31.48 nfet_01v8
M$4754 862 4354 167 167 nfet_01v8 L=150000U W=210000U AS=40400000000P
+ AD=21875000000P PS=560000U PD=460000U
* device instance $4755 r0 *1 51.94,31.88 nfet_01v8
M$4755 74 147 2254 167 nfet_01v8 L=150000U W=140000U AS=21875000000P
+ AD=16800000000P PS=460000U PD=380000U
* device instance $4756 r0 *1 52.46,31.88 nfet_01v8
M$4756 75 147 862 167 nfet_01v8 L=150000U W=140000U AS=21875000000P
+ AD=16800000000P PS=460000U PD=380000U
* device instance $4757 r0 *1 51.94,32.27 nfet_01v8
M$4757 2440 148 74 167 nfet_01v8 L=150000U W=140000U AS=16800000000P
+ AD=21875000000P PS=380000U PD=460000U
* device instance $4758 r0 *1 52.46,32.27 nfet_01v8
M$4758 1069 148 75 167 nfet_01v8 L=150000U W=140000U AS=16800000000P
+ AD=21875000000P PS=380000U PD=460000U
* device instance $4759 r0 *1 51.905,32.67 nfet_01v8
M$4759 167 2902 2440 167 nfet_01v8 L=150000U W=210000U AS=21875000000P
+ AD=40400000000P PS=460000U PD=560000U
* device instance $4760 r0 *1 52.495,32.67 nfet_01v8
M$4760 167 1613 1069 167 nfet_01v8 L=150000U W=210000U AS=21875000000P
+ AD=40400000000P PS=460000U PD=560000U
* device instance $4761 r0 *1 51.905,33.06 nfet_01v8
M$4761 2902 2440 167 167 nfet_01v8 L=150000U W=210000U AS=40400000000P
+ AD=21875000000P PS=560000U PD=460000U
* device instance $4762 r0 *1 52.495,33.06 nfet_01v8
M$4762 1613 1069 167 167 nfet_01v8 L=150000U W=210000U AS=40400000000P
+ AD=21875000000P PS=560000U PD=460000U
* device instance $4763 r0 *1 51.94,33.46 nfet_01v8
M$4763 73 148 2902 167 nfet_01v8 L=150000U W=140000U AS=21875000000P
+ AD=16800000000P PS=460000U PD=380000U
* device instance $4764 r0 *1 52.46,33.46 nfet_01v8
M$4764 76 148 1613 167 nfet_01v8 L=150000U W=140000U AS=21875000000P
+ AD=16800000000P PS=460000U PD=380000U
* device instance $4765 r0 *1 51.94,33.85 nfet_01v8
M$4765 3470 149 73 167 nfet_01v8 L=150000U W=140000U AS=16800000000P
+ AD=21875000000P PS=380000U PD=460000U
* device instance $4766 r0 *1 52.46,33.85 nfet_01v8
M$4766 1136 149 76 167 nfet_01v8 L=150000U W=140000U AS=16800000000P
+ AD=21875000000P PS=380000U PD=460000U
* device instance $4767 r0 *1 51.905,34.25 nfet_01v8
M$4767 167 2900 3470 167 nfet_01v8 L=150000U W=210000U AS=21875000000P
+ AD=40400000000P PS=460000U PD=560000U
* device instance $4768 r0 *1 52.495,34.25 nfet_01v8
M$4768 167 1693 1136 167 nfet_01v8 L=150000U W=210000U AS=21875000000P
+ AD=40400000000P PS=460000U PD=560000U
* device instance $4769 r0 *1 51.905,34.64 nfet_01v8
M$4769 2900 3470 167 167 nfet_01v8 L=150000U W=210000U AS=40400000000P
+ AD=21875000000P PS=560000U PD=460000U
* device instance $4770 r0 *1 52.495,34.64 nfet_01v8
M$4770 1693 1136 167 167 nfet_01v8 L=150000U W=210000U AS=40400000000P
+ AD=21875000000P PS=560000U PD=460000U
* device instance $4771 r0 *1 51.94,35.04 nfet_01v8
M$4771 74 149 2900 167 nfet_01v8 L=150000U W=140000U AS=21875000000P
+ AD=16800000000P PS=460000U PD=380000U
* device instance $4772 r0 *1 52.46,35.04 nfet_01v8
M$4772 75 149 1693 167 nfet_01v8 L=150000U W=140000U AS=21875000000P
+ AD=16800000000P PS=460000U PD=380000U
* device instance $4773 r0 *1 62.84,29.11 nfet_01v8
M$4773 2397 146 90 167 nfet_01v8 L=150000U W=140000U AS=16800000000P
+ AD=21875000000P PS=380000U PD=460000U
* device instance $4774 r0 *1 63.36,29.11 nfet_01v8
M$4774 969 146 91 167 nfet_01v8 L=150000U W=140000U AS=16800000000P
+ AD=21875000000P PS=380000U PD=460000U
* device instance $4775 r0 *1 62.805,29.51 nfet_01v8
M$4775 167 2812 2397 167 nfet_01v8 L=150000U W=210000U AS=21875000000P
+ AD=40400000000P PS=460000U PD=560000U
* device instance $4776 r0 *1 63.395,29.51 nfet_01v8
M$4776 167 1499 969 167 nfet_01v8 L=150000U W=210000U AS=21875000000P
+ AD=40400000000P PS=460000U PD=560000U
* device instance $4777 r0 *1 62.805,29.9 nfet_01v8
M$4777 2812 2397 167 167 nfet_01v8 L=150000U W=210000U AS=40400000000P
+ AD=21875000000P PS=560000U PD=460000U
* device instance $4778 r0 *1 63.395,29.9 nfet_01v8
M$4778 1499 969 167 167 nfet_01v8 L=150000U W=210000U AS=40400000000P
+ AD=21875000000P PS=560000U PD=460000U
* device instance $4779 r0 *1 62.84,30.3 nfet_01v8
M$4779 89 146 2812 167 nfet_01v8 L=150000U W=140000U AS=21875000000P
+ AD=16800000000P PS=460000U PD=380000U
* device instance $4780 r0 *1 63.36,30.3 nfet_01v8
M$4780 92 146 1499 167 nfet_01v8 L=150000U W=140000U AS=21875000000P
+ AD=16800000000P PS=460000U PD=380000U
* device instance $4781 r0 *1 62.84,30.69 nfet_01v8
M$4781 3464 147 89 167 nfet_01v8 L=150000U W=140000U AS=16800000000P
+ AD=21875000000P PS=380000U PD=460000U
* device instance $4782 r0 *1 63.36,30.69 nfet_01v8
M$4782 4364 147 92 167 nfet_01v8 L=150000U W=140000U AS=16800000000P
+ AD=21875000000P PS=380000U PD=460000U
* device instance $4783 r0 *1 62.805,31.09 nfet_01v8
M$4783 167 2061 3464 167 nfet_01v8 L=150000U W=210000U AS=21875000000P
+ AD=40400000000P PS=460000U PD=560000U
* device instance $4784 r0 *1 63.395,31.09 nfet_01v8
M$4784 167 773 4364 167 nfet_01v8 L=150000U W=210000U AS=21875000000P
+ AD=40400000000P PS=460000U PD=560000U
* device instance $4785 r0 *1 62.805,31.48 nfet_01v8
M$4785 2061 3464 167 167 nfet_01v8 L=150000U W=210000U AS=40400000000P
+ AD=21875000000P PS=560000U PD=460000U
* device instance $4786 r0 *1 63.395,31.48 nfet_01v8
M$4786 773 4364 167 167 nfet_01v8 L=150000U W=210000U AS=40400000000P
+ AD=21875000000P PS=560000U PD=460000U
* device instance $4787 r0 *1 62.84,31.88 nfet_01v8
M$4787 90 147 2061 167 nfet_01v8 L=150000U W=140000U AS=21875000000P
+ AD=16800000000P PS=460000U PD=380000U
* device instance $4788 r0 *1 63.36,31.88 nfet_01v8
M$4788 91 147 773 167 nfet_01v8 L=150000U W=140000U AS=21875000000P
+ AD=16800000000P PS=460000U PD=380000U
* device instance $4789 r0 *1 62.84,32.27 nfet_01v8
M$4789 2396 148 90 167 nfet_01v8 L=150000U W=140000U AS=16800000000P
+ AD=21875000000P PS=380000U PD=460000U
* device instance $4790 r0 *1 63.36,32.27 nfet_01v8
M$4790 970 148 91 167 nfet_01v8 L=150000U W=140000U AS=16800000000P
+ AD=21875000000P PS=380000U PD=460000U
* device instance $4791 r0 *1 62.805,32.67 nfet_01v8
M$4791 167 2810 2396 167 nfet_01v8 L=150000U W=210000U AS=21875000000P
+ AD=40400000000P PS=460000U PD=560000U
* device instance $4792 r0 *1 63.395,32.67 nfet_01v8
M$4792 167 1500 970 167 nfet_01v8 L=150000U W=210000U AS=21875000000P
+ AD=40400000000P PS=460000U PD=560000U
* device instance $4793 r0 *1 62.805,33.06 nfet_01v8
M$4793 2810 2396 167 167 nfet_01v8 L=150000U W=210000U AS=40400000000P
+ AD=21875000000P PS=560000U PD=460000U
* device instance $4794 r0 *1 63.395,33.06 nfet_01v8
M$4794 1500 970 167 167 nfet_01v8 L=150000U W=210000U AS=40400000000P
+ AD=21875000000P PS=560000U PD=460000U
* device instance $4795 r0 *1 62.84,33.46 nfet_01v8
M$4795 89 148 2810 167 nfet_01v8 L=150000U W=140000U AS=21875000000P
+ AD=16800000000P PS=460000U PD=380000U
* device instance $4796 r0 *1 63.36,33.46 nfet_01v8
M$4796 92 148 1500 167 nfet_01v8 L=150000U W=140000U AS=21875000000P
+ AD=16800000000P PS=460000U PD=380000U
* device instance $4797 r0 *1 62.84,33.85 nfet_01v8
M$4797 2395 149 89 167 nfet_01v8 L=150000U W=140000U AS=16800000000P
+ AD=21875000000P PS=380000U PD=460000U
* device instance $4798 r0 *1 63.36,33.85 nfet_01v8
M$4798 971 149 92 167 nfet_01v8 L=150000U W=140000U AS=16800000000P
+ AD=21875000000P PS=380000U PD=460000U
* device instance $4799 r0 *1 62.805,34.25 nfet_01v8
M$4799 167 2809 2395 167 nfet_01v8 L=150000U W=210000U AS=21875000000P
+ AD=40400000000P PS=460000U PD=560000U
* device instance $4800 r0 *1 63.395,34.25 nfet_01v8
M$4800 167 1501 971 167 nfet_01v8 L=150000U W=210000U AS=21875000000P
+ AD=40400000000P PS=460000U PD=560000U
* device instance $4801 r0 *1 62.805,34.64 nfet_01v8
M$4801 2809 2395 167 167 nfet_01v8 L=150000U W=210000U AS=40400000000P
+ AD=21875000000P PS=560000U PD=460000U
* device instance $4802 r0 *1 63.395,34.64 nfet_01v8
M$4802 1501 971 167 167 nfet_01v8 L=150000U W=210000U AS=40400000000P
+ AD=21875000000P PS=560000U PD=460000U
* device instance $4803 r0 *1 62.84,35.04 nfet_01v8
M$4803 90 149 2809 167 nfet_01v8 L=150000U W=140000U AS=21875000000P
+ AD=16800000000P PS=460000U PD=380000U
* device instance $4804 r0 *1 63.36,35.04 nfet_01v8
M$4804 91 149 1501 167 nfet_01v8 L=150000U W=140000U AS=21875000000P
+ AD=16800000000P PS=460000U PD=380000U
* device instance $4805 r0 *1 73.74,29.11 nfet_01v8
M$4805 3433 146 106 167 nfet_01v8 L=150000U W=140000U AS=16800000000P
+ AD=21875000000P PS=380000U PD=460000U
* device instance $4806 r0 *1 74.26,29.11 nfet_01v8
M$4806 947 146 107 167 nfet_01v8 L=150000U W=140000U AS=16800000000P
+ AD=21875000000P PS=380000U PD=460000U
* device instance $4807 r0 *1 73.705,29.51 nfet_01v8
M$4807 167 2885 3433 167 nfet_01v8 L=150000U W=210000U AS=21875000000P
+ AD=40400000000P PS=460000U PD=560000U
* device instance $4808 r0 *1 74.295,29.51 nfet_01v8
M$4808 167 1471 947 167 nfet_01v8 L=150000U W=210000U AS=21875000000P
+ AD=40400000000P PS=460000U PD=560000U
* device instance $4809 r0 *1 73.705,29.9 nfet_01v8
M$4809 2885 3433 167 167 nfet_01v8 L=150000U W=210000U AS=40400000000P
+ AD=21875000000P PS=560000U PD=460000U
* device instance $4810 r0 *1 74.295,29.9 nfet_01v8
M$4810 1471 947 167 167 nfet_01v8 L=150000U W=210000U AS=40400000000P
+ AD=21875000000P PS=560000U PD=460000U
* device instance $4811 r0 *1 73.74,30.3 nfet_01v8
M$4811 105 146 2885 167 nfet_01v8 L=150000U W=140000U AS=21875000000P
+ AD=16800000000P PS=460000U PD=380000U
* device instance $4812 r0 *1 74.26,30.3 nfet_01v8
M$4812 108 146 1471 167 nfet_01v8 L=150000U W=140000U AS=21875000000P
+ AD=16800000000P PS=460000U PD=380000U
* device instance $4813 r0 *1 73.74,30.69 nfet_01v8
M$4813 3434 147 105 167 nfet_01v8 L=150000U W=140000U AS=16800000000P
+ AD=21875000000P PS=380000U PD=460000U
* device instance $4814 r0 *1 74.26,30.69 nfet_01v8
M$4814 4292 147 108 167 nfet_01v8 L=150000U W=140000U AS=16800000000P
+ AD=21875000000P PS=380000U PD=460000U
* device instance $4815 r0 *1 73.705,31.09 nfet_01v8
M$4815 167 2044 3434 167 nfet_01v8 L=150000U W=210000U AS=21875000000P
+ AD=40400000000P PS=460000U PD=560000U
* device instance $4816 r0 *1 74.295,31.09 nfet_01v8
M$4816 167 1468 4292 167 nfet_01v8 L=150000U W=210000U AS=21875000000P
+ AD=40400000000P PS=460000U PD=560000U
* device instance $4817 r0 *1 73.705,31.48 nfet_01v8
M$4817 2044 3434 167 167 nfet_01v8 L=150000U W=210000U AS=40400000000P
+ AD=21875000000P PS=560000U PD=460000U
* device instance $4818 r0 *1 74.295,31.48 nfet_01v8
M$4818 1468 4292 167 167 nfet_01v8 L=150000U W=210000U AS=40400000000P
+ AD=21875000000P PS=560000U PD=460000U
* device instance $4819 r0 *1 73.74,31.88 nfet_01v8
M$4819 106 147 2044 167 nfet_01v8 L=150000U W=140000U AS=21875000000P
+ AD=16800000000P PS=460000U PD=380000U
* device instance $4820 r0 *1 74.26,31.88 nfet_01v8
M$4820 107 147 1468 167 nfet_01v8 L=150000U W=140000U AS=21875000000P
+ AD=16800000000P PS=460000U PD=380000U
* device instance $4821 r0 *1 73.74,32.27 nfet_01v8
M$4821 2355 148 106 167 nfet_01v8 L=150000U W=140000U AS=16800000000P
+ AD=21875000000P PS=380000U PD=460000U
* device instance $4822 r0 *1 74.26,32.27 nfet_01v8
M$4822 657 148 107 167 nfet_01v8 L=150000U W=140000U AS=16800000000P
+ AD=21875000000P PS=380000U PD=460000U
* device instance $4823 r0 *1 73.705,32.67 nfet_01v8
M$4823 167 2739 2355 167 nfet_01v8 L=150000U W=210000U AS=21875000000P
+ AD=40400000000P PS=460000U PD=560000U
* device instance $4824 r0 *1 74.295,32.67 nfet_01v8
M$4824 167 837 657 167 nfet_01v8 L=150000U W=210000U AS=21875000000P
+ AD=40400000000P PS=460000U PD=560000U
* device instance $4825 r0 *1 73.705,33.06 nfet_01v8
M$4825 2739 2355 167 167 nfet_01v8 L=150000U W=210000U AS=40400000000P
+ AD=21875000000P PS=560000U PD=460000U
* device instance $4826 r0 *1 74.295,33.06 nfet_01v8
M$4826 837 657 167 167 nfet_01v8 L=150000U W=210000U AS=40400000000P
+ AD=21875000000P PS=560000U PD=460000U
* device instance $4827 r0 *1 73.74,33.46 nfet_01v8
M$4827 105 148 2739 167 nfet_01v8 L=150000U W=140000U AS=21875000000P
+ AD=16800000000P PS=460000U PD=380000U
* device instance $4828 r0 *1 74.26,33.46 nfet_01v8
M$4828 108 148 837 167 nfet_01v8 L=150000U W=140000U AS=21875000000P
+ AD=16800000000P PS=460000U PD=380000U
* device instance $4829 r0 *1 73.74,33.85 nfet_01v8
M$4829 2359 149 105 167 nfet_01v8 L=150000U W=140000U AS=16800000000P
+ AD=21875000000P PS=380000U PD=460000U
* device instance $4830 r0 *1 74.26,33.85 nfet_01v8
M$4830 944 149 108 167 nfet_01v8 L=150000U W=140000U AS=16800000000P
+ AD=21875000000P PS=380000U PD=460000U
* device instance $4831 r0 *1 73.705,34.25 nfet_01v8
M$4831 167 2747 2359 167 nfet_01v8 L=150000U W=210000U AS=21875000000P
+ AD=40400000000P PS=460000U PD=560000U
* device instance $4832 r0 *1 74.295,34.25 nfet_01v8
M$4832 167 1467 944 167 nfet_01v8 L=150000U W=210000U AS=21875000000P
+ AD=40400000000P PS=460000U PD=560000U
* device instance $4833 r0 *1 73.705,34.64 nfet_01v8
M$4833 2747 2359 167 167 nfet_01v8 L=150000U W=210000U AS=40400000000P
+ AD=21875000000P PS=560000U PD=460000U
* device instance $4834 r0 *1 74.295,34.64 nfet_01v8
M$4834 1467 944 167 167 nfet_01v8 L=150000U W=210000U AS=40400000000P
+ AD=21875000000P PS=560000U PD=460000U
* device instance $4835 r0 *1 73.74,35.04 nfet_01v8
M$4835 106 149 2747 167 nfet_01v8 L=150000U W=140000U AS=21875000000P
+ AD=16800000000P PS=460000U PD=380000U
* device instance $4836 r0 *1 74.26,35.04 nfet_01v8
M$4836 107 149 1467 167 nfet_01v8 L=150000U W=140000U AS=21875000000P
+ AD=16800000000P PS=460000U PD=380000U
* device instance $4837 r0 *1 84.64,29.11 nfet_01v8
M$4837 2391 146 122 167 nfet_01v8 L=150000U W=140000U AS=16800000000P
+ AD=21875000000P PS=380000U PD=460000U
* device instance $4838 r0 *1 85.16,29.11 nfet_01v8
M$4838 962 146 123 167 nfet_01v8 L=150000U W=140000U AS=16800000000P
+ AD=21875000000P PS=380000U PD=460000U
* device instance $4839 r0 *1 84.605,29.51 nfet_01v8
M$4839 167 2802 2391 167 nfet_01v8 L=150000U W=210000U AS=21875000000P
+ AD=40400000000P PS=460000U PD=560000U
* device instance $4840 r0 *1 85.195,29.51 nfet_01v8
M$4840 167 1491 962 167 nfet_01v8 L=150000U W=210000U AS=21875000000P
+ AD=40400000000P PS=460000U PD=560000U
* device instance $4841 r0 *1 84.605,29.9 nfet_01v8
M$4841 2802 2391 167 167 nfet_01v8 L=150000U W=210000U AS=40400000000P
+ AD=21875000000P PS=560000U PD=460000U
* device instance $4842 r0 *1 85.195,29.9 nfet_01v8
M$4842 1491 962 167 167 nfet_01v8 L=150000U W=210000U AS=40400000000P
+ AD=21875000000P PS=560000U PD=460000U
* device instance $4843 r0 *1 84.64,30.3 nfet_01v8
M$4843 121 146 2802 167 nfet_01v8 L=150000U W=140000U AS=21875000000P
+ AD=16800000000P PS=460000U PD=380000U
* device instance $4844 r0 *1 85.16,30.3 nfet_01v8
M$4844 124 146 1491 167 nfet_01v8 L=150000U W=140000U AS=21875000000P
+ AD=16800000000P PS=460000U PD=380000U
* device instance $4845 r0 *1 84.64,30.69 nfet_01v8
M$4845 3240 147 121 167 nfet_01v8 L=150000U W=140000U AS=16800000000P
+ AD=21875000000P PS=380000U PD=460000U
* device instance $4846 r0 *1 85.16,30.69 nfet_01v8
M$4846 4278 147 124 167 nfet_01v8 L=150000U W=140000U AS=16800000000P
+ AD=21875000000P PS=380000U PD=460000U
* device instance $4847 r0 *1 84.605,31.09 nfet_01v8
M$4847 167 2795 3240 167 nfet_01v8 L=150000U W=210000U AS=21875000000P
+ AD=40400000000P PS=460000U PD=560000U
* device instance $4848 r0 *1 85.195,31.09 nfet_01v8
M$4848 167 1489 4278 167 nfet_01v8 L=150000U W=210000U AS=21875000000P
+ AD=40400000000P PS=460000U PD=560000U
* device instance $4849 r0 *1 84.605,31.48 nfet_01v8
M$4849 2795 3240 167 167 nfet_01v8 L=150000U W=210000U AS=40400000000P
+ AD=21875000000P PS=560000U PD=460000U
* device instance $4850 r0 *1 85.195,31.48 nfet_01v8
M$4850 1489 4278 167 167 nfet_01v8 L=150000U W=210000U AS=40400000000P
+ AD=21875000000P PS=560000U PD=460000U
* device instance $4851 r0 *1 84.64,31.88 nfet_01v8
M$4851 122 147 2795 167 nfet_01v8 L=150000U W=140000U AS=21875000000P
+ AD=16800000000P PS=460000U PD=380000U
* device instance $4852 r0 *1 85.16,31.88 nfet_01v8
M$4852 123 147 1489 167 nfet_01v8 L=150000U W=140000U AS=21875000000P
+ AD=16800000000P PS=460000U PD=380000U
* device instance $4853 r0 *1 84.64,32.27 nfet_01v8
M$4853 2074 148 122 167 nfet_01v8 L=150000U W=140000U AS=16800000000P
+ AD=21875000000P PS=380000U PD=460000U
* device instance $4854 r0 *1 85.16,32.27 nfet_01v8
M$4854 665 148 123 167 nfet_01v8 L=150000U W=140000U AS=16800000000P
+ AD=21875000000P PS=380000U PD=460000U
* device instance $4855 r0 *1 84.605,32.67 nfet_01v8
M$4855 167 2150 2074 167 nfet_01v8 L=150000U W=210000U AS=21875000000P
+ AD=40400000000P PS=460000U PD=560000U
* device instance $4856 r0 *1 85.195,32.67 nfet_01v8
M$4856 167 854 665 167 nfet_01v8 L=150000U W=210000U AS=21875000000P
+ AD=40400000000P PS=460000U PD=560000U
* device instance $4857 r0 *1 84.605,33.06 nfet_01v8
M$4857 2150 2074 167 167 nfet_01v8 L=150000U W=210000U AS=40400000000P
+ AD=21875000000P PS=560000U PD=460000U
* device instance $4858 r0 *1 85.195,33.06 nfet_01v8
M$4858 854 665 167 167 nfet_01v8 L=150000U W=210000U AS=40400000000P
+ AD=21875000000P PS=560000U PD=460000U
* device instance $4859 r0 *1 84.64,33.46 nfet_01v8
M$4859 121 148 2150 167 nfet_01v8 L=150000U W=140000U AS=21875000000P
+ AD=16800000000P PS=460000U PD=380000U
* device instance $4860 r0 *1 85.16,33.46 nfet_01v8
M$4860 124 148 854 167 nfet_01v8 L=150000U W=140000U AS=21875000000P
+ AD=16800000000P PS=460000U PD=380000U
* device instance $4861 r0 *1 84.64,33.85 nfet_01v8
M$4861 3238 149 121 167 nfet_01v8 L=150000U W=140000U AS=16800000000P
+ AD=21875000000P PS=380000U PD=460000U
* device instance $4862 r0 *1 85.16,33.85 nfet_01v8
M$4862 958 149 124 167 nfet_01v8 L=150000U W=140000U AS=16800000000P
+ AD=21875000000P PS=380000U PD=460000U
* device instance $4863 r0 *1 84.605,34.25 nfet_01v8
M$4863 167 2769 3238 167 nfet_01v8 L=150000U W=210000U AS=21875000000P
+ AD=40400000000P PS=460000U PD=560000U
* device instance $4864 r0 *1 85.195,34.25 nfet_01v8
M$4864 167 1484 958 167 nfet_01v8 L=150000U W=210000U AS=21875000000P
+ AD=40400000000P PS=460000U PD=560000U
* device instance $4865 r0 *1 84.605,34.64 nfet_01v8
M$4865 2769 3238 167 167 nfet_01v8 L=150000U W=210000U AS=40400000000P
+ AD=21875000000P PS=560000U PD=460000U
* device instance $4866 r0 *1 85.195,34.64 nfet_01v8
M$4866 1484 958 167 167 nfet_01v8 L=150000U W=210000U AS=40400000000P
+ AD=21875000000P PS=560000U PD=460000U
* device instance $4867 r0 *1 84.64,35.04 nfet_01v8
M$4867 122 149 2769 167 nfet_01v8 L=150000U W=140000U AS=21875000000P
+ AD=16800000000P PS=460000U PD=380000U
* device instance $4868 r0 *1 85.16,35.04 nfet_01v8
M$4868 123 149 1484 167 nfet_01v8 L=150000U W=140000U AS=21875000000P
+ AD=16800000000P PS=460000U PD=380000U
* device instance $4869 r0 *1 19.24,60.71 nfet_01v8
M$4869 2473 162 26 167 nfet_01v8 L=150000U W=140000U AS=16800000000P
+ AD=21875000000P PS=380000U PD=460000U
* device instance $4870 r0 *1 19.76,60.71 nfet_01v8
M$4870 911 162 27 167 nfet_01v8 L=150000U W=140000U AS=16800000000P
+ AD=21875000000P PS=380000U PD=460000U
* device instance $4871 r0 *1 19.205,61.11 nfet_01v8
M$4871 167 2969 2473 167 nfet_01v8 L=150000U W=210000U AS=21875000000P
+ AD=40400000000P PS=460000U PD=560000U
* device instance $4872 r0 *1 19.795,61.11 nfet_01v8
M$4872 167 1428 911 167 nfet_01v8 L=150000U W=210000U AS=21875000000P
+ AD=40400000000P PS=460000U PD=560000U
* device instance $4873 r0 *1 19.205,61.5 nfet_01v8
M$4873 2969 2473 167 167 nfet_01v8 L=150000U W=210000U AS=40400000000P
+ AD=21875000000P PS=560000U PD=460000U
* device instance $4874 r0 *1 19.795,61.5 nfet_01v8
M$4874 1428 911 167 167 nfet_01v8 L=150000U W=210000U AS=40400000000P
+ AD=21875000000P PS=560000U PD=460000U
* device instance $4875 r0 *1 19.24,61.9 nfet_01v8
M$4875 25 162 2969 167 nfet_01v8 L=150000U W=140000U AS=21875000000P
+ AD=16800000000P PS=460000U PD=380000U
* device instance $4876 r0 *1 19.76,61.9 nfet_01v8
M$4876 28 162 1428 167 nfet_01v8 L=150000U W=140000U AS=21875000000P
+ AD=16800000000P PS=460000U PD=380000U
* device instance $4877 r0 *1 19.24,62.29 nfet_01v8
M$4877 3705 163 25 167 nfet_01v8 L=150000U W=140000U AS=16800000000P
+ AD=21875000000P PS=380000U PD=460000U
* device instance $4878 r0 *1 19.76,62.29 nfet_01v8
M$4878 4445 163 28 167 nfet_01v8 L=150000U W=140000U AS=16800000000P
+ AD=21875000000P PS=380000U PD=460000U
* device instance $4879 r0 *1 19.205,62.69 nfet_01v8
M$4879 167 2132 3705 167 nfet_01v8 L=150000U W=210000U AS=21875000000P
+ AD=40400000000P PS=460000U PD=560000U
* device instance $4880 r0 *1 19.795,62.69 nfet_01v8
M$4880 167 825 4445 167 nfet_01v8 L=150000U W=210000U AS=21875000000P
+ AD=40400000000P PS=460000U PD=560000U
* device instance $4881 r0 *1 19.205,63.08 nfet_01v8
M$4881 2132 3705 167 167 nfet_01v8 L=150000U W=210000U AS=40400000000P
+ AD=21875000000P PS=560000U PD=460000U
* device instance $4882 r0 *1 19.795,63.08 nfet_01v8
M$4882 825 4445 167 167 nfet_01v8 L=150000U W=210000U AS=40400000000P
+ AD=21875000000P PS=560000U PD=460000U
* device instance $4883 r0 *1 19.24,63.48 nfet_01v8
M$4883 26 163 2132 167 nfet_01v8 L=150000U W=140000U AS=21875000000P
+ AD=16800000000P PS=460000U PD=380000U
* device instance $4884 r0 *1 19.76,63.48 nfet_01v8
M$4884 27 163 825 167 nfet_01v8 L=150000U W=140000U AS=21875000000P
+ AD=16800000000P PS=460000U PD=380000U
* device instance $4885 r0 *1 19.24,63.87 nfet_01v8
M$4885 2122 164 26 167 nfet_01v8 L=150000U W=140000U AS=16800000000P
+ AD=21875000000P PS=380000U PD=460000U
* device instance $4886 r0 *1 19.76,63.87 nfet_01v8
M$4886 638 164 27 167 nfet_01v8 L=150000U W=140000U AS=16800000000P
+ AD=21875000000P PS=380000U PD=460000U
* device instance $4887 r0 *1 19.205,64.27 nfet_01v8
M$4887 167 2255 2122 167 nfet_01v8 L=150000U W=210000U AS=21875000000P
+ AD=40400000000P PS=460000U PD=560000U
* device instance $4888 r0 *1 19.795,64.27 nfet_01v8
M$4888 167 796 638 167 nfet_01v8 L=150000U W=210000U AS=21875000000P
+ AD=40400000000P PS=460000U PD=560000U
* device instance $4889 r0 *1 19.205,64.66 nfet_01v8
M$4889 2255 2122 167 167 nfet_01v8 L=150000U W=210000U AS=40400000000P
+ AD=21875000000P PS=560000U PD=460000U
* device instance $4890 r0 *1 19.795,64.66 nfet_01v8
M$4890 796 638 167 167 nfet_01v8 L=150000U W=210000U AS=40400000000P
+ AD=21875000000P PS=560000U PD=460000U
* device instance $4891 r0 *1 19.24,65.06 nfet_01v8
M$4891 25 164 2255 167 nfet_01v8 L=150000U W=140000U AS=21875000000P
+ AD=16800000000P PS=460000U PD=380000U
* device instance $4892 r0 *1 19.76,65.06 nfet_01v8
M$4892 28 164 796 167 nfet_01v8 L=150000U W=140000U AS=21875000000P
+ AD=16800000000P PS=460000U PD=380000U
* device instance $4893 r0 *1 19.24,65.45 nfet_01v8
M$4893 2482 165 25 167 nfet_01v8 L=150000U W=140000U AS=16800000000P
+ AD=21875000000P PS=380000U PD=460000U
* device instance $4894 r0 *1 19.76,65.45 nfet_01v8
M$4894 877 165 28 167 nfet_01v8 L=150000U W=140000U AS=16800000000P
+ AD=21875000000P PS=380000U PD=460000U
* device instance $4895 r0 *1 19.205,65.85 nfet_01v8
M$4895 167 2986 2482 167 nfet_01v8 L=150000U W=210000U AS=21875000000P
+ AD=40400000000P PS=460000U PD=560000U
* device instance $4896 r0 *1 19.795,65.85 nfet_01v8
M$4896 167 1387 877 167 nfet_01v8 L=150000U W=210000U AS=21875000000P
+ AD=40400000000P PS=460000U PD=560000U
* device instance $4897 r0 *1 19.205,66.24 nfet_01v8
M$4897 2986 2482 167 167 nfet_01v8 L=150000U W=210000U AS=40400000000P
+ AD=21875000000P PS=560000U PD=460000U
* device instance $4898 r0 *1 19.795,66.24 nfet_01v8
M$4898 1387 877 167 167 nfet_01v8 L=150000U W=210000U AS=40400000000P
+ AD=21875000000P PS=560000U PD=460000U
* device instance $4899 r0 *1 19.24,66.64 nfet_01v8
M$4899 26 165 2986 167 nfet_01v8 L=150000U W=140000U AS=21875000000P
+ AD=16800000000P PS=460000U PD=380000U
* device instance $4900 r0 *1 19.76,66.64 nfet_01v8
M$4900 27 165 1387 167 nfet_01v8 L=150000U W=140000U AS=21875000000P
+ AD=16800000000P PS=460000U PD=380000U
* device instance $4901 r0 *1 8.34,21.21 nfet_01v8
M$4901 2410 142 10 167 nfet_01v8 L=150000U W=140000U AS=16800000000P
+ AD=21875000000P PS=380000U PD=460000U
* device instance $4902 r0 *1 8.86,21.21 nfet_01v8
M$4902 1306 142 11 167 nfet_01v8 L=150000U W=140000U AS=16800000000P
+ AD=21875000000P PS=380000U PD=460000U
* device instance $4903 r0 *1 8.305,21.61 nfet_01v8
M$4903 167 2830 2410 167 nfet_01v8 L=150000U W=210000U AS=21875000000P
+ AD=40400000000P PS=460000U PD=560000U
* device instance $4904 r0 *1 8.895,21.61 nfet_01v8
M$4904 167 1884 1306 167 nfet_01v8 L=150000U W=210000U AS=21875000000P
+ AD=40400000000P PS=460000U PD=560000U
* device instance $4905 r0 *1 8.305,22 nfet_01v8
M$4905 2830 2410 167 167 nfet_01v8 L=150000U W=210000U AS=40400000000P
+ AD=21875000000P PS=560000U PD=460000U
* device instance $4906 r0 *1 8.895,22 nfet_01v8
M$4906 1884 1306 167 167 nfet_01v8 L=150000U W=210000U AS=40400000000P
+ AD=21875000000P PS=560000U PD=460000U
* device instance $4907 r0 *1 8.34,22.4 nfet_01v8
M$4907 9 142 2830 167 nfet_01v8 L=150000U W=140000U AS=21875000000P
+ AD=16800000000P PS=460000U PD=380000U
* device instance $4908 r0 *1 8.86,22.4 nfet_01v8
M$4908 12 142 1884 167 nfet_01v8 L=150000U W=140000U AS=21875000000P
+ AD=16800000000P PS=460000U PD=380000U
* device instance $4909 r0 *1 8.34,22.79 nfet_01v8
M$4909 3316 143 9 167 nfet_01v8 L=150000U W=140000U AS=16800000000P
+ AD=21875000000P PS=380000U PD=460000U
* device instance $4910 r0 *1 8.86,22.79 nfet_01v8
M$4910 4532 143 12 167 nfet_01v8 L=150000U W=140000U AS=16800000000P
+ AD=21875000000P PS=380000U PD=460000U
* device instance $4911 r0 *1 8.305,23.19 nfet_01v8
M$4911 167 2845 3316 167 nfet_01v8 L=150000U W=210000U AS=21875000000P
+ AD=40400000000P PS=460000U PD=560000U
* device instance $4912 r0 *1 8.895,23.19 nfet_01v8
M$4912 167 1966 4532 167 nfet_01v8 L=150000U W=210000U AS=21875000000P
+ AD=40400000000P PS=460000U PD=560000U
* device instance $4913 r0 *1 8.305,23.58 nfet_01v8
M$4913 2845 3316 167 167 nfet_01v8 L=150000U W=210000U AS=40400000000P
+ AD=21875000000P PS=560000U PD=460000U
* device instance $4914 r0 *1 8.895,23.58 nfet_01v8
M$4914 1966 4532 167 167 nfet_01v8 L=150000U W=210000U AS=40400000000P
+ AD=21875000000P PS=560000U PD=460000U
* device instance $4915 r0 *1 8.34,23.98 nfet_01v8
M$4915 10 143 2845 167 nfet_01v8 L=150000U W=140000U AS=21875000000P
+ AD=16800000000P PS=460000U PD=380000U
* device instance $4916 r0 *1 8.86,23.98 nfet_01v8
M$4916 11 143 1966 167 nfet_01v8 L=150000U W=140000U AS=21875000000P
+ AD=16800000000P PS=460000U PD=380000U
* device instance $4917 r0 *1 8.34,24.37 nfet_01v8
M$4917 2427 144 10 167 nfet_01v8 L=150000U W=140000U AS=16800000000P
+ AD=21875000000P PS=380000U PD=460000U
* device instance $4918 r0 *1 8.86,24.37 nfet_01v8
M$4918 1369 144 11 167 nfet_01v8 L=150000U W=140000U AS=16800000000P
+ AD=21875000000P PS=380000U PD=460000U
* device instance $4919 r0 *1 8.305,24.77 nfet_01v8
M$4919 167 2862 2427 167 nfet_01v8 L=150000U W=210000U AS=21875000000P
+ AD=40400000000P PS=460000U PD=560000U
* device instance $4920 r0 *1 8.895,24.77 nfet_01v8
M$4920 167 1960 1369 167 nfet_01v8 L=150000U W=210000U AS=21875000000P
+ AD=40400000000P PS=460000U PD=560000U
* device instance $4921 r0 *1 8.305,25.16 nfet_01v8
M$4921 2862 2427 167 167 nfet_01v8 L=150000U W=210000U AS=40400000000P
+ AD=21875000000P PS=560000U PD=460000U
* device instance $4922 r0 *1 8.895,25.16 nfet_01v8
M$4922 1960 1369 167 167 nfet_01v8 L=150000U W=210000U AS=40400000000P
+ AD=21875000000P PS=560000U PD=460000U
* device instance $4923 r0 *1 8.34,25.56 nfet_01v8
M$4923 9 144 2862 167 nfet_01v8 L=150000U W=140000U AS=21875000000P
+ AD=16800000000P PS=460000U PD=380000U
* device instance $4924 r0 *1 8.86,25.56 nfet_01v8
M$4924 12 144 1960 167 nfet_01v8 L=150000U W=140000U AS=21875000000P
+ AD=16800000000P PS=460000U PD=380000U
* device instance $4925 r0 *1 8.34,25.95 nfet_01v8
M$4925 2425 145 9 167 nfet_01v8 L=150000U W=140000U AS=16800000000P
+ AD=21875000000P PS=380000U PD=460000U
* device instance $4926 r0 *1 8.86,25.95 nfet_01v8
M$4926 1366 145 12 167 nfet_01v8 L=150000U W=140000U AS=16800000000P
+ AD=21875000000P PS=380000U PD=460000U
* device instance $4927 r0 *1 8.305,26.35 nfet_01v8
M$4927 167 2860 2425 167 nfet_01v8 L=150000U W=210000U AS=21875000000P
+ AD=40400000000P PS=460000U PD=560000U
* device instance $4928 r0 *1 8.895,26.35 nfet_01v8
M$4928 167 1957 1366 167 nfet_01v8 L=150000U W=210000U AS=21875000000P
+ AD=40400000000P PS=460000U PD=560000U
* device instance $4929 r0 *1 8.305,26.74 nfet_01v8
M$4929 2860 2425 167 167 nfet_01v8 L=150000U W=210000U AS=40400000000P
+ AD=21875000000P PS=560000U PD=460000U
* device instance $4930 r0 *1 8.895,26.74 nfet_01v8
M$4930 1957 1366 167 167 nfet_01v8 L=150000U W=210000U AS=40400000000P
+ AD=21875000000P PS=560000U PD=460000U
* device instance $4931 r0 *1 8.34,27.14 nfet_01v8
M$4931 10 145 2860 167 nfet_01v8 L=150000U W=140000U AS=21875000000P
+ AD=16800000000P PS=460000U PD=380000U
* device instance $4932 r0 *1 8.86,27.14 nfet_01v8
M$4932 11 145 1957 167 nfet_01v8 L=150000U W=140000U AS=21875000000P
+ AD=16800000000P PS=460000U PD=380000U
* device instance $4933 r0 *1 19.24,21.21 nfet_01v8
M$4933 3324 142 26 167 nfet_01v8 L=150000U W=140000U AS=16800000000P
+ AD=21875000000P PS=380000U PD=460000U
* device instance $4934 r0 *1 19.76,21.21 nfet_01v8
M$4934 1293 142 27 167 nfet_01v8 L=150000U W=140000U AS=16800000000P
+ AD=21875000000P PS=380000U PD=460000U
* device instance $4935 r0 *1 19.205,21.61 nfet_01v8
M$4935 167 2869 3324 167 nfet_01v8 L=150000U W=210000U AS=21875000000P
+ AD=40400000000P PS=460000U PD=560000U
* device instance $4936 r0 *1 19.795,21.61 nfet_01v8
M$4936 167 1870 1293 167 nfet_01v8 L=150000U W=210000U AS=21875000000P
+ AD=40400000000P PS=460000U PD=560000U
* device instance $4937 r0 *1 19.205,22 nfet_01v8
M$4937 2869 3324 167 167 nfet_01v8 L=150000U W=210000U AS=40400000000P
+ AD=21875000000P PS=560000U PD=460000U
* device instance $4938 r0 *1 19.795,22 nfet_01v8
M$4938 1870 1293 167 167 nfet_01v8 L=150000U W=210000U AS=40400000000P
+ AD=21875000000P PS=560000U PD=460000U
* device instance $4939 r0 *1 19.24,22.4 nfet_01v8
M$4939 25 142 2869 167 nfet_01v8 L=150000U W=140000U AS=21875000000P
+ AD=16800000000P PS=460000U PD=380000U
* device instance $4940 r0 *1 19.76,22.4 nfet_01v8
M$4940 28 142 1870 167 nfet_01v8 L=150000U W=140000U AS=21875000000P
+ AD=16800000000P PS=460000U PD=380000U
* device instance $4941 r0 *1 19.24,22.79 nfet_01v8
M$4941 3325 143 25 167 nfet_01v8 L=150000U W=140000U AS=16800000000P
+ AD=21875000000P PS=380000U PD=460000U
* device instance $4942 r0 *1 19.76,22.79 nfet_01v8
M$4942 4489 143 28 167 nfet_01v8 L=150000U W=140000U AS=16800000000P
+ AD=21875000000P PS=380000U PD=460000U
* device instance $4943 r0 *1 19.205,23.19 nfet_01v8
M$4943 167 2831 3325 167 nfet_01v8 L=150000U W=210000U AS=21875000000P
+ AD=40400000000P PS=460000U PD=560000U
* device instance $4944 r0 *1 19.795,23.19 nfet_01v8
M$4944 167 1885 4489 167 nfet_01v8 L=150000U W=210000U AS=21875000000P
+ AD=40400000000P PS=460000U PD=560000U
* device instance $4945 r0 *1 19.205,23.58 nfet_01v8
M$4945 2831 3325 167 167 nfet_01v8 L=150000U W=210000U AS=40400000000P
+ AD=21875000000P PS=560000U PD=460000U
* device instance $4946 r0 *1 19.795,23.58 nfet_01v8
M$4946 1885 4489 167 167 nfet_01v8 L=150000U W=210000U AS=40400000000P
+ AD=21875000000P PS=560000U PD=460000U
* device instance $4947 r0 *1 19.24,23.98 nfet_01v8
M$4947 26 143 2831 167 nfet_01v8 L=150000U W=140000U AS=21875000000P
+ AD=16800000000P PS=460000U PD=380000U
* device instance $4948 r0 *1 19.76,23.98 nfet_01v8
M$4948 27 143 1885 167 nfet_01v8 L=150000U W=140000U AS=21875000000P
+ AD=16800000000P PS=460000U PD=380000U
* device instance $4949 r0 *1 19.24,24.37 nfet_01v8
M$4949 2407 144 26 167 nfet_01v8 L=150000U W=140000U AS=16800000000P
+ AD=21875000000P PS=380000U PD=460000U
* device instance $4950 r0 *1 19.76,24.37 nfet_01v8
M$4950 623 144 27 167 nfet_01v8 L=150000U W=140000U AS=16800000000P
+ AD=21875000000P PS=380000U PD=460000U
* device instance $4951 r0 *1 19.205,24.77 nfet_01v8
M$4951 167 2824 2407 167 nfet_01v8 L=150000U W=210000U AS=21875000000P
+ AD=40400000000P PS=460000U PD=560000U
* device instance $4952 r0 *1 19.795,24.77 nfet_01v8
M$4952 167 766 623 167 nfet_01v8 L=150000U W=210000U AS=21875000000P
+ AD=40400000000P PS=460000U PD=560000U
* device instance $4953 r0 *1 19.205,25.16 nfet_01v8
M$4953 2824 2407 167 167 nfet_01v8 L=150000U W=210000U AS=40400000000P
+ AD=21875000000P PS=560000U PD=460000U
* device instance $4954 r0 *1 19.795,25.16 nfet_01v8
M$4954 766 623 167 167 nfet_01v8 L=150000U W=210000U AS=40400000000P
+ AD=21875000000P PS=560000U PD=460000U
* device instance $4955 r0 *1 19.24,25.56 nfet_01v8
M$4955 25 144 2824 167 nfet_01v8 L=150000U W=140000U AS=21875000000P
+ AD=16800000000P PS=460000U PD=380000U
* device instance $4956 r0 *1 19.76,25.56 nfet_01v8
M$4956 28 144 766 167 nfet_01v8 L=150000U W=140000U AS=21875000000P
+ AD=16800000000P PS=460000U PD=380000U
* device instance $4957 r0 *1 19.24,25.95 nfet_01v8
M$4957 2404 145 25 167 nfet_01v8 L=150000U W=140000U AS=16800000000P
+ AD=21875000000P PS=380000U PD=460000U
* device instance $4958 r0 *1 19.76,25.95 nfet_01v8
M$4958 1308 145 28 167 nfet_01v8 L=150000U W=140000U AS=16800000000P
+ AD=21875000000P PS=380000U PD=460000U
* device instance $4959 r0 *1 19.205,26.35 nfet_01v8
M$4959 167 2820 2404 167 nfet_01v8 L=150000U W=210000U AS=21875000000P
+ AD=40400000000P PS=460000U PD=560000U
* device instance $4960 r0 *1 19.795,26.35 nfet_01v8
M$4960 167 1888 1308 167 nfet_01v8 L=150000U W=210000U AS=21875000000P
+ AD=40400000000P PS=460000U PD=560000U
* device instance $4961 r0 *1 19.205,26.74 nfet_01v8
M$4961 2820 2404 167 167 nfet_01v8 L=150000U W=210000U AS=40400000000P
+ AD=21875000000P PS=560000U PD=460000U
* device instance $4962 r0 *1 19.795,26.74 nfet_01v8
M$4962 1888 1308 167 167 nfet_01v8 L=150000U W=210000U AS=40400000000P
+ AD=21875000000P PS=560000U PD=460000U
* device instance $4963 r0 *1 19.24,27.14 nfet_01v8
M$4963 26 145 2820 167 nfet_01v8 L=150000U W=140000U AS=21875000000P
+ AD=16800000000P PS=460000U PD=380000U
* device instance $4964 r0 *1 19.76,27.14 nfet_01v8
M$4964 27 145 1888 167 nfet_01v8 L=150000U W=140000U AS=21875000000P
+ AD=16800000000P PS=460000U PD=380000U
* device instance $4965 r0 *1 30.14,21.21 nfet_01v8
M$4965 2430 142 42 167 nfet_01v8 L=150000U W=140000U AS=16800000000P
+ AD=21875000000P PS=380000U PD=460000U
* device instance $4966 r0 *1 30.66,21.21 nfet_01v8
M$4966 1203 142 43 167 nfet_01v8 L=150000U W=140000U AS=16800000000P
+ AD=21875000000P PS=380000U PD=460000U
* device instance $4967 r0 *1 30.105,21.61 nfet_01v8
M$4967 167 2873 2430 167 nfet_01v8 L=150000U W=210000U AS=21875000000P
+ AD=40400000000P PS=460000U PD=560000U
* device instance $4968 r0 *1 30.695,21.61 nfet_01v8
M$4968 167 1773 1203 167 nfet_01v8 L=150000U W=210000U AS=21875000000P
+ AD=40400000000P PS=460000U PD=560000U
* device instance $4969 r0 *1 30.105,22 nfet_01v8
M$4969 2873 2430 167 167 nfet_01v8 L=150000U W=210000U AS=40400000000P
+ AD=21875000000P PS=560000U PD=460000U
* device instance $4970 r0 *1 30.695,22 nfet_01v8
M$4970 1773 1203 167 167 nfet_01v8 L=150000U W=210000U AS=40400000000P
+ AD=21875000000P PS=560000U PD=460000U
* device instance $4971 r0 *1 30.14,22.4 nfet_01v8
M$4971 41 142 2873 167 nfet_01v8 L=150000U W=140000U AS=21875000000P
+ AD=16800000000P PS=460000U PD=380000U
* device instance $4972 r0 *1 30.66,22.4 nfet_01v8
M$4972 44 142 1773 167 nfet_01v8 L=150000U W=140000U AS=21875000000P
+ AD=16800000000P PS=460000U PD=380000U
* device instance $4973 r0 *1 30.14,22.79 nfet_01v8
M$4973 3662 143 41 167 nfet_01v8 L=150000U W=140000U AS=16800000000P
+ AD=21875000000P PS=380000U PD=460000U
* device instance $4974 r0 *1 30.66,22.79 nfet_01v8
M$4974 4518 143 44 167 nfet_01v8 L=150000U W=140000U AS=16800000000P
+ AD=21875000000P PS=380000U PD=460000U
* device instance $4975 r0 *1 30.105,23.19 nfet_01v8
M$4975 167 2874 3662 167 nfet_01v8 L=150000U W=210000U AS=21875000000P
+ AD=40400000000P PS=460000U PD=560000U
* device instance $4976 r0 *1 30.695,23.19 nfet_01v8
M$4976 167 1750 4518 167 nfet_01v8 L=150000U W=210000U AS=21875000000P
+ AD=40400000000P PS=460000U PD=560000U
* device instance $4977 r0 *1 30.105,23.58 nfet_01v8
M$4977 2874 3662 167 167 nfet_01v8 L=150000U W=210000U AS=40400000000P
+ AD=21875000000P PS=560000U PD=460000U
* device instance $4978 r0 *1 30.695,23.58 nfet_01v8
M$4978 1750 4518 167 167 nfet_01v8 L=150000U W=210000U AS=40400000000P
+ AD=21875000000P PS=560000U PD=460000U
* device instance $4979 r0 *1 30.14,23.98 nfet_01v8
M$4979 42 143 2874 167 nfet_01v8 L=150000U W=140000U AS=21875000000P
+ AD=16800000000P PS=460000U PD=380000U
* device instance $4980 r0 *1 30.66,23.98 nfet_01v8
M$4980 43 143 1750 167 nfet_01v8 L=150000U W=140000U AS=21875000000P
+ AD=16800000000P PS=460000U PD=380000U
* device instance $4981 r0 *1 30.14,24.37 nfet_01v8
M$4981 3663 144 42 167 nfet_01v8 L=150000U W=140000U AS=16800000000P
+ AD=21875000000P PS=380000U PD=460000U
* device instance $4982 r0 *1 30.66,24.37 nfet_01v8
M$4982 584 144 43 167 nfet_01v8 L=150000U W=140000U AS=16800000000P
+ AD=21875000000P PS=380000U PD=460000U
* device instance $4983 r0 *1 30.105,24.77 nfet_01v8
M$4983 167 2233 3663 167 nfet_01v8 L=150000U W=210000U AS=21875000000P
+ AD=40400000000P PS=460000U PD=560000U
* device instance $4984 r0 *1 30.695,24.77 nfet_01v8
M$4984 167 683 584 167 nfet_01v8 L=150000U W=210000U AS=21875000000P
+ AD=40400000000P PS=460000U PD=560000U
* device instance $4985 r0 *1 30.105,25.16 nfet_01v8
M$4985 2233 3663 167 167 nfet_01v8 L=150000U W=210000U AS=40400000000P
+ AD=21875000000P PS=560000U PD=460000U
* device instance $4986 r0 *1 30.695,25.16 nfet_01v8
M$4986 683 584 167 167 nfet_01v8 L=150000U W=210000U AS=40400000000P
+ AD=21875000000P PS=560000U PD=460000U
* device instance $4987 r0 *1 30.14,25.56 nfet_01v8
M$4987 41 144 2233 167 nfet_01v8 L=150000U W=140000U AS=21875000000P
+ AD=16800000000P PS=460000U PD=380000U
* device instance $4988 r0 *1 30.66,25.56 nfet_01v8
M$4988 44 144 683 167 nfet_01v8 L=150000U W=140000U AS=21875000000P
+ AD=16800000000P PS=460000U PD=380000U
* device instance $4989 r0 *1 30.14,25.95 nfet_01v8
M$4989 3664 145 41 167 nfet_01v8 L=150000U W=140000U AS=16800000000P
+ AD=21875000000P PS=380000U PD=460000U
* device instance $4990 r0 *1 30.66,25.95 nfet_01v8
M$4990 1186 145 44 167 nfet_01v8 L=150000U W=140000U AS=16800000000P
+ AD=21875000000P PS=380000U PD=460000U
* device instance $4991 r0 *1 30.105,26.35 nfet_01v8
M$4991 167 2876 3664 167 nfet_01v8 L=150000U W=210000U AS=21875000000P
+ AD=40400000000P PS=460000U PD=560000U
* device instance $4992 r0 *1 30.695,26.35 nfet_01v8
M$4992 167 1751 1186 167 nfet_01v8 L=150000U W=210000U AS=21875000000P
+ AD=40400000000P PS=460000U PD=560000U
* device instance $4993 r0 *1 30.105,26.74 nfet_01v8
M$4993 2876 3664 167 167 nfet_01v8 L=150000U W=210000U AS=40400000000P
+ AD=21875000000P PS=560000U PD=460000U
* device instance $4994 r0 *1 30.695,26.74 nfet_01v8
M$4994 1751 1186 167 167 nfet_01v8 L=150000U W=210000U AS=40400000000P
+ AD=21875000000P PS=560000U PD=460000U
* device instance $4995 r0 *1 30.14,27.14 nfet_01v8
M$4995 42 145 2876 167 nfet_01v8 L=150000U W=140000U AS=21875000000P
+ AD=16800000000P PS=460000U PD=380000U
* device instance $4996 r0 *1 30.66,27.14 nfet_01v8
M$4996 43 145 1751 167 nfet_01v8 L=150000U W=140000U AS=21875000000P
+ AD=16800000000P PS=460000U PD=380000U
* device instance $4997 r0 *1 41.04,21.21 nfet_01v8
M$4997 3280 142 58 167 nfet_01v8 L=150000U W=140000U AS=16800000000P
+ AD=21875000000P PS=380000U PD=460000U
* device instance $4998 r0 *1 41.56,21.21 nfet_01v8
M$4998 1226 142 59 167 nfet_01v8 L=150000U W=140000U AS=16800000000P
+ AD=21875000000P PS=380000U PD=460000U
* device instance $4999 r0 *1 41.005,21.61 nfet_01v8
M$4999 167 2897 3280 167 nfet_01v8 L=150000U W=210000U AS=21875000000P
+ AD=40400000000P PS=460000U PD=560000U
* device instance $5000 r0 *1 41.595,21.61 nfet_01v8
M$5000 167 1797 1226 167 nfet_01v8 L=150000U W=210000U AS=21875000000P
+ AD=40400000000P PS=460000U PD=560000U
* device instance $5001 r0 *1 41.005,22 nfet_01v8
M$5001 2897 3280 167 167 nfet_01v8 L=150000U W=210000U AS=40400000000P
+ AD=21875000000P PS=560000U PD=460000U
* device instance $5002 r0 *1 41.595,22 nfet_01v8
M$5002 1797 1226 167 167 nfet_01v8 L=150000U W=210000U AS=40400000000P
+ AD=21875000000P PS=560000U PD=460000U
* device instance $5003 r0 *1 41.04,22.4 nfet_01v8
M$5003 57 142 2897 167 nfet_01v8 L=150000U W=140000U AS=21875000000P
+ AD=16800000000P PS=460000U PD=380000U
* device instance $5004 r0 *1 41.56,22.4 nfet_01v8
M$5004 60 142 1797 167 nfet_01v8 L=150000U W=140000U AS=21875000000P
+ AD=16800000000P PS=460000U PD=380000U
* device instance $5005 r0 *1 41.04,22.79 nfet_01v8
M$5005 3281 143 57 167 nfet_01v8 L=150000U W=140000U AS=16800000000P
+ AD=21875000000P PS=380000U PD=460000U
* device instance $5006 r0 *1 41.56,22.79 nfet_01v8
M$5006 4513 143 60 167 nfet_01v8 L=150000U W=140000U AS=16800000000P
+ AD=21875000000P PS=380000U PD=460000U
* device instance $5007 r0 *1 41.005,23.19 nfet_01v8
M$5007 167 2898 3281 167 nfet_01v8 L=150000U W=210000U AS=21875000000P
+ AD=40400000000P PS=460000U PD=560000U
* device instance $5008 r0 *1 41.595,23.19 nfet_01v8
M$5008 167 679 4513 167 nfet_01v8 L=150000U W=210000U AS=21875000000P
+ AD=40400000000P PS=460000U PD=560000U
* device instance $5009 r0 *1 41.005,23.58 nfet_01v8
M$5009 2898 3281 167 167 nfet_01v8 L=150000U W=210000U AS=40400000000P
+ AD=21875000000P PS=560000U PD=460000U
* device instance $5010 r0 *1 41.595,23.58 nfet_01v8
M$5010 679 4513 167 167 nfet_01v8 L=150000U W=210000U AS=40400000000P
+ AD=21875000000P PS=560000U PD=460000U
* device instance $5011 r0 *1 41.04,23.98 nfet_01v8
M$5011 58 143 2898 167 nfet_01v8 L=150000U W=140000U AS=21875000000P
+ AD=16800000000P PS=460000U PD=380000U
* device instance $5012 r0 *1 41.56,23.98 nfet_01v8
M$5012 59 143 679 167 nfet_01v8 L=150000U W=140000U AS=21875000000P
+ AD=16800000000P PS=460000U PD=380000U
* device instance $5013 r0 *1 41.04,24.37 nfet_01v8
M$5013 3277 144 58 167 nfet_01v8 L=150000U W=140000U AS=16800000000P
+ AD=21875000000P PS=380000U PD=460000U
* device instance $5014 r0 *1 41.56,24.37 nfet_01v8
M$5014 1224 144 59 167 nfet_01v8 L=150000U W=140000U AS=16800000000P
+ AD=21875000000P PS=380000U PD=460000U
* device instance $5015 r0 *1 41.005,24.77 nfet_01v8
M$5015 167 2895 3277 167 nfet_01v8 L=150000U W=210000U AS=21875000000P
+ AD=40400000000P PS=460000U PD=560000U
* device instance $5016 r0 *1 41.595,24.77 nfet_01v8
M$5016 167 1795 1224 167 nfet_01v8 L=150000U W=210000U AS=21875000000P
+ AD=40400000000P PS=460000U PD=560000U
* device instance $5017 r0 *1 41.005,25.16 nfet_01v8
M$5017 2895 3277 167 167 nfet_01v8 L=150000U W=210000U AS=40400000000P
+ AD=21875000000P PS=560000U PD=460000U
* device instance $5018 r0 *1 41.595,25.16 nfet_01v8
M$5018 1795 1224 167 167 nfet_01v8 L=150000U W=210000U AS=40400000000P
+ AD=21875000000P PS=560000U PD=460000U
* device instance $5019 r0 *1 41.04,25.56 nfet_01v8
M$5019 57 144 2895 167 nfet_01v8 L=150000U W=140000U AS=21875000000P
+ AD=16800000000P PS=460000U PD=380000U
* device instance $5020 r0 *1 41.56,25.56 nfet_01v8
M$5020 60 144 1795 167 nfet_01v8 L=150000U W=140000U AS=21875000000P
+ AD=16800000000P PS=460000U PD=380000U
* device instance $5021 r0 *1 41.04,25.95 nfet_01v8
M$5021 2438 145 57 167 nfet_01v8 L=150000U W=140000U AS=16800000000P
+ AD=21875000000P PS=380000U PD=460000U
* device instance $5022 r0 *1 41.56,25.95 nfet_01v8
M$5022 1225 145 60 167 nfet_01v8 L=150000U W=140000U AS=16800000000P
+ AD=21875000000P PS=380000U PD=460000U
* device instance $5023 r0 *1 41.005,26.35 nfet_01v8
M$5023 167 2896 2438 167 nfet_01v8 L=150000U W=210000U AS=21875000000P
+ AD=40400000000P PS=460000U PD=560000U
* device instance $5024 r0 *1 41.595,26.35 nfet_01v8
M$5024 167 1796 1225 167 nfet_01v8 L=150000U W=210000U AS=21875000000P
+ AD=40400000000P PS=460000U PD=560000U
* device instance $5025 r0 *1 41.005,26.74 nfet_01v8
M$5025 2896 2438 167 167 nfet_01v8 L=150000U W=210000U AS=40400000000P
+ AD=21875000000P PS=560000U PD=460000U
* device instance $5026 r0 *1 41.595,26.74 nfet_01v8
M$5026 1796 1225 167 167 nfet_01v8 L=150000U W=210000U AS=40400000000P
+ AD=21875000000P PS=560000U PD=460000U
* device instance $5027 r0 *1 41.04,27.14 nfet_01v8
M$5027 58 145 2896 167 nfet_01v8 L=150000U W=140000U AS=21875000000P
+ AD=16800000000P PS=460000U PD=380000U
* device instance $5028 r0 *1 41.56,27.14 nfet_01v8
M$5028 59 145 1796 167 nfet_01v8 L=150000U W=140000U AS=21875000000P
+ AD=16800000000P PS=460000U PD=380000U
* device instance $5029 r0 *1 51.94,21.21 nfet_01v8
M$5029 3472 142 74 167 nfet_01v8 L=150000U W=140000U AS=16800000000P
+ AD=21875000000P PS=380000U PD=460000U
* device instance $5030 r0 *1 52.46,21.21 nfet_01v8
M$5030 1150 142 75 167 nfet_01v8 L=150000U W=140000U AS=16800000000P
+ AD=21875000000P PS=380000U PD=460000U
* device instance $5031 r0 *1 51.905,21.61 nfet_01v8
M$5031 167 2891 3472 167 nfet_01v8 L=150000U W=210000U AS=21875000000P
+ AD=40400000000P PS=460000U PD=560000U
* device instance $5032 r0 *1 52.495,21.61 nfet_01v8
M$5032 167 1708 1150 167 nfet_01v8 L=150000U W=210000U AS=21875000000P
+ AD=40400000000P PS=460000U PD=560000U
* device instance $5033 r0 *1 51.905,22 nfet_01v8
M$5033 2891 3472 167 167 nfet_01v8 L=150000U W=210000U AS=40400000000P
+ AD=21875000000P PS=560000U PD=460000U
* device instance $5034 r0 *1 52.495,22 nfet_01v8
M$5034 1708 1150 167 167 nfet_01v8 L=150000U W=210000U AS=40400000000P
+ AD=21875000000P PS=560000U PD=460000U
* device instance $5035 r0 *1 51.94,22.4 nfet_01v8
M$5035 73 142 2891 167 nfet_01v8 L=150000U W=140000U AS=21875000000P
+ AD=16800000000P PS=460000U PD=380000U
* device instance $5036 r0 *1 52.46,22.4 nfet_01v8
M$5036 76 142 1708 167 nfet_01v8 L=150000U W=140000U AS=21875000000P
+ AD=16800000000P PS=460000U PD=380000U
* device instance $5037 r0 *1 51.94,22.79 nfet_01v8
M$5037 3446 143 73 167 nfet_01v8 L=150000U W=140000U AS=16800000000P
+ AD=21875000000P PS=380000U PD=460000U
* device instance $5038 r0 *1 52.46,22.79 nfet_01v8
M$5038 4379 143 76 167 nfet_01v8 L=150000U W=140000U AS=16800000000P
+ AD=21875000000P PS=380000U PD=460000U
* device instance $5039 r0 *1 51.905,23.19 nfet_01v8
M$5039 167 2257 3446 167 nfet_01v8 L=150000U W=210000U AS=21875000000P
+ AD=40400000000P PS=460000U PD=560000U
* device instance $5040 r0 *1 52.495,23.19 nfet_01v8
M$5040 167 809 4379 167 nfet_01v8 L=150000U W=210000U AS=21875000000P
+ AD=40400000000P PS=460000U PD=560000U
* device instance $5041 r0 *1 51.905,23.58 nfet_01v8
M$5041 2257 3446 167 167 nfet_01v8 L=150000U W=210000U AS=40400000000P
+ AD=21875000000P PS=560000U PD=460000U
* device instance $5042 r0 *1 52.495,23.58 nfet_01v8
M$5042 809 4379 167 167 nfet_01v8 L=150000U W=210000U AS=40400000000P
+ AD=21875000000P PS=560000U PD=460000U
* device instance $5043 r0 *1 51.94,23.98 nfet_01v8
M$5043 74 143 2257 167 nfet_01v8 L=150000U W=140000U AS=21875000000P
+ AD=16800000000P PS=460000U PD=380000U
* device instance $5044 r0 *1 52.46,23.98 nfet_01v8
M$5044 75 143 809 167 nfet_01v8 L=150000U W=140000U AS=21875000000P
+ AD=16800000000P PS=460000U PD=380000U
* device instance $5045 r0 *1 51.94,24.37 nfet_01v8
M$5045 2124 144 74 167 nfet_01v8 L=150000U W=140000U AS=16800000000P
+ AD=21875000000P PS=380000U PD=460000U
* device instance $5046 r0 *1 52.46,24.37 nfet_01v8
M$5046 635 144 75 167 nfet_01v8 L=150000U W=140000U AS=16800000000P
+ AD=21875000000P PS=380000U PD=460000U
* device instance $5047 r0 *1 51.905,24.77 nfet_01v8
M$5047 167 2260 2124 167 nfet_01v8 L=150000U W=210000U AS=21875000000P
+ AD=40400000000P PS=460000U PD=560000U
* device instance $5048 r0 *1 52.495,24.77 nfet_01v8
M$5048 167 787 635 167 nfet_01v8 L=150000U W=210000U AS=21875000000P
+ AD=40400000000P PS=460000U PD=560000U
* device instance $5049 r0 *1 51.905,25.16 nfet_01v8
M$5049 2260 2124 167 167 nfet_01v8 L=150000U W=210000U AS=40400000000P
+ AD=21875000000P PS=560000U PD=460000U
* device instance $5050 r0 *1 52.495,25.16 nfet_01v8
M$5050 787 635 167 167 nfet_01v8 L=150000U W=210000U AS=40400000000P
+ AD=21875000000P PS=560000U PD=460000U
* device instance $5051 r0 *1 51.94,25.56 nfet_01v8
M$5051 73 144 2260 167 nfet_01v8 L=150000U W=140000U AS=21875000000P
+ AD=16800000000P PS=460000U PD=380000U
* device instance $5052 r0 *1 52.46,25.56 nfet_01v8
M$5052 76 144 787 167 nfet_01v8 L=150000U W=140000U AS=21875000000P
+ AD=16800000000P PS=460000U PD=380000U
* device instance $5053 r0 *1 51.94,25.95 nfet_01v8
M$5053 3481 145 73 167 nfet_01v8 L=150000U W=140000U AS=16800000000P
+ AD=21875000000P PS=380000U PD=460000U
* device instance $5054 r0 *1 52.46,25.95 nfet_01v8
M$5054 1149 145 76 167 nfet_01v8 L=150000U W=140000U AS=16800000000P
+ AD=21875000000P PS=380000U PD=460000U
* device instance $5055 r0 *1 51.905,26.35 nfet_01v8
M$5055 167 2867 3481 167 nfet_01v8 L=150000U W=210000U AS=21875000000P
+ AD=40400000000P PS=460000U PD=560000U
* device instance $5056 r0 *1 52.495,26.35 nfet_01v8
M$5056 167 1707 1149 167 nfet_01v8 L=150000U W=210000U AS=21875000000P
+ AD=40400000000P PS=460000U PD=560000U
* device instance $5057 r0 *1 51.905,26.74 nfet_01v8
M$5057 2867 3481 167 167 nfet_01v8 L=150000U W=210000U AS=40400000000P
+ AD=21875000000P PS=560000U PD=460000U
* device instance $5058 r0 *1 52.495,26.74 nfet_01v8
M$5058 1707 1149 167 167 nfet_01v8 L=150000U W=210000U AS=40400000000P
+ AD=21875000000P PS=560000U PD=460000U
* device instance $5059 r0 *1 51.94,27.14 nfet_01v8
M$5059 74 145 2867 167 nfet_01v8 L=150000U W=140000U AS=21875000000P
+ AD=16800000000P PS=460000U PD=380000U
* device instance $5060 r0 *1 52.46,27.14 nfet_01v8
M$5060 75 145 1707 167 nfet_01v8 L=150000U W=140000U AS=21875000000P
+ AD=16800000000P PS=460000U PD=380000U
* device instance $5061 r0 *1 62.84,21.21 nfet_01v8
M$5061 2345 142 90 167 nfet_01v8 L=150000U W=140000U AS=16800000000P
+ AD=21875000000P PS=380000U PD=460000U
* device instance $5062 r0 *1 63.36,21.21 nfet_01v8
M$5062 1131 142 91 167 nfet_01v8 L=150000U W=140000U AS=16800000000P
+ AD=21875000000P PS=380000U PD=460000U
* device instance $5063 r0 *1 62.805,21.61 nfet_01v8
M$5063 167 2716 2345 167 nfet_01v8 L=150000U W=210000U AS=21875000000P
+ AD=40400000000P PS=460000U PD=560000U
* device instance $5064 r0 *1 63.395,21.61 nfet_01v8
M$5064 167 1687 1131 167 nfet_01v8 L=150000U W=210000U AS=21875000000P
+ AD=40400000000P PS=460000U PD=560000U
* device instance $5065 r0 *1 62.805,22 nfet_01v8
M$5065 2716 2345 167 167 nfet_01v8 L=150000U W=210000U AS=40400000000P
+ AD=21875000000P PS=560000U PD=460000U
* device instance $5066 r0 *1 63.395,22 nfet_01v8
M$5066 1687 1131 167 167 nfet_01v8 L=150000U W=210000U AS=40400000000P
+ AD=21875000000P PS=560000U PD=460000U
* device instance $5067 r0 *1 62.84,22.4 nfet_01v8
M$5067 89 142 2716 167 nfet_01v8 L=150000U W=140000U AS=21875000000P
+ AD=16800000000P PS=460000U PD=380000U
* device instance $5068 r0 *1 63.36,22.4 nfet_01v8
M$5068 92 142 1687 167 nfet_01v8 L=150000U W=140000U AS=21875000000P
+ AD=16800000000P PS=460000U PD=380000U
* device instance $5069 r0 *1 62.84,22.79 nfet_01v8
M$5069 3455 143 89 167 nfet_01v8 L=150000U W=140000U AS=16800000000P
+ AD=21875000000P PS=380000U PD=460000U
* device instance $5070 r0 *1 63.36,22.79 nfet_01v8
M$5070 4378 143 92 167 nfet_01v8 L=150000U W=140000U AS=16800000000P
+ AD=21875000000P PS=380000U PD=460000U
* device instance $5071 r0 *1 62.805,23.19 nfet_01v8
M$5071 167 2718 3455 167 nfet_01v8 L=150000U W=210000U AS=21875000000P
+ AD=40400000000P PS=460000U PD=560000U
* device instance $5072 r0 *1 63.395,23.19 nfet_01v8
M$5072 167 759 4378 167 nfet_01v8 L=150000U W=210000U AS=21875000000P
+ AD=40400000000P PS=460000U PD=560000U
* device instance $5073 r0 *1 62.805,23.58 nfet_01v8
M$5073 2718 3455 167 167 nfet_01v8 L=150000U W=210000U AS=40400000000P
+ AD=21875000000P PS=560000U PD=460000U
* device instance $5074 r0 *1 63.395,23.58 nfet_01v8
M$5074 759 4378 167 167 nfet_01v8 L=150000U W=210000U AS=40400000000P
+ AD=21875000000P PS=560000U PD=460000U
* device instance $5075 r0 *1 62.84,23.98 nfet_01v8
M$5075 90 143 2718 167 nfet_01v8 L=150000U W=140000U AS=21875000000P
+ AD=16800000000P PS=460000U PD=380000U
* device instance $5076 r0 *1 63.36,23.98 nfet_01v8
M$5076 91 143 759 167 nfet_01v8 L=150000U W=140000U AS=21875000000P
+ AD=16800000000P PS=460000U PD=380000U
* device instance $5077 r0 *1 62.84,24.37 nfet_01v8
M$5077 2356 144 90 167 nfet_01v8 L=150000U W=140000U AS=16800000000P
+ AD=21875000000P PS=380000U PD=460000U
* device instance $5078 r0 *1 63.36,24.37 nfet_01v8
M$5078 618 144 91 167 nfet_01v8 L=150000U W=140000U AS=16800000000P
+ AD=21875000000P PS=380000U PD=460000U
* device instance $5079 r0 *1 62.805,24.77 nfet_01v8
M$5079 167 2740 2356 167 nfet_01v8 L=150000U W=210000U AS=21875000000P
+ AD=40400000000P PS=460000U PD=560000U
* device instance $5080 r0 *1 63.395,24.77 nfet_01v8
M$5080 167 758 618 167 nfet_01v8 L=150000U W=210000U AS=21875000000P
+ AD=40400000000P PS=460000U PD=560000U
* device instance $5081 r0 *1 62.805,25.16 nfet_01v8
M$5081 2740 2356 167 167 nfet_01v8 L=150000U W=210000U AS=40400000000P
+ AD=21875000000P PS=560000U PD=460000U
* device instance $5082 r0 *1 63.395,25.16 nfet_01v8
M$5082 758 618 167 167 nfet_01v8 L=150000U W=210000U AS=40400000000P
+ AD=21875000000P PS=560000U PD=460000U
* device instance $5083 r0 *1 62.84,25.56 nfet_01v8
M$5083 89 144 2740 167 nfet_01v8 L=150000U W=140000U AS=21875000000P
+ AD=16800000000P PS=460000U PD=380000U
* device instance $5084 r0 *1 63.36,25.56 nfet_01v8
M$5084 92 144 758 167 nfet_01v8 L=150000U W=140000U AS=21875000000P
+ AD=16800000000P PS=460000U PD=380000U
* device instance $5085 r0 *1 62.84,25.95 nfet_01v8
M$5085 2358 145 89 167 nfet_01v8 L=150000U W=140000U AS=16800000000P
+ AD=21875000000P PS=380000U PD=460000U
* device instance $5086 r0 *1 63.36,25.95 nfet_01v8
M$5086 1133 145 92 167 nfet_01v8 L=150000U W=140000U AS=16800000000P
+ AD=21875000000P PS=380000U PD=460000U
* device instance $5087 r0 *1 62.805,26.35 nfet_01v8
M$5087 167 2746 2358 167 nfet_01v8 L=150000U W=210000U AS=21875000000P
+ AD=40400000000P PS=460000U PD=560000U
* device instance $5088 r0 *1 63.395,26.35 nfet_01v8
M$5088 167 1689 1133 167 nfet_01v8 L=150000U W=210000U AS=21875000000P
+ AD=40400000000P PS=460000U PD=560000U
* device instance $5089 r0 *1 62.805,26.74 nfet_01v8
M$5089 2746 2358 167 167 nfet_01v8 L=150000U W=210000U AS=40400000000P
+ AD=21875000000P PS=560000U PD=460000U
* device instance $5090 r0 *1 63.395,26.74 nfet_01v8
M$5090 1689 1133 167 167 nfet_01v8 L=150000U W=210000U AS=40400000000P
+ AD=21875000000P PS=560000U PD=460000U
* device instance $5091 r0 *1 62.84,27.14 nfet_01v8
M$5091 90 145 2746 167 nfet_01v8 L=150000U W=140000U AS=21875000000P
+ AD=16800000000P PS=460000U PD=380000U
* device instance $5092 r0 *1 63.36,27.14 nfet_01v8
M$5092 91 145 1689 167 nfet_01v8 L=150000U W=140000U AS=21875000000P
+ AD=16800000000P PS=460000U PD=380000U
* device instance $5093 r0 *1 73.74,21.21 nfet_01v8
M$5093 3442 142 106 167 nfet_01v8 L=150000U W=140000U AS=16800000000P
+ AD=21875000000P PS=380000U PD=460000U
* device instance $5094 r0 *1 74.26,21.21 nfet_01v8
M$5094 984 142 107 167 nfet_01v8 L=150000U W=140000U AS=16800000000P
+ AD=21875000000P PS=380000U PD=460000U
* device instance $5095 r0 *1 73.705,21.61 nfet_01v8
M$5095 167 2856 3442 167 nfet_01v8 L=150000U W=210000U AS=21875000000P
+ AD=40400000000P PS=460000U PD=560000U
* device instance $5096 r0 *1 74.295,21.61 nfet_01v8
M$5096 167 1517 984 167 nfet_01v8 L=150000U W=210000U AS=21875000000P
+ AD=40400000000P PS=460000U PD=560000U
* device instance $5097 r0 *1 73.705,22 nfet_01v8
M$5097 2856 3442 167 167 nfet_01v8 L=150000U W=210000U AS=40400000000P
+ AD=21875000000P PS=560000U PD=460000U
* device instance $5098 r0 *1 74.295,22 nfet_01v8
M$5098 1517 984 167 167 nfet_01v8 L=150000U W=210000U AS=40400000000P
+ AD=21875000000P PS=560000U PD=460000U
* device instance $5099 r0 *1 73.74,22.4 nfet_01v8
M$5099 105 142 2856 167 nfet_01v8 L=150000U W=140000U AS=21875000000P
+ AD=16800000000P PS=460000U PD=380000U
* device instance $5100 r0 *1 74.26,22.4 nfet_01v8
M$5100 108 142 1517 167 nfet_01v8 L=150000U W=140000U AS=21875000000P
+ AD=16800000000P PS=460000U PD=380000U
* device instance $5101 r0 *1 73.74,22.79 nfet_01v8
M$5101 3441 143 105 167 nfet_01v8 L=150000U W=140000U AS=16800000000P
+ AD=21875000000P PS=380000U PD=460000U
* device instance $5102 r0 *1 74.26,22.79 nfet_01v8
M$5102 4286 143 108 167 nfet_01v8 L=150000U W=140000U AS=16800000000P
+ AD=21875000000P PS=380000U PD=460000U
* device instance $5103 r0 *1 73.705,23.19 nfet_01v8
M$5103 167 2180 3441 167 nfet_01v8 L=150000U W=210000U AS=21875000000P
+ AD=40400000000P PS=460000U PD=560000U
* device instance $5104 r0 *1 74.295,23.19 nfet_01v8
M$5104 167 1474 4286 167 nfet_01v8 L=150000U W=210000U AS=21875000000P
+ AD=40400000000P PS=460000U PD=560000U
* device instance $5105 r0 *1 73.705,23.58 nfet_01v8
M$5105 2180 3441 167 167 nfet_01v8 L=150000U W=210000U AS=40400000000P
+ AD=21875000000P PS=560000U PD=460000U
* device instance $5106 r0 *1 74.295,23.58 nfet_01v8
M$5106 1474 4286 167 167 nfet_01v8 L=150000U W=210000U AS=40400000000P
+ AD=21875000000P PS=560000U PD=460000U
* device instance $5107 r0 *1 73.74,23.98 nfet_01v8
M$5107 106 143 2180 167 nfet_01v8 L=150000U W=140000U AS=21875000000P
+ AD=16800000000P PS=460000U PD=380000U
* device instance $5108 r0 *1 74.26,23.98 nfet_01v8
M$5108 107 143 1474 167 nfet_01v8 L=150000U W=140000U AS=21875000000P
+ AD=16800000000P PS=460000U PD=380000U
* device instance $5109 r0 *1 73.74,24.37 nfet_01v8
M$5109 2089 144 106 167 nfet_01v8 L=150000U W=140000U AS=16800000000P
+ AD=21875000000P PS=380000U PD=460000U
* device instance $5110 r0 *1 74.26,24.37 nfet_01v8
M$5110 632 144 107 167 nfet_01v8 L=150000U W=140000U AS=16800000000P
+ AD=21875000000P PS=380000U PD=460000U
* device instance $5111 r0 *1 73.705,24.77 nfet_01v8
M$5111 167 2178 2089 167 nfet_01v8 L=150000U W=210000U AS=21875000000P
+ AD=40400000000P PS=460000U PD=560000U
* device instance $5112 r0 *1 74.295,24.77 nfet_01v8
M$5112 167 783 632 167 nfet_01v8 L=150000U W=210000U AS=21875000000P
+ AD=40400000000P PS=460000U PD=560000U
* device instance $5113 r0 *1 73.705,25.16 nfet_01v8
M$5113 2178 2089 167 167 nfet_01v8 L=150000U W=210000U AS=40400000000P
+ AD=21875000000P PS=560000U PD=460000U
* device instance $5114 r0 *1 74.295,25.16 nfet_01v8
M$5114 783 632 167 167 nfet_01v8 L=150000U W=210000U AS=40400000000P
+ AD=21875000000P PS=560000U PD=460000U
* device instance $5115 r0 *1 73.74,25.56 nfet_01v8
M$5115 105 144 2178 167 nfet_01v8 L=150000U W=140000U AS=21875000000P
+ AD=16800000000P PS=460000U PD=380000U
* device instance $5116 r0 *1 74.26,25.56 nfet_01v8
M$5116 108 144 783 167 nfet_01v8 L=150000U W=140000U AS=21875000000P
+ AD=16800000000P PS=460000U PD=380000U
* device instance $5117 r0 *1 73.74,25.95 nfet_01v8
M$5117 3439 145 105 167 nfet_01v8 L=150000U W=140000U AS=16800000000P
+ AD=21875000000P PS=380000U PD=460000U
* device instance $5118 r0 *1 74.26,25.95 nfet_01v8
M$5118 982 145 108 167 nfet_01v8 L=150000U W=140000U AS=16800000000P
+ AD=21875000000P PS=380000U PD=460000U
* device instance $5119 r0 *1 73.705,26.35 nfet_01v8
M$5119 167 2819 3439 167 nfet_01v8 L=150000U W=210000U AS=21875000000P
+ AD=40400000000P PS=460000U PD=560000U
* device instance $5120 r0 *1 74.295,26.35 nfet_01v8
M$5120 167 1515 982 167 nfet_01v8 L=150000U W=210000U AS=21875000000P
+ AD=40400000000P PS=460000U PD=560000U
* device instance $5121 r0 *1 73.705,26.74 nfet_01v8
M$5121 2819 3439 167 167 nfet_01v8 L=150000U W=210000U AS=40400000000P
+ AD=21875000000P PS=560000U PD=460000U
* device instance $5122 r0 *1 74.295,26.74 nfet_01v8
M$5122 1515 982 167 167 nfet_01v8 L=150000U W=210000U AS=40400000000P
+ AD=21875000000P PS=560000U PD=460000U
* device instance $5123 r0 *1 73.74,27.14 nfet_01v8
M$5123 106 145 2819 167 nfet_01v8 L=150000U W=140000U AS=21875000000P
+ AD=16800000000P PS=460000U PD=380000U
* device instance $5124 r0 *1 74.26,27.14 nfet_01v8
M$5124 107 145 1515 167 nfet_01v8 L=150000U W=140000U AS=21875000000P
+ AD=16800000000P PS=460000U PD=380000U
* device instance $5125 r0 *1 8.34,13.31 nfet_01v8
M$5125 3211 138 10 167 nfet_01v8 L=150000U W=140000U AS=16800000000P
+ AD=21875000000P PS=380000U PD=460000U
* device instance $5126 r0 *1 8.86,13.31 nfet_01v8
M$5126 1019 138 11 167 nfet_01v8 L=150000U W=140000U AS=16800000000P
+ AD=21875000000P PS=380000U PD=460000U
* device instance $5127 r0 *1 8.305,13.71 nfet_01v8
M$5127 167 3082 3211 167 nfet_01v8 L=150000U W=210000U AS=21875000000P
+ AD=40400000000P PS=460000U PD=560000U
* device instance $5128 r0 *1 8.895,13.71 nfet_01v8
M$5128 167 1554 1019 167 nfet_01v8 L=150000U W=210000U AS=21875000000P
+ AD=40400000000P PS=460000U PD=560000U
* device instance $5129 r0 *1 8.305,14.1 nfet_01v8
M$5129 3082 3211 167 167 nfet_01v8 L=150000U W=210000U AS=40400000000P
+ AD=21875000000P PS=560000U PD=460000U
* device instance $5130 r0 *1 8.895,14.1 nfet_01v8
M$5130 1554 1019 167 167 nfet_01v8 L=150000U W=210000U AS=40400000000P
+ AD=21875000000P PS=560000U PD=460000U
* device instance $5131 r0 *1 8.34,14.5 nfet_01v8
M$5131 9 138 3082 167 nfet_01v8 L=150000U W=140000U AS=21875000000P
+ AD=16800000000P PS=460000U PD=380000U
* device instance $5132 r0 *1 8.86,14.5 nfet_01v8
M$5132 12 138 1554 167 nfet_01v8 L=150000U W=140000U AS=21875000000P
+ AD=16800000000P PS=460000U PD=380000U
* device instance $5133 r0 *1 8.34,14.89 nfet_01v8
M$5133 3307 139 9 167 nfet_01v8 L=150000U W=140000U AS=16800000000P
+ AD=21875000000P PS=380000U PD=460000U
* device instance $5134 r0 *1 8.86,14.89 nfet_01v8
M$5134 4475 139 12 167 nfet_01v8 L=150000U W=140000U AS=16800000000P
+ AD=21875000000P PS=380000U PD=460000U
* device instance $5135 r0 *1 8.305,15.29 nfet_01v8
M$5135 167 2268 3307 167 nfet_01v8 L=150000U W=210000U AS=21875000000P
+ AD=40400000000P PS=460000U PD=560000U
* device instance $5136 r0 *1 8.895,15.29 nfet_01v8
M$5136 167 791 4475 167 nfet_01v8 L=150000U W=210000U AS=21875000000P
+ AD=40400000000P PS=460000U PD=560000U
* device instance $5137 r0 *1 8.305,15.68 nfet_01v8
M$5137 2268 3307 167 167 nfet_01v8 L=150000U W=210000U AS=40400000000P
+ AD=21875000000P PS=560000U PD=460000U
* device instance $5138 r0 *1 8.895,15.68 nfet_01v8
M$5138 791 4475 167 167 nfet_01v8 L=150000U W=210000U AS=40400000000P
+ AD=21875000000P PS=560000U PD=460000U
* device instance $5139 r0 *1 8.34,16.08 nfet_01v8
M$5139 10 139 2268 167 nfet_01v8 L=150000U W=140000U AS=21875000000P
+ AD=16800000000P PS=460000U PD=380000U
* device instance $5140 r0 *1 8.86,16.08 nfet_01v8
M$5140 11 139 791 167 nfet_01v8 L=150000U W=140000U AS=21875000000P
+ AD=16800000000P PS=460000U PD=380000U
* device instance $5141 r0 *1 8.34,16.47 nfet_01v8
M$5141 2361 140 10 167 nfet_01v8 L=150000U W=140000U AS=16800000000P
+ AD=21875000000P PS=380000U PD=460000U
* device instance $5142 r0 *1 8.86,16.47 nfet_01v8
M$5142 644 140 11 167 nfet_01v8 L=150000U W=140000U AS=16800000000P
+ AD=21875000000P PS=380000U PD=460000U
* device instance $5143 r0 *1 8.305,16.87 nfet_01v8
M$5143 167 2750 2361 167 nfet_01v8 L=150000U W=210000U AS=21875000000P
+ AD=40400000000P PS=460000U PD=560000U
* device instance $5144 r0 *1 8.895,16.87 nfet_01v8
M$5144 167 804 644 167 nfet_01v8 L=150000U W=210000U AS=21875000000P
+ AD=40400000000P PS=460000U PD=560000U
* device instance $5145 r0 *1 8.305,17.26 nfet_01v8
M$5145 2750 2361 167 167 nfet_01v8 L=150000U W=210000U AS=40400000000P
+ AD=21875000000P PS=560000U PD=460000U
* device instance $5146 r0 *1 8.895,17.26 nfet_01v8
M$5146 804 644 167 167 nfet_01v8 L=150000U W=210000U AS=40400000000P
+ AD=21875000000P PS=560000U PD=460000U
* device instance $5147 r0 *1 8.34,17.66 nfet_01v8
M$5147 9 140 2750 167 nfet_01v8 L=150000U W=140000U AS=21875000000P
+ AD=16800000000P PS=460000U PD=380000U
* device instance $5148 r0 *1 8.86,17.66 nfet_01v8
M$5148 12 140 804 167 nfet_01v8 L=150000U W=140000U AS=21875000000P
+ AD=16800000000P PS=460000U PD=380000U
* device instance $5149 r0 *1 8.34,18.05 nfet_01v8
M$5149 3265 141 9 167 nfet_01v8 L=150000U W=140000U AS=16800000000P
+ AD=21875000000P PS=380000U PD=460000U
* device instance $5150 r0 *1 8.86,18.05 nfet_01v8
M$5150 1323 141 12 167 nfet_01v8 L=150000U W=140000U AS=16800000000P
+ AD=21875000000P PS=380000U PD=460000U
* device instance $5151 r0 *1 8.305,18.45 nfet_01v8
M$5151 167 2771 3265 167 nfet_01v8 L=150000U W=210000U AS=21875000000P
+ AD=40400000000P PS=460000U PD=560000U
* device instance $5152 r0 *1 8.895,18.45 nfet_01v8
M$5152 167 1904 1323 167 nfet_01v8 L=150000U W=210000U AS=21875000000P
+ AD=40400000000P PS=460000U PD=560000U
* device instance $5153 r0 *1 8.305,18.84 nfet_01v8
M$5153 2771 3265 167 167 nfet_01v8 L=150000U W=210000U AS=40400000000P
+ AD=21875000000P PS=560000U PD=460000U
* device instance $5154 r0 *1 8.895,18.84 nfet_01v8
M$5154 1904 1323 167 167 nfet_01v8 L=150000U W=210000U AS=40400000000P
+ AD=21875000000P PS=560000U PD=460000U
* device instance $5155 r0 *1 8.34,19.24 nfet_01v8
M$5155 10 141 2771 167 nfet_01v8 L=150000U W=140000U AS=21875000000P
+ AD=16800000000P PS=460000U PD=380000U
* device instance $5156 r0 *1 8.86,19.24 nfet_01v8
M$5156 11 141 1904 167 nfet_01v8 L=150000U W=140000U AS=21875000000P
+ AD=16800000000P PS=460000U PD=380000U
* device instance $5157 r0 *1 84.64,21.21 nfet_01v8
M$5157 2423 142 122 167 nfet_01v8 L=150000U W=140000U AS=16800000000P
+ AD=21875000000P PS=380000U PD=460000U
* device instance $5158 r0 *1 85.16,21.21 nfet_01v8
M$5158 988 142 123 167 nfet_01v8 L=150000U W=140000U AS=16800000000P
+ AD=21875000000P PS=380000U PD=460000U
* device instance $5159 r0 *1 84.605,21.61 nfet_01v8
M$5159 167 2858 2423 167 nfet_01v8 L=150000U W=210000U AS=21875000000P
+ AD=40400000000P PS=460000U PD=560000U
* device instance $5160 r0 *1 85.195,21.61 nfet_01v8
M$5160 167 1522 988 167 nfet_01v8 L=150000U W=210000U AS=21875000000P
+ AD=40400000000P PS=460000U PD=560000U
* device instance $5161 r0 *1 84.605,22 nfet_01v8
M$5161 2858 2423 167 167 nfet_01v8 L=150000U W=210000U AS=40400000000P
+ AD=21875000000P PS=560000U PD=460000U
* device instance $5162 r0 *1 85.195,22 nfet_01v8
M$5162 1522 988 167 167 nfet_01v8 L=150000U W=210000U AS=40400000000P
+ AD=21875000000P PS=560000U PD=460000U
* device instance $5163 r0 *1 84.64,22.4 nfet_01v8
M$5163 121 142 2858 167 nfet_01v8 L=150000U W=140000U AS=21875000000P
+ AD=16800000000P PS=460000U PD=380000U
* device instance $5164 r0 *1 85.16,22.4 nfet_01v8
M$5164 124 142 1522 167 nfet_01v8 L=150000U W=140000U AS=21875000000P
+ AD=16800000000P PS=460000U PD=380000U
* device instance $5165 r0 *1 84.64,22.79 nfet_01v8
M$5165 3415 143 121 167 nfet_01v8 L=150000U W=140000U AS=16800000000P
+ AD=21875000000P PS=380000U PD=460000U
* device instance $5166 r0 *1 85.16,22.79 nfet_01v8
M$5166 4367 143 124 167 nfet_01v8 L=150000U W=140000U AS=16800000000P
+ AD=21875000000P PS=380000U PD=460000U
* device instance $5167 r0 *1 84.605,23.19 nfet_01v8
M$5167 167 2863 3415 167 nfet_01v8 L=150000U W=210000U AS=21875000000P
+ AD=40400000000P PS=460000U PD=560000U
* device instance $5168 r0 *1 85.195,23.19 nfet_01v8
M$5168 167 1520 4367 167 nfet_01v8 L=150000U W=210000U AS=21875000000P
+ AD=40400000000P PS=460000U PD=560000U
* device instance $5169 r0 *1 84.605,23.58 nfet_01v8
M$5169 2863 3415 167 167 nfet_01v8 L=150000U W=210000U AS=40400000000P
+ AD=21875000000P PS=560000U PD=460000U
* device instance $5170 r0 *1 85.195,23.58 nfet_01v8
M$5170 1520 4367 167 167 nfet_01v8 L=150000U W=210000U AS=40400000000P
+ AD=21875000000P PS=560000U PD=460000U
* device instance $5171 r0 *1 84.64,23.98 nfet_01v8
M$5171 122 143 2863 167 nfet_01v8 L=150000U W=140000U AS=21875000000P
+ AD=16800000000P PS=460000U PD=380000U
* device instance $5172 r0 *1 85.16,23.98 nfet_01v8
M$5172 123 143 1520 167 nfet_01v8 L=150000U W=140000U AS=21875000000P
+ AD=16800000000P PS=460000U PD=380000U
* device instance $5173 r0 *1 84.64,24.37 nfet_01v8
M$5173 3412 144 122 167 nfet_01v8 L=150000U W=140000U AS=16800000000P
+ AD=21875000000P PS=380000U PD=460000U
* device instance $5174 r0 *1 85.16,24.37 nfet_01v8
M$5174 637 144 123 167 nfet_01v8 L=150000U W=140000U AS=16800000000P
+ AD=21875000000P PS=380000U PD=460000U
* device instance $5175 r0 *1 84.605,24.77 nfet_01v8
M$5175 167 2171 3412 167 nfet_01v8 L=150000U W=210000U AS=21875000000P
+ AD=40400000000P PS=460000U PD=560000U
* device instance $5176 r0 *1 85.195,24.77 nfet_01v8
M$5176 167 790 637 167 nfet_01v8 L=150000U W=210000U AS=21875000000P
+ AD=40400000000P PS=460000U PD=560000U
* device instance $5177 r0 *1 84.605,25.16 nfet_01v8
M$5177 2171 3412 167 167 nfet_01v8 L=150000U W=210000U AS=40400000000P
+ AD=21875000000P PS=560000U PD=460000U
* device instance $5178 r0 *1 85.195,25.16 nfet_01v8
M$5178 790 637 167 167 nfet_01v8 L=150000U W=210000U AS=40400000000P
+ AD=21875000000P PS=560000U PD=460000U
* device instance $5179 r0 *1 84.64,25.56 nfet_01v8
M$5179 121 144 2171 167 nfet_01v8 L=150000U W=140000U AS=21875000000P
+ AD=16800000000P PS=460000U PD=380000U
* device instance $5180 r0 *1 85.16,25.56 nfet_01v8
M$5180 124 144 790 167 nfet_01v8 L=150000U W=140000U AS=21875000000P
+ AD=16800000000P PS=460000U PD=380000U
* device instance $5181 r0 *1 84.64,25.95 nfet_01v8
M$5181 3413 145 121 167 nfet_01v8 L=150000U W=140000U AS=16800000000P
+ AD=21875000000P PS=380000U PD=460000U
* device instance $5182 r0 *1 85.16,25.95 nfet_01v8
M$5182 993 145 124 167 nfet_01v8 L=150000U W=140000U AS=16800000000P
+ AD=21875000000P PS=380000U PD=460000U
* device instance $5183 r0 *1 84.605,26.35 nfet_01v8
M$5183 167 2864 3413 167 nfet_01v8 L=150000U W=210000U AS=21875000000P
+ AD=40400000000P PS=460000U PD=560000U
* device instance $5184 r0 *1 85.195,26.35 nfet_01v8
M$5184 167 1528 993 167 nfet_01v8 L=150000U W=210000U AS=21875000000P
+ AD=40400000000P PS=460000U PD=560000U
* device instance $5185 r0 *1 84.605,26.74 nfet_01v8
M$5185 2864 3413 167 167 nfet_01v8 L=150000U W=210000U AS=40400000000P
+ AD=21875000000P PS=560000U PD=460000U
* device instance $5186 r0 *1 85.195,26.74 nfet_01v8
M$5186 1528 993 167 167 nfet_01v8 L=150000U W=210000U AS=40400000000P
+ AD=21875000000P PS=560000U PD=460000U
* device instance $5187 r0 *1 84.64,27.14 nfet_01v8
M$5187 122 145 2864 167 nfet_01v8 L=150000U W=140000U AS=21875000000P
+ AD=16800000000P PS=460000U PD=380000U
* device instance $5188 r0 *1 85.16,27.14 nfet_01v8
M$5188 123 145 1528 167 nfet_01v8 L=150000U W=140000U AS=21875000000P
+ AD=16800000000P PS=460000U PD=380000U
* device instance $5189 r0 *1 32.54,60.71 nfet_01v8
M$5189 2305 162 46 167 nfet_01v8 L=150000U W=140000U AS=16800000000P
+ AD=21875000000P PS=380000U PD=460000U
* device instance $5190 r0 *1 33.06,60.71 nfet_01v8
M$5190 903 162 47 167 nfet_01v8 L=150000U W=140000U AS=16800000000P
+ AD=21875000000P PS=380000U PD=460000U
* device instance $5191 r0 *1 32.505,61.11 nfet_01v8
M$5191 167 2624 2305 167 nfet_01v8 L=150000U W=210000U AS=21875000000P
+ AD=40400000000P PS=460000U PD=560000U
* device instance $5192 r0 *1 33.095,61.11 nfet_01v8
M$5192 167 1420 903 167 nfet_01v8 L=150000U W=210000U AS=21875000000P
+ AD=40400000000P PS=460000U PD=560000U
* device instance $5193 r0 *1 32.505,61.5 nfet_01v8
M$5193 2624 2305 167 167 nfet_01v8 L=150000U W=210000U AS=40400000000P
+ AD=21875000000P PS=560000U PD=460000U
* device instance $5194 r0 *1 33.095,61.5 nfet_01v8
M$5194 1420 903 167 167 nfet_01v8 L=150000U W=210000U AS=40400000000P
+ AD=21875000000P PS=560000U PD=460000U
* device instance $5195 r0 *1 32.54,61.9 nfet_01v8
M$5195 45 162 2624 167 nfet_01v8 L=150000U W=140000U AS=21875000000P
+ AD=16800000000P PS=460000U PD=380000U
* device instance $5196 r0 *1 33.06,61.9 nfet_01v8
M$5196 48 162 1420 167 nfet_01v8 L=150000U W=140000U AS=21875000000P
+ AD=16800000000P PS=460000U PD=380000U
* device instance $5197 r0 *1 32.54,62.29 nfet_01v8
M$5197 3546 163 45 167 nfet_01v8 L=150000U W=140000U AS=16800000000P
+ AD=21875000000P PS=380000U PD=460000U
* device instance $5198 r0 *1 33.06,62.29 nfet_01v8
M$5198 4469 163 48 167 nfet_01v8 L=150000U W=140000U AS=16800000000P
+ AD=21875000000P PS=380000U PD=460000U
* device instance $5199 r0 *1 32.505,62.69 nfet_01v8
M$5199 167 2672 3546 167 nfet_01v8 L=150000U W=210000U AS=21875000000P
+ AD=40400000000P PS=460000U PD=560000U
* device instance $5200 r0 *1 33.095,62.69 nfet_01v8
M$5200 167 1411 4469 167 nfet_01v8 L=150000U W=210000U AS=21875000000P
+ AD=40400000000P PS=460000U PD=560000U
* device instance $5201 r0 *1 32.505,63.08 nfet_01v8
M$5201 2672 3546 167 167 nfet_01v8 L=150000U W=210000U AS=40400000000P
+ AD=21875000000P PS=560000U PD=460000U
* device instance $5202 r0 *1 33.095,63.08 nfet_01v8
M$5202 1411 4469 167 167 nfet_01v8 L=150000U W=210000U AS=40400000000P
+ AD=21875000000P PS=560000U PD=460000U
* device instance $5203 r0 *1 32.54,63.48 nfet_01v8
M$5203 46 163 2672 167 nfet_01v8 L=150000U W=140000U AS=21875000000P
+ AD=16800000000P PS=460000U PD=380000U
* device instance $5204 r0 *1 33.06,63.48 nfet_01v8
M$5204 47 163 1411 167 nfet_01v8 L=150000U W=140000U AS=21875000000P
+ AD=16800000000P PS=460000U PD=380000U
* device instance $5205 r0 *1 32.54,63.87 nfet_01v8
M$5205 2287 164 46 167 nfet_01v8 L=150000U W=140000U AS=16800000000P
+ AD=21875000000P PS=380000U PD=460000U
* device instance $5206 r0 *1 33.06,63.87 nfet_01v8
M$5206 909 164 47 167 nfet_01v8 L=150000U W=140000U AS=16800000000P
+ AD=21875000000P PS=380000U PD=460000U
* device instance $5207 r0 *1 32.505,64.27 nfet_01v8
M$5207 167 2595 2287 167 nfet_01v8 L=150000U W=210000U AS=21875000000P
+ AD=40400000000P PS=460000U PD=560000U
* device instance $5208 r0 *1 33.095,64.27 nfet_01v8
M$5208 167 1426 909 167 nfet_01v8 L=150000U W=210000U AS=21875000000P
+ AD=40400000000P PS=460000U PD=560000U
* device instance $5209 r0 *1 32.505,64.66 nfet_01v8
M$5209 2595 2287 167 167 nfet_01v8 L=150000U W=210000U AS=40400000000P
+ AD=21875000000P PS=560000U PD=460000U
* device instance $5210 r0 *1 33.095,64.66 nfet_01v8
M$5210 1426 909 167 167 nfet_01v8 L=150000U W=210000U AS=40400000000P
+ AD=21875000000P PS=560000U PD=460000U
* device instance $5211 r0 *1 32.54,65.06 nfet_01v8
M$5211 45 164 2595 167 nfet_01v8 L=150000U W=140000U AS=21875000000P
+ AD=16800000000P PS=460000U PD=380000U
* device instance $5212 r0 *1 33.06,65.06 nfet_01v8
M$5212 48 164 1426 167 nfet_01v8 L=150000U W=140000U AS=21875000000P
+ AD=16800000000P PS=460000U PD=380000U
* device instance $5213 r0 *1 32.54,65.45 nfet_01v8
M$5213 3547 165 45 167 nfet_01v8 L=150000U W=140000U AS=16800000000P
+ AD=21875000000P PS=380000U PD=460000U
* device instance $5214 r0 *1 33.06,65.45 nfet_01v8
M$5214 1365 165 48 167 nfet_01v8 L=150000U W=140000U AS=16800000000P
+ AD=21875000000P PS=380000U PD=460000U
* device instance $5215 r0 *1 32.505,65.85 nfet_01v8
M$5215 167 2565 3547 167 nfet_01v8 L=150000U W=210000U AS=21875000000P
+ AD=40400000000P PS=460000U PD=560000U
* device instance $5216 r0 *1 33.095,65.85 nfet_01v8
M$5216 167 1956 1365 167 nfet_01v8 L=150000U W=210000U AS=21875000000P
+ AD=40400000000P PS=460000U PD=560000U
* device instance $5217 r0 *1 32.505,66.24 nfet_01v8
M$5217 2565 3547 167 167 nfet_01v8 L=150000U W=210000U AS=40400000000P
+ AD=21875000000P PS=560000U PD=460000U
* device instance $5218 r0 *1 33.095,66.24 nfet_01v8
M$5218 1956 1365 167 167 nfet_01v8 L=150000U W=210000U AS=40400000000P
+ AD=21875000000P PS=560000U PD=460000U
* device instance $5219 r0 *1 32.54,66.64 nfet_01v8
M$5219 46 165 2565 167 nfet_01v8 L=150000U W=140000U AS=21875000000P
+ AD=16800000000P PS=460000U PD=380000U
* device instance $5220 r0 *1 33.06,66.64 nfet_01v8
M$5220 47 165 1956 167 nfet_01v8 L=150000U W=140000U AS=21875000000P
+ AD=16800000000P PS=460000U PD=380000U
* device instance $5221 r0 *1 87.04,37.01 nfet_01v8
M$5221 3508 150 126 167 nfet_01v8 L=150000U W=140000U AS=16800000000P
+ AD=21875000000P PS=380000U PD=460000U
* device instance $5222 r0 *1 87.56,37.01 nfet_01v8
M$5222 1205 150 127 167 nfet_01v8 L=150000U W=140000U AS=16800000000P
+ AD=21875000000P PS=380000U PD=460000U
* device instance $5223 r0 *1 87.005,37.41 nfet_01v8
M$5223 167 2677 3508 167 nfet_01v8 L=150000U W=210000U AS=21875000000P
+ AD=40400000000P PS=460000U PD=560000U
* device instance $5224 r0 *1 87.595,37.41 nfet_01v8
M$5224 167 1775 1205 167 nfet_01v8 L=150000U W=210000U AS=21875000000P
+ AD=40400000000P PS=460000U PD=560000U
* device instance $5225 r0 *1 87.005,37.8 nfet_01v8
M$5225 2677 3508 167 167 nfet_01v8 L=150000U W=210000U AS=40400000000P
+ AD=21875000000P PS=560000U PD=460000U
* device instance $5226 r0 *1 87.595,37.8 nfet_01v8
M$5226 1775 1205 167 167 nfet_01v8 L=150000U W=210000U AS=40400000000P
+ AD=21875000000P PS=560000U PD=460000U
* device instance $5227 r0 *1 87.04,38.2 nfet_01v8
M$5227 125 150 2677 167 nfet_01v8 L=150000U W=140000U AS=21875000000P
+ AD=16800000000P PS=460000U PD=380000U
* device instance $5228 r0 *1 87.56,38.2 nfet_01v8
M$5228 128 150 1775 167 nfet_01v8 L=150000U W=140000U AS=21875000000P
+ AD=16800000000P PS=460000U PD=380000U
* device instance $5229 r0 *1 87.04,38.59 nfet_01v8
M$5229 3484 151 125 167 nfet_01v8 L=150000U W=140000U AS=16800000000P
+ AD=21875000000P PS=380000U PD=460000U
* device instance $5230 r0 *1 87.56,38.59 nfet_01v8
M$5230 4416 151 128 167 nfet_01v8 L=150000U W=140000U AS=16800000000P
+ AD=21875000000P PS=380000U PD=460000U
* device instance $5231 r0 *1 87.005,38.99 nfet_01v8
M$5231 167 2228 3484 167 nfet_01v8 L=150000U W=210000U AS=21875000000P
+ AD=40400000000P PS=460000U PD=560000U
* device instance $5232 r0 *1 87.595,38.99 nfet_01v8
M$5232 167 1765 4416 167 nfet_01v8 L=150000U W=210000U AS=21875000000P
+ AD=40400000000P PS=460000U PD=560000U
* device instance $5233 r0 *1 87.005,39.38 nfet_01v8
M$5233 2228 3484 167 167 nfet_01v8 L=150000U W=210000U AS=40400000000P
+ AD=21875000000P PS=560000U PD=460000U
* device instance $5234 r0 *1 87.595,39.38 nfet_01v8
M$5234 1765 4416 167 167 nfet_01v8 L=150000U W=210000U AS=40400000000P
+ AD=21875000000P PS=560000U PD=460000U
* device instance $5235 r0 *1 87.04,39.78 nfet_01v8
M$5235 126 151 2228 167 nfet_01v8 L=150000U W=140000U AS=21875000000P
+ AD=16800000000P PS=460000U PD=380000U
* device instance $5236 r0 *1 87.56,39.78 nfet_01v8
M$5236 127 151 1765 167 nfet_01v8 L=150000U W=140000U AS=21875000000P
+ AD=16800000000P PS=460000U PD=380000U
* device instance $5237 r0 *1 87.04,40.17 nfet_01v8
M$5237 3510 152 126 167 nfet_01v8 L=150000U W=140000U AS=16800000000P
+ AD=21875000000P PS=380000U PD=460000U
* device instance $5238 r0 *1 87.56,40.17 nfet_01v8
M$5238 1214 152 127 167 nfet_01v8 L=150000U W=140000U AS=16800000000P
+ AD=21875000000P PS=380000U PD=460000U
* device instance $5239 r0 *1 87.005,40.57 nfet_01v8
M$5239 167 2638 3510 167 nfet_01v8 L=150000U W=210000U AS=21875000000P
+ AD=40400000000P PS=460000U PD=560000U
* device instance $5240 r0 *1 87.595,40.57 nfet_01v8
M$5240 167 1785 1214 167 nfet_01v8 L=150000U W=210000U AS=21875000000P
+ AD=40400000000P PS=460000U PD=560000U
* device instance $5241 r0 *1 87.005,40.96 nfet_01v8
M$5241 2638 3510 167 167 nfet_01v8 L=150000U W=210000U AS=40400000000P
+ AD=21875000000P PS=560000U PD=460000U
* device instance $5242 r0 *1 87.595,40.96 nfet_01v8
M$5242 1785 1214 167 167 nfet_01v8 L=150000U W=210000U AS=40400000000P
+ AD=21875000000P PS=560000U PD=460000U
* device instance $5243 r0 *1 87.04,41.36 nfet_01v8
M$5243 125 152 2638 167 nfet_01v8 L=150000U W=140000U AS=21875000000P
+ AD=16800000000P PS=460000U PD=380000U
* device instance $5244 r0 *1 87.56,41.36 nfet_01v8
M$5244 128 152 1785 167 nfet_01v8 L=150000U W=140000U AS=21875000000P
+ AD=16800000000P PS=460000U PD=380000U
* device instance $5245 r0 *1 87.04,41.75 nfet_01v8
M$5245 3511 153 125 167 nfet_01v8 L=150000U W=140000U AS=16800000000P
+ AD=21875000000P PS=380000U PD=460000U
* device instance $5246 r0 *1 87.56,41.75 nfet_01v8
M$5246 1206 153 128 167 nfet_01v8 L=150000U W=140000U AS=16800000000P
+ AD=21875000000P PS=380000U PD=460000U
* device instance $5247 r0 *1 87.005,42.15 nfet_01v8
M$5247 167 2667 3511 167 nfet_01v8 L=150000U W=210000U AS=21875000000P
+ AD=40400000000P PS=460000U PD=560000U
* device instance $5248 r0 *1 87.595,42.15 nfet_01v8
M$5248 167 1776 1206 167 nfet_01v8 L=150000U W=210000U AS=21875000000P
+ AD=40400000000P PS=460000U PD=560000U
* device instance $5249 r0 *1 87.005,42.54 nfet_01v8
M$5249 2667 3511 167 167 nfet_01v8 L=150000U W=210000U AS=40400000000P
+ AD=21875000000P PS=560000U PD=460000U
* device instance $5250 r0 *1 87.595,42.54 nfet_01v8
M$5250 1776 1206 167 167 nfet_01v8 L=150000U W=210000U AS=40400000000P
+ AD=21875000000P PS=560000U PD=460000U
* device instance $5251 r0 *1 87.04,42.94 nfet_01v8
M$5251 126 153 2667 167 nfet_01v8 L=150000U W=140000U AS=21875000000P
+ AD=16800000000P PS=460000U PD=380000U
* device instance $5252 r0 *1 87.56,42.94 nfet_01v8
M$5252 127 153 1776 167 nfet_01v8 L=150000U W=140000U AS=21875000000P
+ AD=16800000000P PS=460000U PD=380000U
* device instance $5253 r0 *1 76.14,37.01 nfet_01v8
M$5253 3507 150 110 167 nfet_01v8 L=150000U W=140000U AS=16800000000P
+ AD=21875000000P PS=380000U PD=460000U
* device instance $5254 r0 *1 76.66,37.01 nfet_01v8
M$5254 1355 150 111 167 nfet_01v8 L=150000U W=140000U AS=16800000000P
+ AD=21875000000P PS=380000U PD=460000U
* device instance $5255 r0 *1 76.105,37.41 nfet_01v8
M$5255 167 2602 3507 167 nfet_01v8 L=150000U W=210000U AS=21875000000P
+ AD=40400000000P PS=460000U PD=560000U
* device instance $5256 r0 *1 76.695,37.41 nfet_01v8
M$5256 167 1944 1355 167 nfet_01v8 L=150000U W=210000U AS=21875000000P
+ AD=40400000000P PS=460000U PD=560000U
* device instance $5257 r0 *1 76.105,37.8 nfet_01v8
M$5257 2602 3507 167 167 nfet_01v8 L=150000U W=210000U AS=40400000000P
+ AD=21875000000P PS=560000U PD=460000U
* device instance $5258 r0 *1 76.695,37.8 nfet_01v8
M$5258 1944 1355 167 167 nfet_01v8 L=150000U W=210000U AS=40400000000P
+ AD=21875000000P PS=560000U PD=460000U
* device instance $5259 r0 *1 76.14,38.2 nfet_01v8
M$5259 109 150 2602 167 nfet_01v8 L=150000U W=140000U AS=21875000000P
+ AD=16800000000P PS=460000U PD=380000U
* device instance $5260 r0 *1 76.66,38.2 nfet_01v8
M$5260 112 150 1944 167 nfet_01v8 L=150000U W=140000U AS=21875000000P
+ AD=16800000000P PS=460000U PD=380000U
* device instance $5261 r0 *1 76.14,38.59 nfet_01v8
M$5261 3516 151 109 167 nfet_01v8 L=150000U W=140000U AS=16800000000P
+ AD=21875000000P PS=380000U PD=460000U
* device instance $5262 r0 *1 76.66,38.59 nfet_01v8
M$5262 4515 151 112 167 nfet_01v8 L=150000U W=140000U AS=16800000000P
+ AD=21875000000P PS=380000U PD=460000U
* device instance $5263 r0 *1 76.105,38.99 nfet_01v8
M$5263 167 2606 3516 167 nfet_01v8 L=150000U W=210000U AS=21875000000P
+ AD=40400000000P PS=460000U PD=560000U
* device instance $5264 r0 *1 76.695,38.99 nfet_01v8
M$5264 167 871 4515 167 nfet_01v8 L=150000U W=210000U AS=21875000000P
+ AD=40400000000P PS=460000U PD=560000U
* device instance $5265 r0 *1 76.105,39.38 nfet_01v8
M$5265 2606 3516 167 167 nfet_01v8 L=150000U W=210000U AS=40400000000P
+ AD=21875000000P PS=560000U PD=460000U
* device instance $5266 r0 *1 76.695,39.38 nfet_01v8
M$5266 871 4515 167 167 nfet_01v8 L=150000U W=210000U AS=40400000000P
+ AD=21875000000P PS=560000U PD=460000U
* device instance $5267 r0 *1 76.14,39.78 nfet_01v8
M$5267 110 151 2606 167 nfet_01v8 L=150000U W=140000U AS=21875000000P
+ AD=16800000000P PS=460000U PD=380000U
* device instance $5268 r0 *1 76.66,39.78 nfet_01v8
M$5268 111 151 871 167 nfet_01v8 L=150000U W=140000U AS=21875000000P
+ AD=16800000000P PS=460000U PD=380000U
* device instance $5269 r0 *1 76.14,40.17 nfet_01v8
M$5269 2296 152 110 167 nfet_01v8 L=150000U W=140000U AS=16800000000P
+ AD=21875000000P PS=380000U PD=460000U
* device instance $5270 r0 *1 76.66,40.17 nfet_01v8
M$5270 624 152 111 167 nfet_01v8 L=150000U W=140000U AS=16800000000P
+ AD=21875000000P PS=380000U PD=460000U
* device instance $5271 r0 *1 76.105,40.57 nfet_01v8
M$5271 167 2612 2296 167 nfet_01v8 L=150000U W=210000U AS=21875000000P
+ AD=40400000000P PS=460000U PD=560000U
* device instance $5272 r0 *1 76.695,40.57 nfet_01v8
M$5272 167 768 624 167 nfet_01v8 L=150000U W=210000U AS=21875000000P
+ AD=40400000000P PS=460000U PD=560000U
* device instance $5273 r0 *1 76.105,40.96 nfet_01v8
M$5273 2612 2296 167 167 nfet_01v8 L=150000U W=210000U AS=40400000000P
+ AD=21875000000P PS=560000U PD=460000U
* device instance $5274 r0 *1 76.695,40.96 nfet_01v8
M$5274 768 624 167 167 nfet_01v8 L=150000U W=210000U AS=40400000000P
+ AD=21875000000P PS=560000U PD=460000U
* device instance $5275 r0 *1 76.14,41.36 nfet_01v8
M$5275 109 152 2612 167 nfet_01v8 L=150000U W=140000U AS=21875000000P
+ AD=16800000000P PS=460000U PD=380000U
* device instance $5276 r0 *1 76.66,41.36 nfet_01v8
M$5276 112 152 768 167 nfet_01v8 L=150000U W=140000U AS=21875000000P
+ AD=16800000000P PS=460000U PD=380000U
* device instance $5277 r0 *1 76.14,41.75 nfet_01v8
M$5277 2285 153 109 167 nfet_01v8 L=150000U W=140000U AS=16800000000P
+ AD=21875000000P PS=380000U PD=460000U
* device instance $5278 r0 *1 76.66,41.75 nfet_01v8
M$5278 1297 153 112 167 nfet_01v8 L=150000U W=140000U AS=16800000000P
+ AD=21875000000P PS=380000U PD=460000U
* device instance $5279 r0 *1 76.105,42.15 nfet_01v8
M$5279 167 2592 2285 167 nfet_01v8 L=150000U W=210000U AS=21875000000P
+ AD=40400000000P PS=460000U PD=560000U
* device instance $5280 r0 *1 76.695,42.15 nfet_01v8
M$5280 167 1874 1297 167 nfet_01v8 L=150000U W=210000U AS=21875000000P
+ AD=40400000000P PS=460000U PD=560000U
* device instance $5281 r0 *1 76.105,42.54 nfet_01v8
M$5281 2592 2285 167 167 nfet_01v8 L=150000U W=210000U AS=40400000000P
+ AD=21875000000P PS=560000U PD=460000U
* device instance $5282 r0 *1 76.695,42.54 nfet_01v8
M$5282 1874 1297 167 167 nfet_01v8 L=150000U W=210000U AS=40400000000P
+ AD=21875000000P PS=560000U PD=460000U
* device instance $5283 r0 *1 76.14,42.94 nfet_01v8
M$5283 110 153 2592 167 nfet_01v8 L=150000U W=140000U AS=21875000000P
+ AD=16800000000P PS=460000U PD=380000U
* device instance $5284 r0 *1 76.66,42.94 nfet_01v8
M$5284 111 153 1874 167 nfet_01v8 L=150000U W=140000U AS=21875000000P
+ AD=16800000000P PS=460000U PD=380000U
* device instance $5285 r0 *1 65.24,37.01 nfet_01v8
M$5285 2284 150 94 167 nfet_01v8 L=150000U W=140000U AS=16800000000P
+ AD=21875000000P PS=380000U PD=460000U
* device instance $5286 r0 *1 65.76,37.01 nfet_01v8
M$5286 1029 150 95 167 nfet_01v8 L=150000U W=140000U AS=16800000000P
+ AD=21875000000P PS=380000U PD=460000U
* device instance $5287 r0 *1 65.205,37.41 nfet_01v8
M$5287 167 2590 2284 167 nfet_01v8 L=150000U W=210000U AS=21875000000P
+ AD=40400000000P PS=460000U PD=560000U
* device instance $5288 r0 *1 65.795,37.41 nfet_01v8
M$5288 167 1567 1029 167 nfet_01v8 L=150000U W=210000U AS=21875000000P
+ AD=40400000000P PS=460000U PD=560000U
* device instance $5289 r0 *1 65.205,37.8 nfet_01v8
M$5289 2590 2284 167 167 nfet_01v8 L=150000U W=210000U AS=40400000000P
+ AD=21875000000P PS=560000U PD=460000U
* device instance $5290 r0 *1 65.795,37.8 nfet_01v8
M$5290 1567 1029 167 167 nfet_01v8 L=150000U W=210000U AS=40400000000P
+ AD=21875000000P PS=560000U PD=460000U
* device instance $5291 r0 *1 65.24,38.2 nfet_01v8
M$5291 93 150 2590 167 nfet_01v8 L=150000U W=140000U AS=21875000000P
+ AD=16800000000P PS=460000U PD=380000U
* device instance $5292 r0 *1 65.76,38.2 nfet_01v8
M$5292 96 150 1567 167 nfet_01v8 L=150000U W=140000U AS=21875000000P
+ AD=16800000000P PS=460000U PD=380000U
* device instance $5293 r0 *1 65.24,38.59 nfet_01v8
M$5293 3611 151 93 167 nfet_01v8 L=150000U W=140000U AS=16800000000P
+ AD=21875000000P PS=380000U PD=460000U
* device instance $5294 r0 *1 65.76,38.59 nfet_01v8
M$5294 4285 151 96 167 nfet_01v8 L=150000U W=140000U AS=16800000000P
+ AD=21875000000P PS=380000U PD=460000U
* device instance $5295 r0 *1 65.205,38.99 nfet_01v8
M$5295 167 2033 3611 167 nfet_01v8 L=150000U W=210000U AS=21875000000P
+ AD=40400000000P PS=460000U PD=560000U
* device instance $5296 r0 *1 65.795,38.99 nfet_01v8
M$5296 167 760 4285 167 nfet_01v8 L=150000U W=210000U AS=21875000000P
+ AD=40400000000P PS=460000U PD=560000U
* device instance $5297 r0 *1 65.205,39.38 nfet_01v8
M$5297 2033 3611 167 167 nfet_01v8 L=150000U W=210000U AS=40400000000P
+ AD=21875000000P PS=560000U PD=460000U
* device instance $5298 r0 *1 65.795,39.38 nfet_01v8
M$5298 760 4285 167 167 nfet_01v8 L=150000U W=210000U AS=40400000000P
+ AD=21875000000P PS=560000U PD=460000U
* device instance $5299 r0 *1 65.24,39.78 nfet_01v8
M$5299 94 151 2033 167 nfet_01v8 L=150000U W=140000U AS=21875000000P
+ AD=16800000000P PS=460000U PD=380000U
* device instance $5300 r0 *1 65.76,39.78 nfet_01v8
M$5300 95 151 760 167 nfet_01v8 L=150000U W=140000U AS=21875000000P
+ AD=16800000000P PS=460000U PD=380000U
* device instance $5301 r0 *1 65.24,40.17 nfet_01v8
M$5301 2290 152 94 167 nfet_01v8 L=150000U W=140000U AS=16800000000P
+ AD=21875000000P PS=380000U PD=460000U
* device instance $5302 r0 *1 65.76,40.17 nfet_01v8
M$5302 963 152 95 167 nfet_01v8 L=150000U W=140000U AS=16800000000P
+ AD=21875000000P PS=380000U PD=460000U
* device instance $5303 r0 *1 65.205,40.57 nfet_01v8
M$5303 167 2600 2290 167 nfet_01v8 L=150000U W=210000U AS=21875000000P
+ AD=40400000000P PS=460000U PD=560000U
* device instance $5304 r0 *1 65.795,40.57 nfet_01v8
M$5304 167 1492 963 167 nfet_01v8 L=150000U W=210000U AS=21875000000P
+ AD=40400000000P PS=460000U PD=560000U
* device instance $5305 r0 *1 65.205,40.96 nfet_01v8
M$5305 2600 2290 167 167 nfet_01v8 L=150000U W=210000U AS=40400000000P
+ AD=21875000000P PS=560000U PD=460000U
* device instance $5306 r0 *1 65.795,40.96 nfet_01v8
M$5306 1492 963 167 167 nfet_01v8 L=150000U W=210000U AS=40400000000P
+ AD=21875000000P PS=560000U PD=460000U
* device instance $5307 r0 *1 65.24,41.36 nfet_01v8
M$5307 93 152 2600 167 nfet_01v8 L=150000U W=140000U AS=21875000000P
+ AD=16800000000P PS=460000U PD=380000U
* device instance $5308 r0 *1 65.76,41.36 nfet_01v8
M$5308 96 152 1492 167 nfet_01v8 L=150000U W=140000U AS=21875000000P
+ AD=16800000000P PS=460000U PD=380000U
* device instance $5309 r0 *1 65.24,41.75 nfet_01v8
M$5309 3613 153 93 167 nfet_01v8 L=150000U W=140000U AS=16800000000P
+ AD=21875000000P PS=380000U PD=460000U
* device instance $5310 r0 *1 65.76,41.75 nfet_01v8
M$5310 953 153 96 167 nfet_01v8 L=150000U W=140000U AS=16800000000P
+ AD=21875000000P PS=380000U PD=460000U
* device instance $5311 r0 *1 65.205,42.15 nfet_01v8
M$5311 167 2605 3613 167 nfet_01v8 L=150000U W=210000U AS=21875000000P
+ AD=40400000000P PS=460000U PD=560000U
* device instance $5312 r0 *1 65.795,42.15 nfet_01v8
M$5312 167 1479 953 167 nfet_01v8 L=150000U W=210000U AS=21875000000P
+ AD=40400000000P PS=460000U PD=560000U
* device instance $5313 r0 *1 65.205,42.54 nfet_01v8
M$5313 2605 3613 167 167 nfet_01v8 L=150000U W=210000U AS=40400000000P
+ AD=21875000000P PS=560000U PD=460000U
* device instance $5314 r0 *1 65.795,42.54 nfet_01v8
M$5314 1479 953 167 167 nfet_01v8 L=150000U W=210000U AS=40400000000P
+ AD=21875000000P PS=560000U PD=460000U
* device instance $5315 r0 *1 65.24,42.94 nfet_01v8
M$5315 94 153 2605 167 nfet_01v8 L=150000U W=140000U AS=21875000000P
+ AD=16800000000P PS=460000U PD=380000U
* device instance $5316 r0 *1 65.76,42.94 nfet_01v8
M$5316 95 153 1479 167 nfet_01v8 L=150000U W=140000U AS=21875000000P
+ AD=16800000000P PS=460000U PD=380000U
* device instance $5317 r0 *1 54.34,37.01 nfet_01v8
M$5317 2288 150 78 167 nfet_01v8 L=150000U W=140000U AS=16800000000P
+ AD=21875000000P PS=380000U PD=460000U
* device instance $5318 r0 *1 54.86,37.01 nfet_01v8
M$5318 951 150 79 167 nfet_01v8 L=150000U W=140000U AS=16800000000P
+ AD=21875000000P PS=380000U PD=460000U
* device instance $5319 r0 *1 54.305,37.41 nfet_01v8
M$5319 167 2596 2288 167 nfet_01v8 L=150000U W=210000U AS=21875000000P
+ AD=40400000000P PS=460000U PD=560000U
* device instance $5320 r0 *1 54.895,37.41 nfet_01v8
M$5320 167 1477 951 167 nfet_01v8 L=150000U W=210000U AS=21875000000P
+ AD=40400000000P PS=460000U PD=560000U
* device instance $5321 r0 *1 54.305,37.8 nfet_01v8
M$5321 2596 2288 167 167 nfet_01v8 L=150000U W=210000U AS=40400000000P
+ AD=21875000000P PS=560000U PD=460000U
* device instance $5322 r0 *1 54.895,37.8 nfet_01v8
M$5322 1477 951 167 167 nfet_01v8 L=150000U W=210000U AS=40400000000P
+ AD=21875000000P PS=560000U PD=460000U
* device instance $5323 r0 *1 54.34,38.2 nfet_01v8
M$5323 77 150 2596 167 nfet_01v8 L=150000U W=140000U AS=21875000000P
+ AD=16800000000P PS=460000U PD=380000U
* device instance $5324 r0 *1 54.86,38.2 nfet_01v8
M$5324 80 150 1477 167 nfet_01v8 L=150000U W=140000U AS=21875000000P
+ AD=16800000000P PS=460000U PD=380000U
* device instance $5325 r0 *1 54.34,38.59 nfet_01v8
M$5325 3610 151 77 167 nfet_01v8 L=150000U W=140000U AS=16800000000P
+ AD=21875000000P PS=380000U PD=460000U
* device instance $5326 r0 *1 54.86,38.59 nfet_01v8
M$5326 4296 151 80 167 nfet_01v8 L=150000U W=140000U AS=16800000000P
+ AD=21875000000P PS=380000U PD=460000U
* device instance $5327 r0 *1 54.305,38.99 nfet_01v8
M$5327 167 2025 3610 167 nfet_01v8 L=150000U W=210000U AS=21875000000P
+ AD=40400000000P PS=460000U PD=560000U
* device instance $5328 r0 *1 54.895,38.99 nfet_01v8
M$5328 167 818 4296 167 nfet_01v8 L=150000U W=210000U AS=21875000000P
+ AD=40400000000P PS=460000U PD=560000U
* device instance $5329 r0 *1 54.305,39.38 nfet_01v8
M$5329 2025 3610 167 167 nfet_01v8 L=150000U W=210000U AS=40400000000P
+ AD=21875000000P PS=560000U PD=460000U
* device instance $5330 r0 *1 54.895,39.38 nfet_01v8
M$5330 818 4296 167 167 nfet_01v8 L=150000U W=210000U AS=40400000000P
+ AD=21875000000P PS=560000U PD=460000U
* device instance $5331 r0 *1 54.34,39.78 nfet_01v8
M$5331 78 151 2025 167 nfet_01v8 L=150000U W=140000U AS=21875000000P
+ AD=16800000000P PS=460000U PD=380000U
* device instance $5332 r0 *1 54.86,39.78 nfet_01v8
M$5332 79 151 818 167 nfet_01v8 L=150000U W=140000U AS=21875000000P
+ AD=16800000000P PS=460000U PD=380000U
* device instance $5333 r0 *1 54.34,40.17 nfet_01v8
M$5333 2083 152 78 167 nfet_01v8 L=150000U W=140000U AS=16800000000P
+ AD=21875000000P PS=380000U PD=460000U
* device instance $5334 r0 *1 54.86,40.17 nfet_01v8
M$5334 643 152 79 167 nfet_01v8 L=150000U W=140000U AS=16800000000P
+ AD=21875000000P PS=380000U PD=460000U
* device instance $5335 r0 *1 54.305,40.57 nfet_01v8
M$5335 167 2164 2083 167 nfet_01v8 L=150000U W=210000U AS=21875000000P
+ AD=40400000000P PS=460000U PD=560000U
* device instance $5336 r0 *1 54.895,40.57 nfet_01v8
M$5336 167 803 643 167 nfet_01v8 L=150000U W=210000U AS=21875000000P
+ AD=40400000000P PS=460000U PD=560000U
* device instance $5337 r0 *1 54.305,40.96 nfet_01v8
M$5337 2164 2083 167 167 nfet_01v8 L=150000U W=210000U AS=40400000000P
+ AD=21875000000P PS=560000U PD=460000U
* device instance $5338 r0 *1 54.895,40.96 nfet_01v8
M$5338 803 643 167 167 nfet_01v8 L=150000U W=210000U AS=40400000000P
+ AD=21875000000P PS=560000U PD=460000U
* device instance $5339 r0 *1 54.34,41.36 nfet_01v8
M$5339 77 152 2164 167 nfet_01v8 L=150000U W=140000U AS=21875000000P
+ AD=16800000000P PS=460000U PD=380000U
* device instance $5340 r0 *1 54.86,41.36 nfet_01v8
M$5340 80 152 803 167 nfet_01v8 L=150000U W=140000U AS=21875000000P
+ AD=16800000000P PS=460000U PD=380000U
* device instance $5341 r0 *1 54.34,41.75 nfet_01v8
M$5341 3605 153 77 167 nfet_01v8 L=150000U W=140000U AS=16800000000P
+ AD=21875000000P PS=380000U PD=460000U
* device instance $5342 r0 *1 54.86,41.75 nfet_01v8
M$5342 987 153 80 167 nfet_01v8 L=150000U W=140000U AS=16800000000P
+ AD=21875000000P PS=380000U PD=460000U
* device instance $5343 r0 *1 54.305,42.15 nfet_01v8
M$5343 167 2670 3605 167 nfet_01v8 L=150000U W=210000U AS=21875000000P
+ AD=40400000000P PS=460000U PD=560000U
* device instance $5344 r0 *1 54.895,42.15 nfet_01v8
M$5344 167 1521 987 167 nfet_01v8 L=150000U W=210000U AS=21875000000P
+ AD=40400000000P PS=460000U PD=560000U
* device instance $5345 r0 *1 54.305,42.54 nfet_01v8
M$5345 2670 3605 167 167 nfet_01v8 L=150000U W=210000U AS=40400000000P
+ AD=21875000000P PS=560000U PD=460000U
* device instance $5346 r0 *1 54.895,42.54 nfet_01v8
M$5346 1521 987 167 167 nfet_01v8 L=150000U W=210000U AS=40400000000P
+ AD=21875000000P PS=560000U PD=460000U
* device instance $5347 r0 *1 54.34,42.94 nfet_01v8
M$5347 78 153 2670 167 nfet_01v8 L=150000U W=140000U AS=21875000000P
+ AD=16800000000P PS=460000U PD=380000U
* device instance $5348 r0 *1 54.86,42.94 nfet_01v8
M$5348 79 153 1521 167 nfet_01v8 L=150000U W=140000U AS=21875000000P
+ AD=16800000000P PS=460000U PD=380000U
* device instance $5349 r0 *1 76.14,60.71 nfet_01v8
M$5349 2411 162 110 167 nfet_01v8 L=150000U W=140000U AS=16800000000P
+ AD=21875000000P PS=380000U PD=460000U
* device instance $5350 r0 *1 76.66,60.71 nfet_01v8
M$5350 1374 162 111 167 nfet_01v8 L=150000U W=140000U AS=16800000000P
+ AD=21875000000P PS=380000U PD=460000U
* device instance $5351 r0 *1 76.105,61.11 nfet_01v8
M$5351 167 2834 2411 167 nfet_01v8 L=150000U W=210000U AS=21875000000P
+ AD=40400000000P PS=460000U PD=560000U
* device instance $5352 r0 *1 76.695,61.11 nfet_01v8
M$5352 167 1967 1374 167 nfet_01v8 L=150000U W=210000U AS=21875000000P
+ AD=40400000000P PS=460000U PD=560000U
* device instance $5353 r0 *1 76.105,61.5 nfet_01v8
M$5353 2834 2411 167 167 nfet_01v8 L=150000U W=210000U AS=40400000000P
+ AD=21875000000P PS=560000U PD=460000U
* device instance $5354 r0 *1 76.695,61.5 nfet_01v8
M$5354 1967 1374 167 167 nfet_01v8 L=150000U W=210000U AS=40400000000P
+ AD=21875000000P PS=560000U PD=460000U
* device instance $5355 r0 *1 76.14,61.9 nfet_01v8
M$5355 109 162 2834 167 nfet_01v8 L=150000U W=140000U AS=21875000000P
+ AD=16800000000P PS=460000U PD=380000U
* device instance $5356 r0 *1 76.66,61.9 nfet_01v8
M$5356 112 162 1967 167 nfet_01v8 L=150000U W=140000U AS=21875000000P
+ AD=16800000000P PS=460000U PD=380000U
* device instance $5357 r0 *1 76.14,62.29 nfet_01v8
M$5357 3183 163 109 167 nfet_01v8 L=150000U W=140000U AS=16800000000P
+ AD=21875000000P PS=380000U PD=460000U
* device instance $5358 r0 *1 76.66,62.29 nfet_01v8
M$5358 4487 163 112 167 nfet_01v8 L=150000U W=140000U AS=16800000000P
+ AD=21875000000P PS=380000U PD=460000U
* device instance $5359 r0 *1 76.105,62.69 nfet_01v8
M$5359 167 2263 3183 167 nfet_01v8 L=150000U W=210000U AS=21875000000P
+ AD=40400000000P PS=460000U PD=560000U
* device instance $5360 r0 *1 76.695,62.69 nfet_01v8
M$5360 167 813 4487 167 nfet_01v8 L=150000U W=210000U AS=21875000000P
+ AD=40400000000P PS=460000U PD=560000U
* device instance $5361 r0 *1 76.105,63.08 nfet_01v8
M$5361 2263 3183 167 167 nfet_01v8 L=150000U W=210000U AS=40400000000P
+ AD=21875000000P PS=560000U PD=460000U
* device instance $5362 r0 *1 76.695,63.08 nfet_01v8
M$5362 813 4487 167 167 nfet_01v8 L=150000U W=210000U AS=40400000000P
+ AD=21875000000P PS=560000U PD=460000U
* device instance $5363 r0 *1 76.14,63.48 nfet_01v8
M$5363 110 163 2263 167 nfet_01v8 L=150000U W=140000U AS=21875000000P
+ AD=16800000000P PS=460000U PD=380000U
* device instance $5364 r0 *1 76.66,63.48 nfet_01v8
M$5364 111 163 813 167 nfet_01v8 L=150000U W=140000U AS=21875000000P
+ AD=16800000000P PS=460000U PD=380000U
* device instance $5365 r0 *1 76.14,63.87 nfet_01v8
M$5365 2377 164 110 167 nfet_01v8 L=150000U W=140000U AS=16800000000P
+ AD=21875000000P PS=380000U PD=460000U
* device instance $5366 r0 *1 76.66,63.87 nfet_01v8
M$5366 1006 164 111 167 nfet_01v8 L=150000U W=140000U AS=16800000000P
+ AD=21875000000P PS=380000U PD=460000U
* device instance $5367 r0 *1 76.105,64.27 nfet_01v8
M$5367 167 2778 2377 167 nfet_01v8 L=150000U W=210000U AS=21875000000P
+ AD=40400000000P PS=460000U PD=560000U
* device instance $5368 r0 *1 76.695,64.27 nfet_01v8
M$5368 167 1541 1006 167 nfet_01v8 L=150000U W=210000U AS=21875000000P
+ AD=40400000000P PS=460000U PD=560000U
* device instance $5369 r0 *1 76.105,64.66 nfet_01v8
M$5369 2778 2377 167 167 nfet_01v8 L=150000U W=210000U AS=40400000000P
+ AD=21875000000P PS=560000U PD=460000U
* device instance $5370 r0 *1 76.695,64.66 nfet_01v8
M$5370 1541 1006 167 167 nfet_01v8 L=150000U W=210000U AS=40400000000P
+ AD=21875000000P PS=560000U PD=460000U
* device instance $5371 r0 *1 76.14,65.06 nfet_01v8
M$5371 109 164 2778 167 nfet_01v8 L=150000U W=140000U AS=21875000000P
+ AD=16800000000P PS=460000U PD=380000U
* device instance $5372 r0 *1 76.66,65.06 nfet_01v8
M$5372 112 164 1541 167 nfet_01v8 L=150000U W=140000U AS=21875000000P
+ AD=16800000000P PS=460000U PD=380000U
* device instance $5373 r0 *1 76.14,65.45 nfet_01v8
M$5373 2460 165 109 167 nfet_01v8 L=150000U W=140000U AS=16800000000P
+ AD=21875000000P PS=380000U PD=460000U
* device instance $5374 r0 *1 76.66,65.45 nfet_01v8
M$5374 1030 165 112 167 nfet_01v8 L=150000U W=140000U AS=16800000000P
+ AD=21875000000P PS=380000U PD=460000U
* device instance $5375 r0 *1 76.105,65.85 nfet_01v8
M$5375 167 2940 2460 167 nfet_01v8 L=150000U W=210000U AS=21875000000P
+ AD=40400000000P PS=460000U PD=560000U
* device instance $5376 r0 *1 76.695,65.85 nfet_01v8
M$5376 167 1568 1030 167 nfet_01v8 L=150000U W=210000U AS=21875000000P
+ AD=40400000000P PS=460000U PD=560000U
* device instance $5377 r0 *1 76.105,66.24 nfet_01v8
M$5377 2940 2460 167 167 nfet_01v8 L=150000U W=210000U AS=40400000000P
+ AD=21875000000P PS=560000U PD=460000U
* device instance $5378 r0 *1 76.695,66.24 nfet_01v8
M$5378 1568 1030 167 167 nfet_01v8 L=150000U W=210000U AS=40400000000P
+ AD=21875000000P PS=560000U PD=460000U
* device instance $5379 r0 *1 76.14,66.64 nfet_01v8
M$5379 110 165 2940 167 nfet_01v8 L=150000U W=140000U AS=21875000000P
+ AD=16800000000P PS=460000U PD=380000U
* device instance $5380 r0 *1 76.66,66.64 nfet_01v8
M$5380 111 165 1568 167 nfet_01v8 L=150000U W=140000U AS=21875000000P
+ AD=16800000000P PS=460000U PD=380000U
* device instance $5381 r0 *1 43.44,37.01 nfet_01v8
M$5381 3687 150 62 167 nfet_01v8 L=150000U W=140000U AS=16800000000P
+ AD=21875000000P PS=380000U PD=460000U
* device instance $5382 r0 *1 43.96,37.01 nfet_01v8
M$5382 1245 150 63 167 nfet_01v8 L=150000U W=140000U AS=16800000000P
+ AD=21875000000P PS=380000U PD=460000U
* device instance $5383 r0 *1 43.405,37.41 nfet_01v8
M$5383 167 2737 3687 167 nfet_01v8 L=150000U W=210000U AS=21875000000P
+ AD=40400000000P PS=460000U PD=560000U
* device instance $5384 r0 *1 43.995,37.41 nfet_01v8
M$5384 167 1817 1245 167 nfet_01v8 L=150000U W=210000U AS=21875000000P
+ AD=40400000000P PS=460000U PD=560000U
* device instance $5385 r0 *1 43.405,37.8 nfet_01v8
M$5385 2737 3687 167 167 nfet_01v8 L=150000U W=210000U AS=40400000000P
+ AD=21875000000P PS=560000U PD=460000U
* device instance $5386 r0 *1 43.995,37.8 nfet_01v8
M$5386 1817 1245 167 167 nfet_01v8 L=150000U W=210000U AS=40400000000P
+ AD=21875000000P PS=560000U PD=460000U
* device instance $5387 r0 *1 43.44,38.2 nfet_01v8
M$5387 61 150 2737 167 nfet_01v8 L=150000U W=140000U AS=21875000000P
+ AD=16800000000P PS=460000U PD=380000U
* device instance $5388 r0 *1 43.96,38.2 nfet_01v8
M$5388 64 150 1817 167 nfet_01v8 L=150000U W=140000U AS=21875000000P
+ AD=16800000000P PS=460000U PD=380000U
* device instance $5389 r0 *1 43.44,38.59 nfet_01v8
M$5389 3679 151 61 167 nfet_01v8 L=150000U W=140000U AS=16800000000P
+ AD=21875000000P PS=380000U PD=460000U
* device instance $5390 r0 *1 43.96,38.59 nfet_01v8
M$5390 4424 151 64 167 nfet_01v8 L=150000U W=140000U AS=16800000000P
+ AD=21875000000P PS=380000U PD=460000U
* device instance $5391 r0 *1 43.405,38.99 nfet_01v8
M$5391 167 1994 3679 167 nfet_01v8 L=150000U W=210000U AS=21875000000P
+ AD=40400000000P PS=460000U PD=560000U
* device instance $5392 r0 *1 43.995,38.99 nfet_01v8
M$5392 167 721 4424 167 nfet_01v8 L=150000U W=210000U AS=21875000000P
+ AD=40400000000P PS=460000U PD=560000U
* device instance $5393 r0 *1 43.405,39.38 nfet_01v8
M$5393 1994 3679 167 167 nfet_01v8 L=150000U W=210000U AS=40400000000P
+ AD=21875000000P PS=560000U PD=460000U
* device instance $5394 r0 *1 43.995,39.38 nfet_01v8
M$5394 721 4424 167 167 nfet_01v8 L=150000U W=210000U AS=40400000000P
+ AD=21875000000P PS=560000U PD=460000U
* device instance $5395 r0 *1 43.44,39.78 nfet_01v8
M$5395 62 151 1994 167 nfet_01v8 L=150000U W=140000U AS=21875000000P
+ AD=16800000000P PS=460000U PD=380000U
* device instance $5396 r0 *1 43.96,39.78 nfet_01v8
M$5396 63 151 721 167 nfet_01v8 L=150000U W=140000U AS=21875000000P
+ AD=16800000000P PS=460000U PD=380000U
* device instance $5397 r0 *1 43.44,40.17 nfet_01v8
M$5397 3670 152 62 167 nfet_01v8 L=150000U W=140000U AS=16800000000P
+ AD=21875000000P PS=380000U PD=460000U
* device instance $5398 r0 *1 43.96,40.17 nfet_01v8
M$5398 1233 152 63 167 nfet_01v8 L=150000U W=140000U AS=16800000000P
+ AD=21875000000P PS=380000U PD=460000U
* device instance $5399 r0 *1 43.405,40.57 nfet_01v8
M$5399 167 2687 3670 167 nfet_01v8 L=150000U W=210000U AS=21875000000P
+ AD=40400000000P PS=460000U PD=560000U
* device instance $5400 r0 *1 43.995,40.57 nfet_01v8
M$5400 167 1805 1233 167 nfet_01v8 L=150000U W=210000U AS=21875000000P
+ AD=40400000000P PS=460000U PD=560000U
* device instance $5401 r0 *1 43.405,40.96 nfet_01v8
M$5401 2687 3670 167 167 nfet_01v8 L=150000U W=210000U AS=40400000000P
+ AD=21875000000P PS=560000U PD=460000U
* device instance $5402 r0 *1 43.995,40.96 nfet_01v8
M$5402 1805 1233 167 167 nfet_01v8 L=150000U W=210000U AS=40400000000P
+ AD=21875000000P PS=560000U PD=460000U
* device instance $5403 r0 *1 43.44,41.36 nfet_01v8
M$5403 61 152 2687 167 nfet_01v8 L=150000U W=140000U AS=21875000000P
+ AD=16800000000P PS=460000U PD=380000U
* device instance $5404 r0 *1 43.96,41.36 nfet_01v8
M$5404 64 152 1805 167 nfet_01v8 L=150000U W=140000U AS=21875000000P
+ AD=16800000000P PS=460000U PD=380000U
* device instance $5405 r0 *1 43.44,41.75 nfet_01v8
M$5405 3671 153 61 167 nfet_01v8 L=150000U W=140000U AS=16800000000P
+ AD=21875000000P PS=380000U PD=460000U
* device instance $5406 r0 *1 43.96,41.75 nfet_01v8
M$5406 1236 153 64 167 nfet_01v8 L=150000U W=140000U AS=16800000000P
+ AD=21875000000P PS=380000U PD=460000U
* device instance $5407 r0 *1 43.405,42.15 nfet_01v8
M$5407 167 2691 3671 167 nfet_01v8 L=150000U W=210000U AS=21875000000P
+ AD=40400000000P PS=460000U PD=560000U
* device instance $5408 r0 *1 43.995,42.15 nfet_01v8
M$5408 167 1808 1236 167 nfet_01v8 L=150000U W=210000U AS=21875000000P
+ AD=40400000000P PS=460000U PD=560000U
* device instance $5409 r0 *1 43.405,42.54 nfet_01v8
M$5409 2691 3671 167 167 nfet_01v8 L=150000U W=210000U AS=40400000000P
+ AD=21875000000P PS=560000U PD=460000U
* device instance $5410 r0 *1 43.995,42.54 nfet_01v8
M$5410 1808 1236 167 167 nfet_01v8 L=150000U W=210000U AS=40400000000P
+ AD=21875000000P PS=560000U PD=460000U
* device instance $5411 r0 *1 43.44,42.94 nfet_01v8
M$5411 62 153 2691 167 nfet_01v8 L=150000U W=140000U AS=21875000000P
+ AD=16800000000P PS=460000U PD=380000U
* device instance $5412 r0 *1 43.96,42.94 nfet_01v8
M$5412 63 153 1808 167 nfet_01v8 L=150000U W=140000U AS=21875000000P
+ AD=16800000000P PS=460000U PD=380000U
* device instance $5413 r0 *1 32.54,37.01 nfet_01v8
M$5413 3659 150 46 167 nfet_01v8 L=150000U W=140000U AS=16800000000P
+ AD=21875000000P PS=380000U PD=460000U
* device instance $5414 r0 *1 33.06,37.01 nfet_01v8
M$5414 1256 150 47 167 nfet_01v8 L=150000U W=140000U AS=16800000000P
+ AD=21875000000P PS=380000U PD=460000U
* device instance $5415 r0 *1 32.505,37.41 nfet_01v8
M$5415 167 2711 3659 167 nfet_01v8 L=150000U W=210000U AS=21875000000P
+ AD=40400000000P PS=460000U PD=560000U
* device instance $5416 r0 *1 33.095,37.41 nfet_01v8
M$5416 167 1831 1256 167 nfet_01v8 L=150000U W=210000U AS=21875000000P
+ AD=40400000000P PS=460000U PD=560000U
* device instance $5417 r0 *1 32.505,37.8 nfet_01v8
M$5417 2711 3659 167 167 nfet_01v8 L=150000U W=210000U AS=40400000000P
+ AD=21875000000P PS=560000U PD=460000U
* device instance $5418 r0 *1 33.095,37.8 nfet_01v8
M$5418 1831 1256 167 167 nfet_01v8 L=150000U W=210000U AS=40400000000P
+ AD=21875000000P PS=560000U PD=460000U
* device instance $5419 r0 *1 32.54,38.2 nfet_01v8
M$5419 45 150 2711 167 nfet_01v8 L=150000U W=140000U AS=21875000000P
+ AD=16800000000P PS=460000U PD=380000U
* device instance $5420 r0 *1 33.06,38.2 nfet_01v8
M$5420 48 150 1831 167 nfet_01v8 L=150000U W=140000U AS=21875000000P
+ AD=16800000000P PS=460000U PD=380000U
* device instance $5421 r0 *1 32.54,38.59 nfet_01v8
M$5421 3633 151 45 167 nfet_01v8 L=150000U W=140000U AS=16800000000P
+ AD=21875000000P PS=380000U PD=460000U
* device instance $5422 r0 *1 33.06,38.59 nfet_01v8
M$5422 4420 151 48 167 nfet_01v8 L=150000U W=140000U AS=16800000000P
+ AD=21875000000P PS=380000U PD=460000U
* device instance $5423 r0 *1 32.505,38.99 nfet_01v8
M$5423 167 2708 3633 167 nfet_01v8 L=150000U W=210000U AS=21875000000P
+ AD=40400000000P PS=460000U PD=560000U
* device instance $5424 r0 *1 33.095,38.99 nfet_01v8
M$5424 167 1829 4420 167 nfet_01v8 L=150000U W=210000U AS=21875000000P
+ AD=40400000000P PS=460000U PD=560000U
* device instance $5425 r0 *1 32.505,39.38 nfet_01v8
M$5425 2708 3633 167 167 nfet_01v8 L=150000U W=210000U AS=40400000000P
+ AD=21875000000P PS=560000U PD=460000U
* device instance $5426 r0 *1 33.095,39.38 nfet_01v8
M$5426 1829 4420 167 167 nfet_01v8 L=150000U W=210000U AS=40400000000P
+ AD=21875000000P PS=560000U PD=460000U
* device instance $5427 r0 *1 32.54,39.78 nfet_01v8
M$5427 46 151 2708 167 nfet_01v8 L=150000U W=140000U AS=21875000000P
+ AD=16800000000P PS=460000U PD=380000U
* device instance $5428 r0 *1 33.06,39.78 nfet_01v8
M$5428 47 151 1829 167 nfet_01v8 L=150000U W=140000U AS=21875000000P
+ AD=16800000000P PS=460000U PD=380000U
* device instance $5429 r0 *1 32.54,40.17 nfet_01v8
M$5429 2383 152 46 167 nfet_01v8 L=150000U W=140000U AS=16800000000P
+ AD=21875000000P PS=380000U PD=460000U
* device instance $5430 r0 *1 33.06,40.17 nfet_01v8
M$5430 1247 152 47 167 nfet_01v8 L=150000U W=140000U AS=16800000000P
+ AD=21875000000P PS=380000U PD=460000U
* device instance $5431 r0 *1 32.505,40.57 nfet_01v8
M$5431 167 2785 2383 167 nfet_01v8 L=150000U W=210000U AS=21875000000P
+ AD=40400000000P PS=460000U PD=560000U
* device instance $5432 r0 *1 33.095,40.57 nfet_01v8
M$5432 167 1819 1247 167 nfet_01v8 L=150000U W=210000U AS=21875000000P
+ AD=40400000000P PS=460000U PD=560000U
* device instance $5433 r0 *1 32.505,40.96 nfet_01v8
M$5433 2785 2383 167 167 nfet_01v8 L=150000U W=210000U AS=40400000000P
+ AD=21875000000P PS=560000U PD=460000U
* device instance $5434 r0 *1 33.095,40.96 nfet_01v8
M$5434 1819 1247 167 167 nfet_01v8 L=150000U W=210000U AS=40400000000P
+ AD=21875000000P PS=560000U PD=460000U
* device instance $5435 r0 *1 32.54,41.36 nfet_01v8
M$5435 45 152 2785 167 nfet_01v8 L=150000U W=140000U AS=21875000000P
+ AD=16800000000P PS=460000U PD=380000U
* device instance $5436 r0 *1 33.06,41.36 nfet_01v8
M$5436 48 152 1819 167 nfet_01v8 L=150000U W=140000U AS=21875000000P
+ AD=16800000000P PS=460000U PD=380000U
* device instance $5437 r0 *1 32.54,41.75 nfet_01v8
M$5437 3629 153 45 167 nfet_01v8 L=150000U W=140000U AS=16800000000P
+ AD=21875000000P PS=380000U PD=460000U
* device instance $5438 r0 *1 33.06,41.75 nfet_01v8
M$5438 1252 153 48 167 nfet_01v8 L=150000U W=140000U AS=16800000000P
+ AD=21875000000P PS=380000U PD=460000U
* device instance $5439 r0 *1 32.505,42.15 nfet_01v8
M$5439 167 2699 3629 167 nfet_01v8 L=150000U W=210000U AS=21875000000P
+ AD=40400000000P PS=460000U PD=560000U
* device instance $5440 r0 *1 33.095,42.15 nfet_01v8
M$5440 167 1825 1252 167 nfet_01v8 L=150000U W=210000U AS=21875000000P
+ AD=40400000000P PS=460000U PD=560000U
* device instance $5441 r0 *1 32.505,42.54 nfet_01v8
M$5441 2699 3629 167 167 nfet_01v8 L=150000U W=210000U AS=40400000000P
+ AD=21875000000P PS=560000U PD=460000U
* device instance $5442 r0 *1 33.095,42.54 nfet_01v8
M$5442 1825 1252 167 167 nfet_01v8 L=150000U W=210000U AS=40400000000P
+ AD=21875000000P PS=560000U PD=460000U
* device instance $5443 r0 *1 32.54,42.94 nfet_01v8
M$5443 46 153 2699 167 nfet_01v8 L=150000U W=140000U AS=21875000000P
+ AD=16800000000P PS=460000U PD=380000U
* device instance $5444 r0 *1 33.06,42.94 nfet_01v8
M$5444 47 153 1825 167 nfet_01v8 L=150000U W=140000U AS=21875000000P
+ AD=16800000000P PS=460000U PD=380000U
* device instance $5445 r0 *1 21.64,37.01 nfet_01v8
M$5445 2367 150 30 167 nfet_01v8 L=150000U W=140000U AS=16800000000P
+ AD=21875000000P PS=380000U PD=460000U
* device instance $5446 r0 *1 22.16,37.01 nfet_01v8
M$5446 1207 150 31 167 nfet_01v8 L=150000U W=140000U AS=16800000000P
+ AD=21875000000P PS=380000U PD=460000U
* device instance $5447 r0 *1 21.605,37.41 nfet_01v8
M$5447 167 2760 2367 167 nfet_01v8 L=150000U W=210000U AS=21875000000P
+ AD=40400000000P PS=460000U PD=560000U
* device instance $5448 r0 *1 22.195,37.41 nfet_01v8
M$5448 167 1777 1207 167 nfet_01v8 L=150000U W=210000U AS=21875000000P
+ AD=40400000000P PS=460000U PD=560000U
* device instance $5449 r0 *1 21.605,37.8 nfet_01v8
M$5449 2760 2367 167 167 nfet_01v8 L=150000U W=210000U AS=40400000000P
+ AD=21875000000P PS=560000U PD=460000U
* device instance $5450 r0 *1 22.195,37.8 nfet_01v8
M$5450 1777 1207 167 167 nfet_01v8 L=150000U W=210000U AS=40400000000P
+ AD=21875000000P PS=560000U PD=460000U
* device instance $5451 r0 *1 21.64,38.2 nfet_01v8
M$5451 29 150 2760 167 nfet_01v8 L=150000U W=140000U AS=21875000000P
+ AD=16800000000P PS=460000U PD=380000U
* device instance $5452 r0 *1 22.16,38.2 nfet_01v8
M$5452 32 150 1777 167 nfet_01v8 L=150000U W=140000U AS=21875000000P
+ AD=16800000000P PS=460000U PD=380000U
* device instance $5453 r0 *1 21.64,38.59 nfet_01v8
M$5453 3637 151 29 167 nfet_01v8 L=150000U W=140000U AS=16800000000P
+ AD=21875000000P PS=380000U PD=460000U
* device instance $5454 r0 *1 22.16,38.59 nfet_01v8
M$5454 4405 151 32 167 nfet_01v8 L=150000U W=140000U AS=16800000000P
+ AD=21875000000P PS=380000U PD=460000U
* device instance $5455 r0 *1 21.605,38.99 nfet_01v8
M$5455 167 2037 3637 167 nfet_01v8 L=150000U W=210000U AS=21875000000P
+ AD=40400000000P PS=460000U PD=560000U
* device instance $5456 r0 *1 22.195,38.99 nfet_01v8
M$5456 167 730 4405 167 nfet_01v8 L=150000U W=210000U AS=21875000000P
+ AD=40400000000P PS=460000U PD=560000U
* device instance $5457 r0 *1 21.605,39.38 nfet_01v8
M$5457 2037 3637 167 167 nfet_01v8 L=150000U W=210000U AS=40400000000P
+ AD=21875000000P PS=560000U PD=460000U
* device instance $5458 r0 *1 22.195,39.38 nfet_01v8
M$5458 730 4405 167 167 nfet_01v8 L=150000U W=210000U AS=40400000000P
+ AD=21875000000P PS=560000U PD=460000U
* device instance $5459 r0 *1 21.64,39.78 nfet_01v8
M$5459 30 151 2037 167 nfet_01v8 L=150000U W=140000U AS=21875000000P
+ AD=16800000000P PS=460000U PD=380000U
* device instance $5460 r0 *1 22.16,39.78 nfet_01v8
M$5460 31 151 730 167 nfet_01v8 L=150000U W=140000U AS=21875000000P
+ AD=16800000000P PS=460000U PD=380000U
* device instance $5461 r0 *1 21.64,40.17 nfet_01v8
M$5461 2540 152 30 167 nfet_01v8 L=150000U W=140000U AS=16800000000P
+ AD=21875000000P PS=380000U PD=460000U
* device instance $5462 r0 *1 22.16,40.17 nfet_01v8
M$5462 1350 152 31 167 nfet_01v8 L=150000U W=140000U AS=16800000000P
+ AD=21875000000P PS=380000U PD=460000U
* device instance $5463 r0 *1 21.605,40.57 nfet_01v8
M$5463 167 3115 2540 167 nfet_01v8 L=150000U W=210000U AS=21875000000P
+ AD=40400000000P PS=460000U PD=560000U
* device instance $5464 r0 *1 22.195,40.57 nfet_01v8
M$5464 167 1938 1350 167 nfet_01v8 L=150000U W=210000U AS=21875000000P
+ AD=40400000000P PS=460000U PD=560000U
* device instance $5465 r0 *1 21.605,40.96 nfet_01v8
M$5465 3115 2540 167 167 nfet_01v8 L=150000U W=210000U AS=40400000000P
+ AD=21875000000P PS=560000U PD=460000U
* device instance $5466 r0 *1 22.195,40.96 nfet_01v8
M$5466 1938 1350 167 167 nfet_01v8 L=150000U W=210000U AS=40400000000P
+ AD=21875000000P PS=560000U PD=460000U
* device instance $5467 r0 *1 21.64,41.36 nfet_01v8
M$5467 29 152 3115 167 nfet_01v8 L=150000U W=140000U AS=21875000000P
+ AD=16800000000P PS=460000U PD=380000U
* device instance $5468 r0 *1 22.16,41.36 nfet_01v8
M$5468 32 152 1938 167 nfet_01v8 L=150000U W=140000U AS=21875000000P
+ AD=16800000000P PS=460000U PD=380000U
* device instance $5469 r0 *1 21.64,41.75 nfet_01v8
M$5469 2532 153 29 167 nfet_01v8 L=150000U W=140000U AS=16800000000P
+ AD=21875000000P PS=380000U PD=460000U
* device instance $5470 r0 *1 22.16,41.75 nfet_01v8
M$5470 1372 153 32 167 nfet_01v8 L=150000U W=140000U AS=16800000000P
+ AD=21875000000P PS=380000U PD=460000U
* device instance $5471 r0 *1 21.605,42.15 nfet_01v8
M$5471 167 3098 2532 167 nfet_01v8 L=150000U W=210000U AS=21875000000P
+ AD=40400000000P PS=460000U PD=560000U
* device instance $5472 r0 *1 22.195,42.15 nfet_01v8
M$5472 167 1964 1372 167 nfet_01v8 L=150000U W=210000U AS=21875000000P
+ AD=40400000000P PS=460000U PD=560000U
* device instance $5473 r0 *1 21.605,42.54 nfet_01v8
M$5473 3098 2532 167 167 nfet_01v8 L=150000U W=210000U AS=40400000000P
+ AD=21875000000P PS=560000U PD=460000U
* device instance $5474 r0 *1 22.195,42.54 nfet_01v8
M$5474 1964 1372 167 167 nfet_01v8 L=150000U W=210000U AS=40400000000P
+ AD=21875000000P PS=560000U PD=460000U
* device instance $5475 r0 *1 21.64,42.94 nfet_01v8
M$5475 30 153 3098 167 nfet_01v8 L=150000U W=140000U AS=21875000000P
+ AD=16800000000P PS=460000U PD=380000U
* device instance $5476 r0 *1 22.16,42.94 nfet_01v8
M$5476 31 153 1964 167 nfet_01v8 L=150000U W=140000U AS=21875000000P
+ AD=16800000000P PS=460000U PD=380000U
* device instance $5477 r0 *1 10.74,37.01 nfet_01v8
M$5477 3733 150 14 167 nfet_01v8 L=150000U W=140000U AS=16800000000P
+ AD=21875000000P PS=380000U PD=460000U
* device instance $5478 r0 *1 11.26,37.01 nfet_01v8
M$5478 1347 150 15 167 nfet_01v8 L=150000U W=140000U AS=16800000000P
+ AD=21875000000P PS=380000U PD=460000U
* device instance $5479 r0 *1 10.705,37.41 nfet_01v8
M$5479 167 3078 3733 167 nfet_01v8 L=150000U W=210000U AS=21875000000P
+ AD=40400000000P PS=460000U PD=560000U
* device instance $5480 r0 *1 11.295,37.41 nfet_01v8
M$5480 167 1935 1347 167 nfet_01v8 L=150000U W=210000U AS=21875000000P
+ AD=40400000000P PS=460000U PD=560000U
* device instance $5481 r0 *1 10.705,37.8 nfet_01v8
M$5481 3078 3733 167 167 nfet_01v8 L=150000U W=210000U AS=40400000000P
+ AD=21875000000P PS=560000U PD=460000U
* device instance $5482 r0 *1 11.295,37.8 nfet_01v8
M$5482 1935 1347 167 167 nfet_01v8 L=150000U W=210000U AS=40400000000P
+ AD=21875000000P PS=560000U PD=460000U
* device instance $5483 r0 *1 10.74,38.2 nfet_01v8
M$5483 13 150 3078 167 nfet_01v8 L=150000U W=140000U AS=21875000000P
+ AD=16800000000P PS=460000U PD=380000U
* device instance $5484 r0 *1 11.26,38.2 nfet_01v8
M$5484 16 150 1935 167 nfet_01v8 L=150000U W=140000U AS=21875000000P
+ AD=16800000000P PS=460000U PD=380000U
* device instance $5485 r0 *1 10.74,38.59 nfet_01v8
M$5485 3732 151 13 167 nfet_01v8 L=150000U W=140000U AS=16800000000P
+ AD=21875000000P PS=380000U PD=460000U
* device instance $5486 r0 *1 11.26,38.59 nfet_01v8
M$5486 4402 151 16 167 nfet_01v8 L=150000U W=140000U AS=16800000000P
+ AD=21875000000P PS=380000U PD=460000U
* device instance $5487 r0 *1 10.705,38.99 nfet_01v8
M$5487 167 2147 3732 167 nfet_01v8 L=150000U W=210000U AS=21875000000P
+ AD=40400000000P PS=460000U PD=560000U
* device instance $5488 r0 *1 11.295,38.99 nfet_01v8
M$5488 167 685 4402 167 nfet_01v8 L=150000U W=210000U AS=21875000000P
+ AD=40400000000P PS=460000U PD=560000U
* device instance $5489 r0 *1 10.705,39.38 nfet_01v8
M$5489 2147 3732 167 167 nfet_01v8 L=150000U W=210000U AS=40400000000P
+ AD=21875000000P PS=560000U PD=460000U
* device instance $5490 r0 *1 11.295,39.38 nfet_01v8
M$5490 685 4402 167 167 nfet_01v8 L=150000U W=210000U AS=40400000000P
+ AD=21875000000P PS=560000U PD=460000U
* device instance $5491 r0 *1 10.74,39.78 nfet_01v8
M$5491 14 151 2147 167 nfet_01v8 L=150000U W=140000U AS=21875000000P
+ AD=16800000000P PS=460000U PD=380000U
* device instance $5492 r0 *1 11.26,39.78 nfet_01v8
M$5492 15 151 685 167 nfet_01v8 L=150000U W=140000U AS=21875000000P
+ AD=16800000000P PS=460000U PD=380000U
* device instance $5493 r0 *1 10.74,40.17 nfet_01v8
M$5493 3724 152 14 167 nfet_01v8 L=150000U W=140000U AS=16800000000P
+ AD=21875000000P PS=380000U PD=460000U
* device instance $5494 r0 *1 11.26,40.17 nfet_01v8
M$5494 586 152 15 167 nfet_01v8 L=150000U W=140000U AS=16800000000P
+ AD=21875000000P PS=380000U PD=460000U
* device instance $5495 r0 *1 10.705,40.57 nfet_01v8
M$5495 167 2154 3724 167 nfet_01v8 L=150000U W=210000U AS=21875000000P
+ AD=40400000000P PS=460000U PD=560000U
* device instance $5496 r0 *1 11.295,40.57 nfet_01v8
M$5496 167 690 586 167 nfet_01v8 L=150000U W=210000U AS=21875000000P
+ AD=40400000000P PS=460000U PD=560000U
* device instance $5497 r0 *1 10.705,40.96 nfet_01v8
M$5497 2154 3724 167 167 nfet_01v8 L=150000U W=210000U AS=40400000000P
+ AD=21875000000P PS=560000U PD=460000U
* device instance $5498 r0 *1 11.295,40.96 nfet_01v8
M$5498 690 586 167 167 nfet_01v8 L=150000U W=210000U AS=40400000000P
+ AD=21875000000P PS=560000U PD=460000U
* device instance $5499 r0 *1 10.74,41.36 nfet_01v8
M$5499 13 152 2154 167 nfet_01v8 L=150000U W=140000U AS=21875000000P
+ AD=16800000000P PS=460000U PD=380000U
* device instance $5500 r0 *1 11.26,41.36 nfet_01v8
M$5500 16 152 690 167 nfet_01v8 L=150000U W=140000U AS=21875000000P
+ AD=16800000000P PS=460000U PD=380000U
* device instance $5501 r0 *1 10.74,41.75 nfet_01v8
M$5501 3726 153 13 167 nfet_01v8 L=150000U W=140000U AS=16800000000P
+ AD=21875000000P PS=380000U PD=460000U
* device instance $5502 r0 *1 11.26,41.75 nfet_01v8
M$5502 1299 153 16 167 nfet_01v8 L=150000U W=140000U AS=16800000000P
+ AD=21875000000P PS=380000U PD=460000U
* device instance $5503 r0 *1 10.705,42.15 nfet_01v8
M$5503 167 3088 3726 167 nfet_01v8 L=150000U W=210000U AS=21875000000P
+ AD=40400000000P PS=460000U PD=560000U
* device instance $5504 r0 *1 11.295,42.15 nfet_01v8
M$5504 167 1877 1299 167 nfet_01v8 L=150000U W=210000U AS=21875000000P
+ AD=40400000000P PS=460000U PD=560000U
* device instance $5505 r0 *1 10.705,42.54 nfet_01v8
M$5505 3088 3726 167 167 nfet_01v8 L=150000U W=210000U AS=40400000000P
+ AD=21875000000P PS=560000U PD=460000U
* device instance $5506 r0 *1 11.295,42.54 nfet_01v8
M$5506 1877 1299 167 167 nfet_01v8 L=150000U W=210000U AS=40400000000P
+ AD=21875000000P PS=560000U PD=460000U
* device instance $5507 r0 *1 10.74,42.94 nfet_01v8
M$5507 14 153 3088 167 nfet_01v8 L=150000U W=140000U AS=21875000000P
+ AD=16800000000P PS=460000U PD=380000U
* device instance $5508 r0 *1 11.26,42.94 nfet_01v8
M$5508 15 153 1877 167 nfet_01v8 L=150000U W=140000U AS=21875000000P
+ AD=16800000000P PS=460000U PD=380000U
* device instance $5509 r0 *1 43.44,60.71 nfet_01v8
M$5509 3520 162 62 167 nfet_01v8 L=150000U W=140000U AS=16800000000P
+ AD=21875000000P PS=380000U PD=460000U
* device instance $5510 r0 *1 43.96,60.71 nfet_01v8
M$5510 904 162 63 167 nfet_01v8 L=150000U W=140000U AS=16800000000P
+ AD=21875000000P PS=380000U PD=460000U
* device instance $5511 r0 *1 43.405,61.11 nfet_01v8
M$5511 167 3001 3520 167 nfet_01v8 L=150000U W=210000U AS=21875000000P
+ AD=40400000000P PS=460000U PD=560000U
* device instance $5512 r0 *1 43.995,61.11 nfet_01v8
M$5512 167 1421 904 167 nfet_01v8 L=150000U W=210000U AS=21875000000P
+ AD=40400000000P PS=460000U PD=560000U
* device instance $5513 r0 *1 43.405,61.5 nfet_01v8
M$5513 3001 3520 167 167 nfet_01v8 L=150000U W=210000U AS=40400000000P
+ AD=21875000000P PS=560000U PD=460000U
* device instance $5514 r0 *1 43.995,61.5 nfet_01v8
M$5514 1421 904 167 167 nfet_01v8 L=150000U W=210000U AS=40400000000P
+ AD=21875000000P PS=560000U PD=460000U
* device instance $5515 r0 *1 43.44,61.9 nfet_01v8
M$5515 61 162 3001 167 nfet_01v8 L=150000U W=140000U AS=21875000000P
+ AD=16800000000P PS=460000U PD=380000U
* device instance $5516 r0 *1 43.96,61.9 nfet_01v8
M$5516 64 162 1421 167 nfet_01v8 L=150000U W=140000U AS=21875000000P
+ AD=16800000000P PS=460000U PD=380000U
* device instance $5517 r0 *1 43.44,62.29 nfet_01v8
M$5517 3533 163 61 167 nfet_01v8 L=150000U W=140000U AS=16800000000P
+ AD=21875000000P PS=380000U PD=460000U
* device instance $5518 r0 *1 43.96,62.29 nfet_01v8
M$5518 4398 163 64 167 nfet_01v8 L=150000U W=140000U AS=16800000000P
+ AD=21875000000P PS=380000U PD=460000U
* device instance $5519 r0 *1 43.405,62.69 nfet_01v8
M$5519 167 2547 3533 167 nfet_01v8 L=150000U W=210000U AS=21875000000P
+ AD=40400000000P PS=460000U PD=560000U
* device instance $5520 r0 *1 43.995,62.69 nfet_01v8
M$5520 167 1925 4398 167 nfet_01v8 L=150000U W=210000U AS=21875000000P
+ AD=40400000000P PS=460000U PD=560000U
* device instance $5521 r0 *1 43.405,63.08 nfet_01v8
M$5521 2547 3533 167 167 nfet_01v8 L=150000U W=210000U AS=40400000000P
+ AD=21875000000P PS=560000U PD=460000U
* device instance $5522 r0 *1 43.995,63.08 nfet_01v8
M$5522 1925 4398 167 167 nfet_01v8 L=150000U W=210000U AS=40400000000P
+ AD=21875000000P PS=560000U PD=460000U
* device instance $5523 r0 *1 43.44,63.48 nfet_01v8
M$5523 62 163 2547 167 nfet_01v8 L=150000U W=140000U AS=21875000000P
+ AD=16800000000P PS=460000U PD=380000U
* device instance $5524 r0 *1 43.96,63.48 nfet_01v8
M$5524 63 163 1925 167 nfet_01v8 L=150000U W=140000U AS=21875000000P
+ AD=16800000000P PS=460000U PD=380000U
* device instance $5525 r0 *1 43.44,63.87 nfet_01v8
M$5525 3535 164 62 167 nfet_01v8 L=150000U W=140000U AS=16800000000P
+ AD=21875000000P PS=380000U PD=460000U
* device instance $5526 r0 *1 43.96,63.87 nfet_01v8
M$5526 582 164 63 167 nfet_01v8 L=150000U W=140000U AS=16800000000P
+ AD=21875000000P PS=380000U PD=460000U
* device instance $5527 r0 *1 43.405,64.27 nfet_01v8
M$5527 167 2564 3535 167 nfet_01v8 L=150000U W=210000U AS=21875000000P
+ AD=40400000000P PS=460000U PD=560000U
* device instance $5528 r0 *1 43.995,64.27 nfet_01v8
M$5528 167 677 582 167 nfet_01v8 L=150000U W=210000U AS=21875000000P
+ AD=40400000000P PS=460000U PD=560000U
* device instance $5529 r0 *1 43.405,64.66 nfet_01v8
M$5529 2564 3535 167 167 nfet_01v8 L=150000U W=210000U AS=40400000000P
+ AD=21875000000P PS=560000U PD=460000U
* device instance $5530 r0 *1 43.995,64.66 nfet_01v8
M$5530 677 582 167 167 nfet_01v8 L=150000U W=210000U AS=40400000000P
+ AD=21875000000P PS=560000U PD=460000U
* device instance $5531 r0 *1 43.44,65.06 nfet_01v8
M$5531 61 164 2564 167 nfet_01v8 L=150000U W=140000U AS=21875000000P
+ AD=16800000000P PS=460000U PD=380000U
* device instance $5532 r0 *1 43.96,65.06 nfet_01v8
M$5532 64 164 677 167 nfet_01v8 L=150000U W=140000U AS=21875000000P
+ AD=16800000000P PS=460000U PD=380000U
* device instance $5533 r0 *1 43.44,65.45 nfet_01v8
M$5533 3536 165 61 167 nfet_01v8 L=150000U W=140000U AS=16800000000P
+ AD=21875000000P PS=380000U PD=460000U
* device instance $5534 r0 *1 43.96,65.45 nfet_01v8
M$5534 1285 165 64 167 nfet_01v8 L=150000U W=140000U AS=16800000000P
+ AD=21875000000P PS=380000U PD=460000U
* device instance $5535 r0 *1 43.405,65.85 nfet_01v8
M$5535 167 2575 3536 167 nfet_01v8 L=150000U W=210000U AS=21875000000P
+ AD=40400000000P PS=460000U PD=560000U
* device instance $5536 r0 *1 43.995,65.85 nfet_01v8
M$5536 167 1862 1285 167 nfet_01v8 L=150000U W=210000U AS=21875000000P
+ AD=40400000000P PS=460000U PD=560000U
* device instance $5537 r0 *1 43.405,66.24 nfet_01v8
M$5537 2575 3536 167 167 nfet_01v8 L=150000U W=210000U AS=40400000000P
+ AD=21875000000P PS=560000U PD=460000U
* device instance $5538 r0 *1 43.995,66.24 nfet_01v8
M$5538 1862 1285 167 167 nfet_01v8 L=150000U W=210000U AS=40400000000P
+ AD=21875000000P PS=560000U PD=460000U
* device instance $5539 r0 *1 43.44,66.64 nfet_01v8
M$5539 62 165 2575 167 nfet_01v8 L=150000U W=140000U AS=21875000000P
+ AD=16800000000P PS=460000U PD=380000U
* device instance $5540 r0 *1 43.96,66.64 nfet_01v8
M$5540 63 165 1862 167 nfet_01v8 L=150000U W=140000U AS=21875000000P
+ AD=16800000000P PS=460000U PD=380000U
* device instance $5541 r0 *1 87.04,44.91 nfet_01v8
M$5541 2301 154 126 167 nfet_01v8 L=150000U W=140000U AS=16800000000P
+ AD=21875000000P PS=380000U PD=460000U
* device instance $5542 r0 *1 87.56,44.91 nfet_01v8
M$5542 1021 154 127 167 nfet_01v8 L=150000U W=140000U AS=16800000000P
+ AD=21875000000P PS=380000U PD=460000U
* device instance $5543 r0 *1 87.005,45.31 nfet_01v8
M$5543 167 2619 2301 167 nfet_01v8 L=150000U W=210000U AS=21875000000P
+ AD=40400000000P PS=460000U PD=560000U
* device instance $5544 r0 *1 87.595,45.31 nfet_01v8
M$5544 167 1557 1021 167 nfet_01v8 L=150000U W=210000U AS=21875000000P
+ AD=40400000000P PS=460000U PD=560000U
* device instance $5545 r0 *1 87.005,45.7 nfet_01v8
M$5545 2619 2301 167 167 nfet_01v8 L=150000U W=210000U AS=40400000000P
+ AD=21875000000P PS=560000U PD=460000U
* device instance $5546 r0 *1 87.595,45.7 nfet_01v8
M$5546 1557 1021 167 167 nfet_01v8 L=150000U W=210000U AS=40400000000P
+ AD=21875000000P PS=560000U PD=460000U
* device instance $5547 r0 *1 87.04,46.1 nfet_01v8
M$5547 125 154 2619 167 nfet_01v8 L=150000U W=140000U AS=21875000000P
+ AD=16800000000P PS=460000U PD=380000U
* device instance $5548 r0 *1 87.56,46.1 nfet_01v8
M$5548 128 154 1557 167 nfet_01v8 L=150000U W=140000U AS=21875000000P
+ AD=16800000000P PS=460000U PD=380000U
* device instance $5549 r0 *1 87.04,46.49 nfet_01v8
M$5549 3601 155 125 167 nfet_01v8 L=150000U W=140000U AS=16800000000P
+ AD=21875000000P PS=380000U PD=460000U
* device instance $5550 r0 *1 87.56,46.49 nfet_01v8
M$5550 4505 155 128 167 nfet_01v8 L=150000U W=140000U AS=16800000000P
+ AD=21875000000P PS=380000U PD=460000U
* device instance $5551 r0 *1 87.005,46.89 nfet_01v8
M$5551 167 2250 3601 167 nfet_01v8 L=150000U W=210000U AS=21875000000P
+ AD=40400000000P PS=460000U PD=560000U
* device instance $5552 r0 *1 87.595,46.89 nfet_01v8
M$5552 167 867 4505 167 nfet_01v8 L=150000U W=210000U AS=21875000000P
+ AD=40400000000P PS=460000U PD=560000U
* device instance $5553 r0 *1 87.005,47.28 nfet_01v8
M$5553 2250 3601 167 167 nfet_01v8 L=150000U W=210000U AS=40400000000P
+ AD=21875000000P PS=560000U PD=460000U
* device instance $5554 r0 *1 87.595,47.28 nfet_01v8
M$5554 867 4505 167 167 nfet_01v8 L=150000U W=210000U AS=40400000000P
+ AD=21875000000P PS=560000U PD=460000U
* device instance $5555 r0 *1 87.04,47.68 nfet_01v8
M$5555 126 155 2250 167 nfet_01v8 L=150000U W=140000U AS=21875000000P
+ AD=16800000000P PS=460000U PD=380000U
* device instance $5556 r0 *1 87.56,47.68 nfet_01v8
M$5556 127 155 867 167 nfet_01v8 L=150000U W=140000U AS=21875000000P
+ AD=16800000000P PS=460000U PD=380000U
* device instance $5557 r0 *1 87.04,48.07 nfet_01v8
M$5557 3593 156 126 167 nfet_01v8 L=150000U W=140000U AS=16800000000P
+ AD=21875000000P PS=380000U PD=460000U
* device instance $5558 r0 *1 87.56,48.07 nfet_01v8
M$5558 1016 156 127 167 nfet_01v8 L=150000U W=140000U AS=16800000000P
+ AD=21875000000P PS=380000U PD=460000U
* device instance $5559 r0 *1 87.005,48.47 nfet_01v8
M$5559 167 2131 3593 167 nfet_01v8 L=150000U W=210000U AS=21875000000P
+ AD=40400000000P PS=460000U PD=560000U
* device instance $5560 r0 *1 87.595,48.47 nfet_01v8
M$5560 167 1551 1016 167 nfet_01v8 L=150000U W=210000U AS=21875000000P
+ AD=40400000000P PS=460000U PD=560000U
* device instance $5561 r0 *1 87.005,48.86 nfet_01v8
M$5561 2131 3593 167 167 nfet_01v8 L=150000U W=210000U AS=40400000000P
+ AD=21875000000P PS=560000U PD=460000U
* device instance $5562 r0 *1 87.595,48.86 nfet_01v8
M$5562 1551 1016 167 167 nfet_01v8 L=150000U W=210000U AS=40400000000P
+ AD=21875000000P PS=560000U PD=460000U
* device instance $5563 r0 *1 87.04,49.26 nfet_01v8
M$5563 125 156 2131 167 nfet_01v8 L=150000U W=140000U AS=21875000000P
+ AD=16800000000P PS=460000U PD=380000U
* device instance $5564 r0 *1 87.56,49.26 nfet_01v8
M$5564 128 156 1551 167 nfet_01v8 L=150000U W=140000U AS=21875000000P
+ AD=16800000000P PS=460000U PD=380000U
* device instance $5565 r0 *1 87.04,49.65 nfet_01v8
M$5565 2303 157 125 167 nfet_01v8 L=150000U W=140000U AS=16800000000P
+ AD=21875000000P PS=380000U PD=460000U
* device instance $5566 r0 *1 87.56,49.65 nfet_01v8
M$5566 1045 157 128 167 nfet_01v8 L=150000U W=140000U AS=16800000000P
+ AD=21875000000P PS=380000U PD=460000U
* device instance $5567 r0 *1 87.005,50.05 nfet_01v8
M$5567 167 2621 2303 167 nfet_01v8 L=150000U W=210000U AS=21875000000P
+ AD=40400000000P PS=460000U PD=560000U
* device instance $5568 r0 *1 87.595,50.05 nfet_01v8
M$5568 167 1587 1045 167 nfet_01v8 L=150000U W=210000U AS=21875000000P
+ AD=40400000000P PS=460000U PD=560000U
* device instance $5569 r0 *1 87.005,50.44 nfet_01v8
M$5569 2621 2303 167 167 nfet_01v8 L=150000U W=210000U AS=40400000000P
+ AD=21875000000P PS=560000U PD=460000U
* device instance $5570 r0 *1 87.595,50.44 nfet_01v8
M$5570 1587 1045 167 167 nfet_01v8 L=150000U W=210000U AS=40400000000P
+ AD=21875000000P PS=560000U PD=460000U
* device instance $5571 r0 *1 87.04,50.84 nfet_01v8
M$5571 126 157 2621 167 nfet_01v8 L=150000U W=140000U AS=21875000000P
+ AD=16800000000P PS=460000U PD=380000U
* device instance $5572 r0 *1 87.56,50.84 nfet_01v8
M$5572 127 157 1587 167 nfet_01v8 L=150000U W=140000U AS=21875000000P
+ AD=16800000000P PS=460000U PD=380000U
* device instance $5573 r0 *1 76.14,44.91 nfet_01v8
M$5573 2304 154 110 167 nfet_01v8 L=150000U W=140000U AS=16800000000P
+ AD=21875000000P PS=380000U PD=460000U
* device instance $5574 r0 *1 76.66,44.91 nfet_01v8
M$5574 1315 154 111 167 nfet_01v8 L=150000U W=140000U AS=16800000000P
+ AD=21875000000P PS=380000U PD=460000U
* device instance $5575 r0 *1 76.105,45.31 nfet_01v8
M$5575 167 2622 2304 167 nfet_01v8 L=150000U W=210000U AS=21875000000P
+ AD=40400000000P PS=460000U PD=560000U
* device instance $5576 r0 *1 76.695,45.31 nfet_01v8
M$5576 167 1895 1315 167 nfet_01v8 L=150000U W=210000U AS=21875000000P
+ AD=40400000000P PS=460000U PD=560000U
* device instance $5577 r0 *1 76.105,45.7 nfet_01v8
M$5577 2622 2304 167 167 nfet_01v8 L=150000U W=210000U AS=40400000000P
+ AD=21875000000P PS=560000U PD=460000U
* device instance $5578 r0 *1 76.695,45.7 nfet_01v8
M$5578 1895 1315 167 167 nfet_01v8 L=150000U W=210000U AS=40400000000P
+ AD=21875000000P PS=560000U PD=460000U
* device instance $5579 r0 *1 76.14,46.1 nfet_01v8
M$5579 109 154 2622 167 nfet_01v8 L=150000U W=140000U AS=21875000000P
+ AD=16800000000P PS=460000U PD=380000U
* device instance $5580 r0 *1 76.66,46.1 nfet_01v8
M$5580 112 154 1895 167 nfet_01v8 L=150000U W=140000U AS=21875000000P
+ AD=16800000000P PS=460000U PD=380000U
* device instance $5581 r0 *1 76.14,46.49 nfet_01v8
M$5581 3598 155 109 167 nfet_01v8 L=150000U W=140000U AS=16800000000P
+ AD=21875000000P PS=380000U PD=460000U
* device instance $5582 r0 *1 76.66,46.49 nfet_01v8
M$5582 4486 155 112 167 nfet_01v8 L=150000U W=140000U AS=16800000000P
+ AD=21875000000P PS=380000U PD=460000U
* device instance $5583 r0 *1 76.105,46.89 nfet_01v8
M$5583 167 2265 3598 167 nfet_01v8 L=150000U W=210000U AS=21875000000P
+ AD=40400000000P PS=460000U PD=560000U
* device instance $5584 r0 *1 76.695,46.89 nfet_01v8
M$5584 167 1876 4486 167 nfet_01v8 L=150000U W=210000U AS=21875000000P
+ AD=40400000000P PS=460000U PD=560000U
* device instance $5585 r0 *1 76.105,47.28 nfet_01v8
M$5585 2265 3598 167 167 nfet_01v8 L=150000U W=210000U AS=40400000000P
+ AD=21875000000P PS=560000U PD=460000U
* device instance $5586 r0 *1 76.695,47.28 nfet_01v8
M$5586 1876 4486 167 167 nfet_01v8 L=150000U W=210000U AS=40400000000P
+ AD=21875000000P PS=560000U PD=460000U
* device instance $5587 r0 *1 76.14,47.68 nfet_01v8
M$5587 110 155 2265 167 nfet_01v8 L=150000U W=140000U AS=21875000000P
+ AD=16800000000P PS=460000U PD=380000U
* device instance $5588 r0 *1 76.66,47.68 nfet_01v8
M$5588 111 155 1876 167 nfet_01v8 L=150000U W=140000U AS=21875000000P
+ AD=16800000000P PS=460000U PD=380000U
* device instance $5589 r0 *1 76.14,48.07 nfet_01v8
M$5589 3599 156 110 167 nfet_01v8 L=150000U W=140000U AS=16800000000P
+ AD=21875000000P PS=380000U PD=460000U
* device instance $5590 r0 *1 76.66,48.07 nfet_01v8
M$5590 620 156 111 167 nfet_01v8 L=150000U W=140000U AS=16800000000P
+ AD=21875000000P PS=380000U PD=460000U
* device instance $5591 r0 *1 76.105,48.47 nfet_01v8
M$5591 167 2625 3599 167 nfet_01v8 L=150000U W=210000U AS=21875000000P
+ AD=40400000000P PS=460000U PD=560000U
* device instance $5592 r0 *1 76.695,48.47 nfet_01v8
M$5592 167 762 620 167 nfet_01v8 L=150000U W=210000U AS=21875000000P
+ AD=40400000000P PS=460000U PD=560000U
* device instance $5593 r0 *1 76.105,48.86 nfet_01v8
M$5593 2625 3599 167 167 nfet_01v8 L=150000U W=210000U AS=40400000000P
+ AD=21875000000P PS=560000U PD=460000U
* device instance $5594 r0 *1 76.695,48.86 nfet_01v8
M$5594 762 620 167 167 nfet_01v8 L=150000U W=210000U AS=40400000000P
+ AD=21875000000P PS=560000U PD=460000U
* device instance $5595 r0 *1 76.14,49.26 nfet_01v8
M$5595 109 156 2625 167 nfet_01v8 L=150000U W=140000U AS=21875000000P
+ AD=16800000000P PS=460000U PD=380000U
* device instance $5596 r0 *1 76.66,49.26 nfet_01v8
M$5596 112 156 762 167 nfet_01v8 L=150000U W=140000U AS=21875000000P
+ AD=16800000000P PS=460000U PD=380000U
* device instance $5597 r0 *1 76.14,49.65 nfet_01v8
M$5597 2299 157 109 167 nfet_01v8 L=150000U W=140000U AS=16800000000P
+ AD=21875000000P PS=380000U PD=460000U
* device instance $5598 r0 *1 76.66,49.65 nfet_01v8
M$5598 1325 157 112 167 nfet_01v8 L=150000U W=140000U AS=16800000000P
+ AD=21875000000P PS=380000U PD=460000U
* device instance $5599 r0 *1 76.105,50.05 nfet_01v8
M$5599 167 2617 2299 167 nfet_01v8 L=150000U W=210000U AS=21875000000P
+ AD=40400000000P PS=460000U PD=560000U
* device instance $5600 r0 *1 76.695,50.05 nfet_01v8
M$5600 167 1906 1325 167 nfet_01v8 L=150000U W=210000U AS=21875000000P
+ AD=40400000000P PS=460000U PD=560000U
* device instance $5601 r0 *1 76.105,50.44 nfet_01v8
M$5601 2617 2299 167 167 nfet_01v8 L=150000U W=210000U AS=40400000000P
+ AD=21875000000P PS=560000U PD=460000U
* device instance $5602 r0 *1 76.695,50.44 nfet_01v8
M$5602 1906 1325 167 167 nfet_01v8 L=150000U W=210000U AS=40400000000P
+ AD=21875000000P PS=560000U PD=460000U
* device instance $5603 r0 *1 76.14,50.84 nfet_01v8
M$5603 110 157 2617 167 nfet_01v8 L=150000U W=140000U AS=21875000000P
+ AD=16800000000P PS=460000U PD=380000U
* device instance $5604 r0 *1 76.66,50.84 nfet_01v8
M$5604 111 157 1906 167 nfet_01v8 L=150000U W=140000U AS=21875000000P
+ AD=16800000000P PS=460000U PD=380000U
* device instance $5605 r0 *1 21.64,52.81 nfet_01v8
M$5605 2313 158 30 167 nfet_01v8 L=150000U W=140000U AS=16800000000P
+ AD=21875000000P PS=380000U PD=460000U
* device instance $5606 r0 *1 22.16,52.81 nfet_01v8
M$5606 1267 158 31 167 nfet_01v8 L=150000U W=140000U AS=16800000000P
+ AD=21875000000P PS=380000U PD=460000U
* device instance $5607 r0 *1 21.605,53.21 nfet_01v8
M$5607 167 2646 2313 167 nfet_01v8 L=150000U W=210000U AS=21875000000P
+ AD=40400000000P PS=460000U PD=560000U
* device instance $5608 r0 *1 22.195,53.21 nfet_01v8
M$5608 167 1844 1267 167 nfet_01v8 L=150000U W=210000U AS=21875000000P
+ AD=40400000000P PS=460000U PD=560000U
* device instance $5609 r0 *1 21.605,53.6 nfet_01v8
M$5609 2646 2313 167 167 nfet_01v8 L=150000U W=210000U AS=40400000000P
+ AD=21875000000P PS=560000U PD=460000U
* device instance $5610 r0 *1 22.195,53.6 nfet_01v8
M$5610 1844 1267 167 167 nfet_01v8 L=150000U W=210000U AS=40400000000P
+ AD=21875000000P PS=560000U PD=460000U
* device instance $5611 r0 *1 21.64,54 nfet_01v8
M$5611 29 158 2646 167 nfet_01v8 L=150000U W=140000U AS=21875000000P
+ AD=16800000000P PS=460000U PD=380000U
* device instance $5612 r0 *1 22.16,54 nfet_01v8
M$5612 32 158 1844 167 nfet_01v8 L=150000U W=140000U AS=21875000000P
+ AD=16800000000P PS=460000U PD=380000U
* device instance $5613 r0 *1 21.64,54.39 nfet_01v8
M$5613 3738 159 29 167 nfet_01v8 L=150000U W=140000U AS=16800000000P
+ AD=21875000000P PS=380000U PD=460000U
* device instance $5614 r0 *1 22.16,54.39 nfet_01v8
M$5614 4460 159 32 167 nfet_01v8 L=150000U W=140000U AS=16800000000P
+ AD=21875000000P PS=380000U PD=460000U
* device instance $5615 r0 *1 21.605,54.79 nfet_01v8
M$5615 167 2010 3738 167 nfet_01v8 L=150000U W=210000U AS=21875000000P
+ AD=40400000000P PS=460000U PD=560000U
* device instance $5616 r0 *1 22.195,54.79 nfet_01v8
M$5616 167 835 4460 167 nfet_01v8 L=150000U W=210000U AS=21875000000P
+ AD=40400000000P PS=460000U PD=560000U
* device instance $5617 r0 *1 21.605,55.18 nfet_01v8
M$5617 2010 3738 167 167 nfet_01v8 L=150000U W=210000U AS=40400000000P
+ AD=21875000000P PS=560000U PD=460000U
* device instance $5618 r0 *1 22.195,55.18 nfet_01v8
M$5618 835 4460 167 167 nfet_01v8 L=150000U W=210000U AS=40400000000P
+ AD=21875000000P PS=560000U PD=460000U
* device instance $5619 r0 *1 21.64,55.58 nfet_01v8
M$5619 30 159 2010 167 nfet_01v8 L=150000U W=140000U AS=21875000000P
+ AD=16800000000P PS=460000U PD=380000U
* device instance $5620 r0 *1 22.16,55.58 nfet_01v8
M$5620 31 159 835 167 nfet_01v8 L=150000U W=140000U AS=21875000000P
+ AD=16800000000P PS=460000U PD=380000U
* device instance $5621 r0 *1 21.64,55.97 nfet_01v8
M$5621 2466 160 30 167 nfet_01v8 L=150000U W=140000U AS=16800000000P
+ AD=21875000000P PS=380000U PD=460000U
* device instance $5622 r0 *1 22.16,55.97 nfet_01v8
M$5622 655 160 31 167 nfet_01v8 L=150000U W=140000U AS=16800000000P
+ AD=21875000000P PS=380000U PD=460000U
* device instance $5623 r0 *1 21.605,56.37 nfet_01v8
M$5623 167 2952 2466 167 nfet_01v8 L=150000U W=210000U AS=21875000000P
+ AD=40400000000P PS=460000U PD=560000U
* device instance $5624 r0 *1 22.195,56.37 nfet_01v8
M$5624 167 833 655 167 nfet_01v8 L=150000U W=210000U AS=21875000000P
+ AD=40400000000P PS=460000U PD=560000U
* device instance $5625 r0 *1 21.605,56.76 nfet_01v8
M$5625 2952 2466 167 167 nfet_01v8 L=150000U W=210000U AS=40400000000P
+ AD=21875000000P PS=560000U PD=460000U
* device instance $5626 r0 *1 22.195,56.76 nfet_01v8
M$5626 833 655 167 167 nfet_01v8 L=150000U W=210000U AS=40400000000P
+ AD=21875000000P PS=560000U PD=460000U
* device instance $5627 r0 *1 21.64,57.16 nfet_01v8
M$5627 29 160 2952 167 nfet_01v8 L=150000U W=140000U AS=21875000000P
+ AD=16800000000P PS=460000U PD=380000U
* device instance $5628 r0 *1 22.16,57.16 nfet_01v8
M$5628 32 160 833 167 nfet_01v8 L=150000U W=140000U AS=21875000000P
+ AD=16800000000P PS=460000U PD=380000U
* device instance $5629 r0 *1 21.64,57.55 nfet_01v8
M$5629 2468 161 29 167 nfet_01v8 L=150000U W=140000U AS=16800000000P
+ AD=21875000000P PS=380000U PD=460000U
* device instance $5630 r0 *1 22.16,57.55 nfet_01v8
M$5630 932 161 32 167 nfet_01v8 L=150000U W=140000U AS=16800000000P
+ AD=21875000000P PS=380000U PD=460000U
* device instance $5631 r0 *1 21.605,57.95 nfet_01v8
M$5631 167 2957 2468 167 nfet_01v8 L=150000U W=210000U AS=21875000000P
+ AD=40400000000P PS=460000U PD=560000U
* device instance $5632 r0 *1 22.195,57.95 nfet_01v8
M$5632 167 1450 932 167 nfet_01v8 L=150000U W=210000U AS=21875000000P
+ AD=40400000000P PS=460000U PD=560000U
* device instance $5633 r0 *1 21.605,58.34 nfet_01v8
M$5633 2957 2468 167 167 nfet_01v8 L=150000U W=210000U AS=40400000000P
+ AD=21875000000P PS=560000U PD=460000U
* device instance $5634 r0 *1 22.195,58.34 nfet_01v8
M$5634 1450 932 167 167 nfet_01v8 L=150000U W=210000U AS=40400000000P
+ AD=21875000000P PS=560000U PD=460000U
* device instance $5635 r0 *1 21.64,58.74 nfet_01v8
M$5635 30 161 2957 167 nfet_01v8 L=150000U W=140000U AS=21875000000P
+ AD=16800000000P PS=460000U PD=380000U
* device instance $5636 r0 *1 22.16,58.74 nfet_01v8
M$5636 31 161 1450 167 nfet_01v8 L=150000U W=140000U AS=21875000000P
+ AD=16800000000P PS=460000U PD=380000U
* device instance $5637 r0 *1 32.54,52.81 nfet_01v8
M$5637 3485 158 46 167 nfet_01v8 L=150000U W=140000U AS=16800000000P
+ AD=21875000000P PS=380000U PD=460000U
* device instance $5638 r0 *1 33.06,52.81 nfet_01v8
M$5638 1264 158 47 167 nfet_01v8 L=150000U W=140000U AS=16800000000P
+ AD=21875000000P PS=380000U PD=460000U
* device instance $5639 r0 *1 32.505,53.21 nfet_01v8
M$5639 167 2645 3485 167 nfet_01v8 L=150000U W=210000U AS=21875000000P
+ AD=40400000000P PS=460000U PD=560000U
* device instance $5640 r0 *1 33.095,53.21 nfet_01v8
M$5640 167 1841 1264 167 nfet_01v8 L=150000U W=210000U AS=21875000000P
+ AD=40400000000P PS=460000U PD=560000U
* device instance $5641 r0 *1 32.505,53.6 nfet_01v8
M$5641 2645 3485 167 167 nfet_01v8 L=150000U W=210000U AS=40400000000P
+ AD=21875000000P PS=560000U PD=460000U
* device instance $5642 r0 *1 33.095,53.6 nfet_01v8
M$5642 1841 1264 167 167 nfet_01v8 L=150000U W=210000U AS=40400000000P
+ AD=21875000000P PS=560000U PD=460000U
* device instance $5643 r0 *1 32.54,54 nfet_01v8
M$5643 45 158 2645 167 nfet_01v8 L=150000U W=140000U AS=21875000000P
+ AD=16800000000P PS=460000U PD=380000U
* device instance $5644 r0 *1 33.06,54 nfet_01v8
M$5644 48 158 1841 167 nfet_01v8 L=150000U W=140000U AS=21875000000P
+ AD=16800000000P PS=460000U PD=380000U
* device instance $5645 r0 *1 32.54,54.39 nfet_01v8
M$5645 3519 159 45 167 nfet_01v8 L=150000U W=140000U AS=16800000000P
+ AD=21875000000P PS=380000U PD=460000U
* device instance $5646 r0 *1 33.06,54.39 nfet_01v8
M$5646 4446 159 48 167 nfet_01v8 L=150000U W=140000U AS=16800000000P
+ AD=21875000000P PS=380000U PD=460000U
* device instance $5647 r0 *1 32.505,54.79 nfet_01v8
M$5647 167 2215 3519 167 nfet_01v8 L=150000U W=210000U AS=21875000000P
+ AD=40400000000P PS=460000U PD=560000U
* device instance $5648 r0 *1 33.095,54.79 nfet_01v8
M$5648 167 852 4446 167 nfet_01v8 L=150000U W=210000U AS=21875000000P
+ AD=40400000000P PS=460000U PD=560000U
* device instance $5649 r0 *1 32.505,55.18 nfet_01v8
M$5649 2215 3519 167 167 nfet_01v8 L=150000U W=210000U AS=40400000000P
+ AD=21875000000P PS=560000U PD=460000U
* device instance $5650 r0 *1 33.095,55.18 nfet_01v8
M$5650 852 4446 167 167 nfet_01v8 L=150000U W=210000U AS=40400000000P
+ AD=21875000000P PS=560000U PD=460000U
* device instance $5651 r0 *1 32.54,55.58 nfet_01v8
M$5651 46 159 2215 167 nfet_01v8 L=150000U W=140000U AS=21875000000P
+ AD=16800000000P PS=460000U PD=380000U
* device instance $5652 r0 *1 33.06,55.58 nfet_01v8
M$5652 47 159 852 167 nfet_01v8 L=150000U W=140000U AS=21875000000P
+ AD=16800000000P PS=460000U PD=380000U
* device instance $5653 r0 *1 32.54,55.97 nfet_01v8
M$5653 2312 160 46 167 nfet_01v8 L=150000U W=140000U AS=16800000000P
+ AD=21875000000P PS=380000U PD=460000U
* device instance $5654 r0 *1 33.06,55.97 nfet_01v8
M$5654 645 160 47 167 nfet_01v8 L=150000U W=140000U AS=16800000000P
+ AD=21875000000P PS=380000U PD=460000U
* device instance $5655 r0 *1 32.505,56.37 nfet_01v8
M$5655 167 2644 2312 167 nfet_01v8 L=150000U W=210000U AS=21875000000P
+ AD=40400000000P PS=460000U PD=560000U
* device instance $5656 r0 *1 33.095,56.37 nfet_01v8
M$5656 167 806 645 167 nfet_01v8 L=150000U W=210000U AS=21875000000P
+ AD=40400000000P PS=460000U PD=560000U
* device instance $5657 r0 *1 32.505,56.76 nfet_01v8
M$5657 2644 2312 167 167 nfet_01v8 L=150000U W=210000U AS=40400000000P
+ AD=21875000000P PS=560000U PD=460000U
* device instance $5658 r0 *1 33.095,56.76 nfet_01v8
M$5658 806 645 167 167 nfet_01v8 L=150000U W=210000U AS=40400000000P
+ AD=21875000000P PS=560000U PD=460000U
* device instance $5659 r0 *1 32.54,57.16 nfet_01v8
M$5659 45 160 2644 167 nfet_01v8 L=150000U W=140000U AS=21875000000P
+ AD=16800000000P PS=460000U PD=380000U
* device instance $5660 r0 *1 33.06,57.16 nfet_01v8
M$5660 48 160 806 167 nfet_01v8 L=150000U W=140000U AS=21875000000P
+ AD=16800000000P PS=460000U PD=380000U
* device instance $5661 r0 *1 32.54,57.55 nfet_01v8
M$5661 3549 161 45 167 nfet_01v8 L=150000U W=140000U AS=16800000000P
+ AD=21875000000P PS=380000U PD=460000U
* device instance $5662 r0 *1 33.06,57.55 nfet_01v8
M$5662 921 161 48 167 nfet_01v8 L=150000U W=140000U AS=16800000000P
+ AD=21875000000P PS=380000U PD=460000U
* device instance $5663 r0 *1 32.505,57.95 nfet_01v8
M$5663 167 2623 3549 167 nfet_01v8 L=150000U W=210000U AS=21875000000P
+ AD=40400000000P PS=460000U PD=560000U
* device instance $5664 r0 *1 33.095,57.95 nfet_01v8
M$5664 167 1439 921 167 nfet_01v8 L=150000U W=210000U AS=21875000000P
+ AD=40400000000P PS=460000U PD=560000U
* device instance $5665 r0 *1 32.505,58.34 nfet_01v8
M$5665 2623 3549 167 167 nfet_01v8 L=150000U W=210000U AS=40400000000P
+ AD=21875000000P PS=560000U PD=460000U
* device instance $5666 r0 *1 33.095,58.34 nfet_01v8
M$5666 1439 921 167 167 nfet_01v8 L=150000U W=210000U AS=40400000000P
+ AD=21875000000P PS=560000U PD=460000U
* device instance $5667 r0 *1 32.54,58.74 nfet_01v8
M$5667 46 161 2623 167 nfet_01v8 L=150000U W=140000U AS=21875000000P
+ AD=16800000000P PS=460000U PD=380000U
* device instance $5668 r0 *1 33.06,58.74 nfet_01v8
M$5668 47 161 1439 167 nfet_01v8 L=150000U W=140000U AS=21875000000P
+ AD=16800000000P PS=460000U PD=380000U
* device instance $5669 r0 *1 43.44,52.81 nfet_01v8
M$5669 2311 158 62 167 nfet_01v8 L=150000U W=140000U AS=16800000000P
+ AD=21875000000P PS=380000U PD=460000U
* device instance $5670 r0 *1 43.96,52.81 nfet_01v8
M$5670 1261 158 63 167 nfet_01v8 L=150000U W=140000U AS=16800000000P
+ AD=21875000000P PS=380000U PD=460000U
* device instance $5671 r0 *1 43.405,53.21 nfet_01v8
M$5671 167 2643 2311 167 nfet_01v8 L=150000U W=210000U AS=21875000000P
+ AD=40400000000P PS=460000U PD=560000U
* device instance $5672 r0 *1 43.995,53.21 nfet_01v8
M$5672 167 1838 1261 167 nfet_01v8 L=150000U W=210000U AS=21875000000P
+ AD=40400000000P PS=460000U PD=560000U
* device instance $5673 r0 *1 43.405,53.6 nfet_01v8
M$5673 2643 2311 167 167 nfet_01v8 L=150000U W=210000U AS=40400000000P
+ AD=21875000000P PS=560000U PD=460000U
* device instance $5674 r0 *1 43.995,53.6 nfet_01v8
M$5674 1838 1261 167 167 nfet_01v8 L=150000U W=210000U AS=40400000000P
+ AD=21875000000P PS=560000U PD=460000U
* device instance $5675 r0 *1 43.44,54 nfet_01v8
M$5675 61 158 2643 167 nfet_01v8 L=150000U W=140000U AS=21875000000P
+ AD=16800000000P PS=460000U PD=380000U
* device instance $5676 r0 *1 43.96,54 nfet_01v8
M$5676 64 158 1838 167 nfet_01v8 L=150000U W=140000U AS=21875000000P
+ AD=16800000000P PS=460000U PD=380000U
* device instance $5677 r0 *1 43.44,54.39 nfet_01v8
M$5677 3527 159 61 167 nfet_01v8 L=150000U W=140000U AS=16800000000P
+ AD=21875000000P PS=380000U PD=460000U
* device instance $5678 r0 *1 43.96,54.39 nfet_01v8
M$5678 4439 159 64 167 nfet_01v8 L=150000U W=140000U AS=16800000000P
+ AD=21875000000P PS=380000U PD=460000U
* device instance $5679 r0 *1 43.405,54.79 nfet_01v8
M$5679 167 3007 3527 167 nfet_01v8 L=150000U W=210000U AS=21875000000P
+ AD=40400000000P PS=460000U PD=560000U
* device instance $5680 r0 *1 43.995,54.79 nfet_01v8
M$5680 167 1437 4439 167 nfet_01v8 L=150000U W=210000U AS=21875000000P
+ AD=40400000000P PS=460000U PD=560000U
* device instance $5681 r0 *1 43.405,55.18 nfet_01v8
M$5681 3007 3527 167 167 nfet_01v8 L=150000U W=210000U AS=40400000000P
+ AD=21875000000P PS=560000U PD=460000U
* device instance $5682 r0 *1 43.995,55.18 nfet_01v8
M$5682 1437 4439 167 167 nfet_01v8 L=150000U W=210000U AS=40400000000P
+ AD=21875000000P PS=560000U PD=460000U
* device instance $5683 r0 *1 43.44,55.58 nfet_01v8
M$5683 62 159 3007 167 nfet_01v8 L=150000U W=140000U AS=21875000000P
+ AD=16800000000P PS=460000U PD=380000U
* device instance $5684 r0 *1 43.96,55.58 nfet_01v8
M$5684 63 159 1437 167 nfet_01v8 L=150000U W=140000U AS=21875000000P
+ AD=16800000000P PS=460000U PD=380000U
* device instance $5685 r0 *1 43.44,55.97 nfet_01v8
M$5685 2114 160 62 167 nfet_01v8 L=150000U W=140000U AS=16800000000P
+ AD=21875000000P PS=380000U PD=460000U
* device instance $5686 r0 *1 43.96,55.97 nfet_01v8
M$5686 589 160 63 167 nfet_01v8 L=150000U W=140000U AS=16800000000P
+ AD=21875000000P PS=380000U PD=460000U
* device instance $5687 r0 *1 43.405,56.37 nfet_01v8
M$5687 167 2237 2114 167 nfet_01v8 L=150000U W=210000U AS=21875000000P
+ AD=40400000000P PS=460000U PD=560000U
* device instance $5688 r0 *1 43.995,56.37 nfet_01v8
M$5688 167 699 589 167 nfet_01v8 L=150000U W=210000U AS=21875000000P
+ AD=40400000000P PS=460000U PD=560000U
* device instance $5689 r0 *1 43.405,56.76 nfet_01v8
M$5689 2237 2114 167 167 nfet_01v8 L=150000U W=210000U AS=40400000000P
+ AD=21875000000P PS=560000U PD=460000U
* device instance $5690 r0 *1 43.995,56.76 nfet_01v8
M$5690 699 589 167 167 nfet_01v8 L=150000U W=210000U AS=40400000000P
+ AD=21875000000P PS=560000U PD=460000U
* device instance $5691 r0 *1 43.44,57.16 nfet_01v8
M$5691 61 160 2237 167 nfet_01v8 L=150000U W=140000U AS=21875000000P
+ AD=16800000000P PS=460000U PD=380000U
* device instance $5692 r0 *1 43.96,57.16 nfet_01v8
M$5692 64 160 699 167 nfet_01v8 L=150000U W=140000U AS=21875000000P
+ AD=16800000000P PS=460000U PD=380000U
* device instance $5693 r0 *1 43.44,57.55 nfet_01v8
M$5693 2490 161 61 167 nfet_01v8 L=150000U W=140000U AS=16800000000P
+ AD=21875000000P PS=380000U PD=460000U
* device instance $5694 r0 *1 43.96,57.55 nfet_01v8
M$5694 910 161 64 167 nfet_01v8 L=150000U W=140000U AS=16800000000P
+ AD=21875000000P PS=380000U PD=460000U
* device instance $5695 r0 *1 43.405,57.95 nfet_01v8
M$5695 167 3000 2490 167 nfet_01v8 L=150000U W=210000U AS=21875000000P
+ AD=40400000000P PS=460000U PD=560000U
* device instance $5696 r0 *1 43.995,57.95 nfet_01v8
M$5696 167 1427 910 167 nfet_01v8 L=150000U W=210000U AS=21875000000P
+ AD=40400000000P PS=460000U PD=560000U
* device instance $5697 r0 *1 43.405,58.34 nfet_01v8
M$5697 3000 2490 167 167 nfet_01v8 L=150000U W=210000U AS=40400000000P
+ AD=21875000000P PS=560000U PD=460000U
* device instance $5698 r0 *1 43.995,58.34 nfet_01v8
M$5698 1427 910 167 167 nfet_01v8 L=150000U W=210000U AS=40400000000P
+ AD=21875000000P PS=560000U PD=460000U
* device instance $5699 r0 *1 43.44,58.74 nfet_01v8
M$5699 62 161 3000 167 nfet_01v8 L=150000U W=140000U AS=21875000000P
+ AD=16800000000P PS=460000U PD=380000U
* device instance $5700 r0 *1 43.96,58.74 nfet_01v8
M$5700 63 161 1427 167 nfet_01v8 L=150000U W=140000U AS=21875000000P
+ AD=16800000000P PS=460000U PD=380000U
* device instance $5701 r0 *1 54.34,52.81 nfet_01v8
M$5701 3170 158 78 167 nfet_01v8 L=150000U W=140000U AS=16800000000P
+ AD=21875000000P PS=380000U PD=460000U
* device instance $5702 r0 *1 54.86,52.81 nfet_01v8
M$5702 1086 158 79 167 nfet_01v8 L=150000U W=140000U AS=16800000000P
+ AD=21875000000P PS=380000U PD=460000U
* device instance $5703 r0 *1 54.305,53.21 nfet_01v8
M$5703 167 3075 3170 167 nfet_01v8 L=150000U W=210000U AS=21875000000P
+ AD=40400000000P PS=460000U PD=560000U
* device instance $5704 r0 *1 54.895,53.21 nfet_01v8
M$5704 167 1632 1086 167 nfet_01v8 L=150000U W=210000U AS=21875000000P
+ AD=40400000000P PS=460000U PD=560000U
* device instance $5705 r0 *1 54.305,53.6 nfet_01v8
M$5705 3075 3170 167 167 nfet_01v8 L=150000U W=210000U AS=40400000000P
+ AD=21875000000P PS=560000U PD=460000U
* device instance $5706 r0 *1 54.895,53.6 nfet_01v8
M$5706 1632 1086 167 167 nfet_01v8 L=150000U W=210000U AS=40400000000P
+ AD=21875000000P PS=560000U PD=460000U
* device instance $5707 r0 *1 54.34,54 nfet_01v8
M$5707 77 158 3075 167 nfet_01v8 L=150000U W=140000U AS=21875000000P
+ AD=16800000000P PS=460000U PD=380000U
* device instance $5708 r0 *1 54.86,54 nfet_01v8
M$5708 80 158 1632 167 nfet_01v8 L=150000U W=140000U AS=21875000000P
+ AD=16800000000P PS=460000U PD=380000U
* device instance $5709 r0 *1 54.34,54.39 nfet_01v8
M$5709 3570 159 77 167 nfet_01v8 L=150000U W=140000U AS=16800000000P
+ AD=21875000000P PS=380000U PD=460000U
* device instance $5710 r0 *1 54.86,54.39 nfet_01v8
M$5710 4345 159 80 167 nfet_01v8 L=150000U W=140000U AS=16800000000P
+ AD=21875000000P PS=380000U PD=460000U
* device instance $5711 r0 *1 54.305,54.79 nfet_01v8
M$5711 167 2566 3570 167 nfet_01v8 L=150000U W=210000U AS=21875000000P
+ AD=40400000000P PS=460000U PD=560000U
* device instance $5712 r0 *1 54.895,54.79 nfet_01v8
M$5712 167 742 4345 167 nfet_01v8 L=150000U W=210000U AS=21875000000P
+ AD=40400000000P PS=460000U PD=560000U
* device instance $5713 r0 *1 54.305,55.18 nfet_01v8
M$5713 2566 3570 167 167 nfet_01v8 L=150000U W=210000U AS=40400000000P
+ AD=21875000000P PS=560000U PD=460000U
* device instance $5714 r0 *1 54.895,55.18 nfet_01v8
M$5714 742 4345 167 167 nfet_01v8 L=150000U W=210000U AS=40400000000P
+ AD=21875000000P PS=560000U PD=460000U
* device instance $5715 r0 *1 54.34,55.58 nfet_01v8
M$5715 78 159 2566 167 nfet_01v8 L=150000U W=140000U AS=21875000000P
+ AD=16800000000P PS=460000U PD=380000U
* device instance $5716 r0 *1 54.86,55.58 nfet_01v8
M$5716 79 159 742 167 nfet_01v8 L=150000U W=140000U AS=21875000000P
+ AD=16800000000P PS=460000U PD=380000U
* device instance $5717 r0 *1 54.34,55.97 nfet_01v8
M$5717 3571 160 78 167 nfet_01v8 L=150000U W=140000U AS=16800000000P
+ AD=21875000000P PS=380000U PD=460000U
* device instance $5718 r0 *1 54.86,55.97 nfet_01v8
M$5718 593 160 79 167 nfet_01v8 L=150000U W=140000U AS=16800000000P
+ AD=21875000000P PS=380000U PD=460000U
* device instance $5719 r0 *1 54.305,56.37 nfet_01v8
M$5719 167 2570 3571 167 nfet_01v8 L=150000U W=210000U AS=21875000000P
+ AD=40400000000P PS=460000U PD=560000U
* device instance $5720 r0 *1 54.895,56.37 nfet_01v8
M$5720 167 705 593 167 nfet_01v8 L=150000U W=210000U AS=21875000000P
+ AD=40400000000P PS=460000U PD=560000U
* device instance $5721 r0 *1 54.305,56.76 nfet_01v8
M$5721 2570 3571 167 167 nfet_01v8 L=150000U W=210000U AS=40400000000P
+ AD=21875000000P PS=560000U PD=460000U
* device instance $5722 r0 *1 54.895,56.76 nfet_01v8
M$5722 705 593 167 167 nfet_01v8 L=150000U W=210000U AS=40400000000P
+ AD=21875000000P PS=560000U PD=460000U
* device instance $5723 r0 *1 54.34,57.16 nfet_01v8
M$5723 77 160 2570 167 nfet_01v8 L=150000U W=140000U AS=21875000000P
+ AD=16800000000P PS=460000U PD=380000U
* device instance $5724 r0 *1 54.86,57.16 nfet_01v8
M$5724 80 160 705 167 nfet_01v8 L=150000U W=140000U AS=21875000000P
+ AD=16800000000P PS=460000U PD=380000U
* device instance $5725 r0 *1 54.34,57.55 nfet_01v8
M$5725 3160 161 77 167 nfet_01v8 L=150000U W=140000U AS=16800000000P
+ AD=21875000000P PS=380000U PD=460000U
* device instance $5726 r0 *1 54.86,57.55 nfet_01v8
M$5726 1103 161 80 167 nfet_01v8 L=150000U W=140000U AS=16800000000P
+ AD=21875000000P PS=380000U PD=460000U
* device instance $5727 r0 *1 54.305,57.95 nfet_01v8
M$5727 167 2553 3160 167 nfet_01v8 L=150000U W=210000U AS=21875000000P
+ AD=40400000000P PS=460000U PD=560000U
* device instance $5728 r0 *1 54.895,57.95 nfet_01v8
M$5728 167 1655 1103 167 nfet_01v8 L=150000U W=210000U AS=21875000000P
+ AD=40400000000P PS=460000U PD=560000U
* device instance $5729 r0 *1 54.305,58.34 nfet_01v8
M$5729 2553 3160 167 167 nfet_01v8 L=150000U W=210000U AS=40400000000P
+ AD=21875000000P PS=560000U PD=460000U
* device instance $5730 r0 *1 54.895,58.34 nfet_01v8
M$5730 1655 1103 167 167 nfet_01v8 L=150000U W=210000U AS=40400000000P
+ AD=21875000000P PS=560000U PD=460000U
* device instance $5731 r0 *1 54.34,58.74 nfet_01v8
M$5731 78 161 2553 167 nfet_01v8 L=150000U W=140000U AS=21875000000P
+ AD=16800000000P PS=460000U PD=380000U
* device instance $5732 r0 *1 54.86,58.74 nfet_01v8
M$5732 79 161 1655 167 nfet_01v8 L=150000U W=140000U AS=21875000000P
+ AD=16800000000P PS=460000U PD=380000U
* device instance $5733 r0 *1 65.24,52.81 nfet_01v8
M$5733 2513 158 94 167 nfet_01v8 L=150000U W=140000U AS=16800000000P
+ AD=21875000000P PS=380000U PD=460000U
* device instance $5734 r0 *1 65.76,52.81 nfet_01v8
M$5734 1082 158 95 167 nfet_01v8 L=150000U W=140000U AS=16800000000P
+ AD=21875000000P PS=380000U PD=460000U
* device instance $5735 r0 *1 65.205,53.21 nfet_01v8
M$5735 167 3062 2513 167 nfet_01v8 L=150000U W=210000U AS=21875000000P
+ AD=40400000000P PS=460000U PD=560000U
* device instance $5736 r0 *1 65.795,53.21 nfet_01v8
M$5736 167 1628 1082 167 nfet_01v8 L=150000U W=210000U AS=21875000000P
+ AD=40400000000P PS=460000U PD=560000U
* device instance $5737 r0 *1 65.205,53.6 nfet_01v8
M$5737 3062 2513 167 167 nfet_01v8 L=150000U W=210000U AS=40400000000P
+ AD=21875000000P PS=560000U PD=460000U
* device instance $5738 r0 *1 65.795,53.6 nfet_01v8
M$5738 1628 1082 167 167 nfet_01v8 L=150000U W=210000U AS=40400000000P
+ AD=21875000000P PS=560000U PD=460000U
* device instance $5739 r0 *1 65.24,54 nfet_01v8
M$5739 93 158 3062 167 nfet_01v8 L=150000U W=140000U AS=21875000000P
+ AD=16800000000P PS=460000U PD=380000U
* device instance $5740 r0 *1 65.76,54 nfet_01v8
M$5740 96 158 1628 167 nfet_01v8 L=150000U W=140000U AS=21875000000P
+ AD=16800000000P PS=460000U PD=380000U
* device instance $5741 r0 *1 65.24,54.39 nfet_01v8
M$5741 3581 159 93 167 nfet_01v8 L=150000U W=140000U AS=16800000000P
+ AD=21875000000P PS=380000U PD=460000U
* device instance $5742 r0 *1 65.76,54.39 nfet_01v8
M$5742 4328 159 96 167 nfet_01v8 L=150000U W=140000U AS=16800000000P
+ AD=21875000000P PS=380000U PD=460000U
* device instance $5743 r0 *1 65.205,54.79 nfet_01v8
M$5743 167 2002 3581 167 nfet_01v8 L=150000U W=210000U AS=21875000000P
+ AD=40400000000P PS=460000U PD=560000U
* device instance $5744 r0 *1 65.795,54.79 nfet_01v8
M$5744 167 745 4328 167 nfet_01v8 L=150000U W=210000U AS=21875000000P
+ AD=40400000000P PS=460000U PD=560000U
* device instance $5745 r0 *1 65.205,55.18 nfet_01v8
M$5745 2002 3581 167 167 nfet_01v8 L=150000U W=210000U AS=40400000000P
+ AD=21875000000P PS=560000U PD=460000U
* device instance $5746 r0 *1 65.795,55.18 nfet_01v8
M$5746 745 4328 167 167 nfet_01v8 L=150000U W=210000U AS=40400000000P
+ AD=21875000000P PS=560000U PD=460000U
* device instance $5747 r0 *1 65.24,55.58 nfet_01v8
M$5747 94 159 2002 167 nfet_01v8 L=150000U W=140000U AS=21875000000P
+ AD=16800000000P PS=460000U PD=380000U
* device instance $5748 r0 *1 65.76,55.58 nfet_01v8
M$5748 95 159 745 167 nfet_01v8 L=150000U W=140000U AS=21875000000P
+ AD=16800000000P PS=460000U PD=380000U
* device instance $5749 r0 *1 65.24,55.97 nfet_01v8
M$5749 2099 160 94 167 nfet_01v8 L=150000U W=140000U AS=16800000000P
+ AD=21875000000P PS=380000U PD=460000U
* device instance $5750 r0 *1 65.76,55.97 nfet_01v8
M$5750 1083 160 95 167 nfet_01v8 L=150000U W=140000U AS=16800000000P
+ AD=21875000000P PS=380000U PD=460000U
* device instance $5751 r0 *1 65.205,56.37 nfet_01v8
M$5751 167 2197 2099 167 nfet_01v8 L=150000U W=210000U AS=21875000000P
+ AD=40400000000P PS=460000U PD=560000U
* device instance $5752 r0 *1 65.795,56.37 nfet_01v8
M$5752 167 1629 1083 167 nfet_01v8 L=150000U W=210000U AS=21875000000P
+ AD=40400000000P PS=460000U PD=560000U
* device instance $5753 r0 *1 65.205,56.76 nfet_01v8
M$5753 2197 2099 167 167 nfet_01v8 L=150000U W=210000U AS=40400000000P
+ AD=21875000000P PS=560000U PD=460000U
* device instance $5754 r0 *1 65.795,56.76 nfet_01v8
M$5754 1629 1083 167 167 nfet_01v8 L=150000U W=210000U AS=40400000000P
+ AD=21875000000P PS=560000U PD=460000U
* device instance $5755 r0 *1 65.24,57.16 nfet_01v8
M$5755 93 160 2197 167 nfet_01v8 L=150000U W=140000U AS=21875000000P
+ AD=16800000000P PS=460000U PD=380000U
* device instance $5756 r0 *1 65.76,57.16 nfet_01v8
M$5756 96 160 1629 167 nfet_01v8 L=150000U W=140000U AS=21875000000P
+ AD=16800000000P PS=460000U PD=380000U
* device instance $5757 r0 *1 65.24,57.55 nfet_01v8
M$5757 3585 161 93 167 nfet_01v8 L=150000U W=140000U AS=16800000000P
+ AD=21875000000P PS=380000U PD=460000U
* device instance $5758 r0 *1 65.76,57.55 nfet_01v8
M$5758 1079 161 96 167 nfet_01v8 L=150000U W=140000U AS=16800000000P
+ AD=21875000000P PS=380000U PD=460000U
* device instance $5759 r0 *1 65.205,57.95 nfet_01v8
M$5759 167 2550 3585 167 nfet_01v8 L=150000U W=210000U AS=21875000000P
+ AD=40400000000P PS=460000U PD=560000U
* device instance $5760 r0 *1 65.795,57.95 nfet_01v8
M$5760 167 1624 1079 167 nfet_01v8 L=150000U W=210000U AS=21875000000P
+ AD=40400000000P PS=460000U PD=560000U
* device instance $5761 r0 *1 65.205,58.34 nfet_01v8
M$5761 2550 3585 167 167 nfet_01v8 L=150000U W=210000U AS=40400000000P
+ AD=21875000000P PS=560000U PD=460000U
* device instance $5762 r0 *1 65.795,58.34 nfet_01v8
M$5762 1624 1079 167 167 nfet_01v8 L=150000U W=210000U AS=40400000000P
+ AD=21875000000P PS=560000U PD=460000U
* device instance $5763 r0 *1 65.24,58.74 nfet_01v8
M$5763 94 161 2550 167 nfet_01v8 L=150000U W=140000U AS=21875000000P
+ AD=16800000000P PS=460000U PD=380000U
* device instance $5764 r0 *1 65.76,58.74 nfet_01v8
M$5764 95 161 1624 167 nfet_01v8 L=150000U W=140000U AS=21875000000P
+ AD=16800000000P PS=460000U PD=380000U
* device instance $5765 r0 *1 10.74,52.81 nfet_01v8
M$5765 2310 158 14 167 nfet_01v8 L=150000U W=140000U AS=16800000000P
+ AD=21875000000P PS=380000U PD=460000U
* device instance $5766 r0 *1 11.26,52.81 nfet_01v8
M$5766 1260 158 15 167 nfet_01v8 L=150000U W=140000U AS=16800000000P
+ AD=21875000000P PS=380000U PD=460000U
* device instance $5767 r0 *1 10.705,53.21 nfet_01v8
M$5767 167 2642 2310 167 nfet_01v8 L=150000U W=210000U AS=21875000000P
+ AD=40400000000P PS=460000U PD=560000U
* device instance $5768 r0 *1 11.295,53.21 nfet_01v8
M$5768 167 1836 1260 167 nfet_01v8 L=150000U W=210000U AS=21875000000P
+ AD=40400000000P PS=460000U PD=560000U
* device instance $5769 r0 *1 10.705,53.6 nfet_01v8
M$5769 2642 2310 167 167 nfet_01v8 L=150000U W=210000U AS=40400000000P
+ AD=21875000000P PS=560000U PD=460000U
* device instance $5770 r0 *1 11.295,53.6 nfet_01v8
M$5770 1836 1260 167 167 nfet_01v8 L=150000U W=210000U AS=40400000000P
+ AD=21875000000P PS=560000U PD=460000U
* device instance $5771 r0 *1 10.74,54 nfet_01v8
M$5771 13 158 2642 167 nfet_01v8 L=150000U W=140000U AS=21875000000P
+ AD=16800000000P PS=460000U PD=380000U
* device instance $5772 r0 *1 11.26,54 nfet_01v8
M$5772 16 158 1836 167 nfet_01v8 L=150000U W=140000U AS=21875000000P
+ AD=16800000000P PS=460000U PD=380000U
* device instance $5773 r0 *1 10.74,54.39 nfet_01v8
M$5773 3696 159 13 167 nfet_01v8 L=150000U W=140000U AS=16800000000P
+ AD=21875000000P PS=380000U PD=460000U
* device instance $5774 r0 *1 11.26,54.39 nfet_01v8
M$5774 4433 159 16 167 nfet_01v8 L=150000U W=140000U AS=16800000000P
+ AD=21875000000P PS=380000U PD=460000U
* device instance $5775 r0 *1 10.705,54.79 nfet_01v8
M$5775 167 2261 3696 167 nfet_01v8 L=150000U W=210000U AS=21875000000P
+ AD=40400000000P PS=460000U PD=560000U
* device instance $5776 r0 *1 11.295,54.79 nfet_01v8
M$5776 167 1454 4433 167 nfet_01v8 L=150000U W=210000U AS=21875000000P
+ AD=40400000000P PS=460000U PD=560000U
* device instance $5777 r0 *1 10.705,55.18 nfet_01v8
M$5777 2261 3696 167 167 nfet_01v8 L=150000U W=210000U AS=40400000000P
+ AD=21875000000P PS=560000U PD=460000U
* device instance $5778 r0 *1 11.295,55.18 nfet_01v8
M$5778 1454 4433 167 167 nfet_01v8 L=150000U W=210000U AS=40400000000P
+ AD=21875000000P PS=560000U PD=460000U
* device instance $5779 r0 *1 10.74,55.58 nfet_01v8
M$5779 14 159 2261 167 nfet_01v8 L=150000U W=140000U AS=21875000000P
+ AD=16800000000P PS=460000U PD=380000U
* device instance $5780 r0 *1 11.26,55.58 nfet_01v8
M$5780 15 159 1454 167 nfet_01v8 L=150000U W=140000U AS=21875000000P
+ AD=16800000000P PS=460000U PD=380000U
* device instance $5781 r0 *1 10.74,55.97 nfet_01v8
M$5781 2456 160 14 167 nfet_01v8 L=150000U W=140000U AS=16800000000P
+ AD=21875000000P PS=380000U PD=460000U
* device instance $5782 r0 *1 11.26,55.97 nfet_01v8
M$5782 923 160 15 167 nfet_01v8 L=150000U W=140000U AS=16800000000P
+ AD=21875000000P PS=380000U PD=460000U
* device instance $5783 r0 *1 10.705,56.37 nfet_01v8
M$5783 167 2933 2456 167 nfet_01v8 L=150000U W=210000U AS=21875000000P
+ AD=40400000000P PS=460000U PD=560000U
* device instance $5784 r0 *1 11.295,56.37 nfet_01v8
M$5784 167 1441 923 167 nfet_01v8 L=150000U W=210000U AS=21875000000P
+ AD=40400000000P PS=460000U PD=560000U
* device instance $5785 r0 *1 10.705,56.76 nfet_01v8
M$5785 2933 2456 167 167 nfet_01v8 L=150000U W=210000U AS=40400000000P
+ AD=21875000000P PS=560000U PD=460000U
* device instance $5786 r0 *1 11.295,56.76 nfet_01v8
M$5786 1441 923 167 167 nfet_01v8 L=150000U W=210000U AS=40400000000P
+ AD=21875000000P PS=560000U PD=460000U
* device instance $5787 r0 *1 10.74,57.16 nfet_01v8
M$5787 13 160 2933 167 nfet_01v8 L=150000U W=140000U AS=21875000000P
+ AD=16800000000P PS=460000U PD=380000U
* device instance $5788 r0 *1 11.26,57.16 nfet_01v8
M$5788 16 160 1441 167 nfet_01v8 L=150000U W=140000U AS=21875000000P
+ AD=16800000000P PS=460000U PD=380000U
* device instance $5789 r0 *1 10.74,57.55 nfet_01v8
M$5789 3710 161 13 167 nfet_01v8 L=150000U W=140000U AS=16800000000P
+ AD=21875000000P PS=380000U PD=460000U
* device instance $5790 r0 *1 11.26,57.55 nfet_01v8
M$5790 931 161 16 167 nfet_01v8 L=150000U W=140000U AS=16800000000P
+ AD=21875000000P PS=380000U PD=460000U
* device instance $5791 r0 *1 10.705,57.95 nfet_01v8
M$5791 167 2946 3710 167 nfet_01v8 L=150000U W=210000U AS=21875000000P
+ AD=40400000000P PS=460000U PD=560000U
* device instance $5792 r0 *1 11.295,57.95 nfet_01v8
M$5792 167 1449 931 167 nfet_01v8 L=150000U W=210000U AS=21875000000P
+ AD=40400000000P PS=460000U PD=560000U
* device instance $5793 r0 *1 10.705,58.34 nfet_01v8
M$5793 2946 3710 167 167 nfet_01v8 L=150000U W=210000U AS=40400000000P
+ AD=21875000000P PS=560000U PD=460000U
* device instance $5794 r0 *1 11.295,58.34 nfet_01v8
M$5794 1449 931 167 167 nfet_01v8 L=150000U W=210000U AS=40400000000P
+ AD=21875000000P PS=560000U PD=460000U
* device instance $5795 r0 *1 10.74,58.74 nfet_01v8
M$5795 14 161 2946 167 nfet_01v8 L=150000U W=140000U AS=21875000000P
+ AD=16800000000P PS=460000U PD=380000U
* device instance $5796 r0 *1 11.26,58.74 nfet_01v8
M$5796 15 161 1449 167 nfet_01v8 L=150000U W=140000U AS=21875000000P
+ AD=16800000000P PS=460000U PD=380000U
* device instance $5797 r0 *1 76.14,52.81 nfet_01v8
M$5797 3146 158 110 167 nfet_01v8 L=150000U W=140000U AS=16800000000P
+ AD=21875000000P PS=380000U PD=460000U
* device instance $5798 r0 *1 76.66,52.81 nfet_01v8
M$5798 1166 158 111 167 nfet_01v8 L=150000U W=140000U AS=16800000000P
+ AD=21875000000P PS=380000U PD=460000U
* device instance $5799 r0 *1 76.105,53.21 nfet_01v8
M$5799 167 3101 3146 167 nfet_01v8 L=150000U W=210000U AS=21875000000P
+ AD=40400000000P PS=460000U PD=560000U
* device instance $5800 r0 *1 76.695,53.21 nfet_01v8
M$5800 167 1727 1166 167 nfet_01v8 L=150000U W=210000U AS=21875000000P
+ AD=40400000000P PS=460000U PD=560000U
* device instance $5801 r0 *1 76.105,53.6 nfet_01v8
M$5801 3101 3146 167 167 nfet_01v8 L=150000U W=210000U AS=40400000000P
+ AD=21875000000P PS=560000U PD=460000U
* device instance $5802 r0 *1 76.695,53.6 nfet_01v8
M$5802 1727 1166 167 167 nfet_01v8 L=150000U W=210000U AS=40400000000P
+ AD=21875000000P PS=560000U PD=460000U
* device instance $5803 r0 *1 76.14,54 nfet_01v8
M$5803 109 158 3101 167 nfet_01v8 L=150000U W=140000U AS=21875000000P
+ AD=16800000000P PS=460000U PD=380000U
* device instance $5804 r0 *1 76.66,54 nfet_01v8
M$5804 112 158 1727 167 nfet_01v8 L=150000U W=140000U AS=21875000000P
+ AD=16800000000P PS=460000U PD=380000U
* device instance $5805 r0 *1 76.14,54.39 nfet_01v8
M$5805 3137 159 109 167 nfet_01v8 L=150000U W=140000U AS=16800000000P
+ AD=21875000000P PS=380000U PD=460000U
* device instance $5806 r0 *1 76.66,54.39 nfet_01v8
M$5806 4415 159 112 167 nfet_01v8 L=150000U W=140000U AS=16800000000P
+ AD=21875000000P PS=380000U PD=460000U
* device instance $5807 r0 *1 76.105,54.79 nfet_01v8
M$5807 167 2883 3137 167 nfet_01v8 L=150000U W=210000U AS=21875000000P
+ AD=40400000000P PS=460000U PD=560000U
* device instance $5808 r0 *1 76.695,54.79 nfet_01v8
M$5808 167 1763 4415 167 nfet_01v8 L=150000U W=210000U AS=21875000000P
+ AD=40400000000P PS=460000U PD=560000U
* device instance $5809 r0 *1 76.105,55.18 nfet_01v8
M$5809 2883 3137 167 167 nfet_01v8 L=150000U W=210000U AS=40400000000P
+ AD=21875000000P PS=560000U PD=460000U
* device instance $5810 r0 *1 76.695,55.18 nfet_01v8
M$5810 1763 4415 167 167 nfet_01v8 L=150000U W=210000U AS=40400000000P
+ AD=21875000000P PS=560000U PD=460000U
* device instance $5811 r0 *1 76.14,55.58 nfet_01v8
M$5811 110 159 2883 167 nfet_01v8 L=150000U W=140000U AS=21875000000P
+ AD=16800000000P PS=460000U PD=380000U
* device instance $5812 r0 *1 76.66,55.58 nfet_01v8
M$5812 111 159 1763 167 nfet_01v8 L=150000U W=140000U AS=21875000000P
+ AD=16800000000P PS=460000U PD=380000U
* device instance $5813 r0 *1 76.14,55.97 nfet_01v8
M$5813 2094 160 110 167 nfet_01v8 L=150000U W=140000U AS=16800000000P
+ AD=21875000000P PS=380000U PD=460000U
* device instance $5814 r0 *1 76.66,55.97 nfet_01v8
M$5814 612 160 111 167 nfet_01v8 L=150000U W=140000U AS=16800000000P
+ AD=21875000000P PS=380000U PD=460000U
* device instance $5815 r0 *1 76.105,56.37 nfet_01v8
M$5815 167 2189 2094 167 nfet_01v8 L=150000U W=210000U AS=21875000000P
+ AD=40400000000P PS=460000U PD=560000U
* device instance $5816 r0 *1 76.695,56.37 nfet_01v8
M$5816 167 747 612 167 nfet_01v8 L=150000U W=210000U AS=21875000000P
+ AD=40400000000P PS=460000U PD=560000U
* device instance $5817 r0 *1 76.105,56.76 nfet_01v8
M$5817 2189 2094 167 167 nfet_01v8 L=150000U W=210000U AS=40400000000P
+ AD=21875000000P PS=560000U PD=460000U
* device instance $5818 r0 *1 76.695,56.76 nfet_01v8
M$5818 747 612 167 167 nfet_01v8 L=150000U W=210000U AS=40400000000P
+ AD=21875000000P PS=560000U PD=460000U
* device instance $5819 r0 *1 76.14,57.16 nfet_01v8
M$5819 109 160 2189 167 nfet_01v8 L=150000U W=140000U AS=21875000000P
+ AD=16800000000P PS=460000U PD=380000U
* device instance $5820 r0 *1 76.66,57.16 nfet_01v8
M$5820 112 160 747 167 nfet_01v8 L=150000U W=140000U AS=21875000000P
+ AD=16800000000P PS=460000U PD=380000U
* device instance $5821 r0 *1 76.14,57.55 nfet_01v8
M$5821 3141 161 109 167 nfet_01v8 L=150000U W=140000U AS=16800000000P
+ AD=21875000000P PS=380000U PD=460000U
* device instance $5822 r0 *1 76.66,57.55 nfet_01v8
M$5822 1361 161 112 167 nfet_01v8 L=150000U W=140000U AS=16800000000P
+ AD=21875000000P PS=380000U PD=460000U
* device instance $5823 r0 *1 76.105,57.95 nfet_01v8
M$5823 167 2852 3141 167 nfet_01v8 L=150000U W=210000U AS=21875000000P
+ AD=40400000000P PS=460000U PD=560000U
* device instance $5824 r0 *1 76.695,57.95 nfet_01v8
M$5824 167 1952 1361 167 nfet_01v8 L=150000U W=210000U AS=21875000000P
+ AD=40400000000P PS=460000U PD=560000U
* device instance $5825 r0 *1 76.105,58.34 nfet_01v8
M$5825 2852 3141 167 167 nfet_01v8 L=150000U W=210000U AS=40400000000P
+ AD=21875000000P PS=560000U PD=460000U
* device instance $5826 r0 *1 76.695,58.34 nfet_01v8
M$5826 1952 1361 167 167 nfet_01v8 L=150000U W=210000U AS=40400000000P
+ AD=21875000000P PS=560000U PD=460000U
* device instance $5827 r0 *1 76.14,58.74 nfet_01v8
M$5827 110 161 2852 167 nfet_01v8 L=150000U W=140000U AS=21875000000P
+ AD=16800000000P PS=460000U PD=380000U
* device instance $5828 r0 *1 76.66,58.74 nfet_01v8
M$5828 111 161 1952 167 nfet_01v8 L=150000U W=140000U AS=21875000000P
+ AD=16800000000P PS=460000U PD=380000U
* device instance $5829 r0 *1 65.24,44.91 nfet_01v8
M$5829 2320 154 94 167 nfet_01v8 L=150000U W=140000U AS=16800000000P
+ AD=21875000000P PS=380000U PD=460000U
* device instance $5830 r0 *1 65.76,44.91 nfet_01v8
M$5830 1169 154 95 167 nfet_01v8 L=150000U W=140000U AS=16800000000P
+ AD=21875000000P PS=380000U PD=460000U
* device instance $5831 r0 *1 65.205,45.31 nfet_01v8
M$5831 167 2658 2320 167 nfet_01v8 L=150000U W=210000U AS=21875000000P
+ AD=40400000000P PS=460000U PD=560000U
* device instance $5832 r0 *1 65.795,45.31 nfet_01v8
M$5832 167 1731 1169 167 nfet_01v8 L=150000U W=210000U AS=21875000000P
+ AD=40400000000P PS=460000U PD=560000U
* device instance $5833 r0 *1 65.205,45.7 nfet_01v8
M$5833 2658 2320 167 167 nfet_01v8 L=150000U W=210000U AS=40400000000P
+ AD=21875000000P PS=560000U PD=460000U
* device instance $5834 r0 *1 65.795,45.7 nfet_01v8
M$5834 1731 1169 167 167 nfet_01v8 L=150000U W=210000U AS=40400000000P
+ AD=21875000000P PS=560000U PD=460000U
* device instance $5835 r0 *1 65.24,46.1 nfet_01v8
M$5835 93 154 2658 167 nfet_01v8 L=150000U W=140000U AS=21875000000P
+ AD=16800000000P PS=460000U PD=380000U
* device instance $5836 r0 *1 65.76,46.1 nfet_01v8
M$5836 96 154 1731 167 nfet_01v8 L=150000U W=140000U AS=21875000000P
+ AD=16800000000P PS=460000U PD=380000U
* device instance $5837 r0 *1 65.24,46.49 nfet_01v8
M$5837 3556 155 93 167 nfet_01v8 L=150000U W=140000U AS=16800000000P
+ AD=21875000000P PS=380000U PD=460000U
* device instance $5838 r0 *1 65.76,46.49 nfet_01v8
M$5838 4385 155 96 167 nfet_01v8 L=150000U W=140000U AS=16800000000P
+ AD=21875000000P PS=380000U PD=460000U
* device instance $5839 r0 *1 65.205,46.89 nfet_01v8
M$5839 167 2194 3556 167 nfet_01v8 L=150000U W=210000U AS=21875000000P
+ AD=40400000000P PS=460000U PD=560000U
* device instance $5840 r0 *1 65.795,46.89 nfet_01v8
M$5840 167 865 4385 167 nfet_01v8 L=150000U W=210000U AS=21875000000P
+ AD=40400000000P PS=460000U PD=560000U
* device instance $5841 r0 *1 65.205,47.28 nfet_01v8
M$5841 2194 3556 167 167 nfet_01v8 L=150000U W=210000U AS=40400000000P
+ AD=21875000000P PS=560000U PD=460000U
* device instance $5842 r0 *1 65.795,47.28 nfet_01v8
M$5842 865 4385 167 167 nfet_01v8 L=150000U W=210000U AS=40400000000P
+ AD=21875000000P PS=560000U PD=460000U
* device instance $5843 r0 *1 65.24,47.68 nfet_01v8
M$5843 94 155 2194 167 nfet_01v8 L=150000U W=140000U AS=21875000000P
+ AD=16800000000P PS=460000U PD=380000U
* device instance $5844 r0 *1 65.76,47.68 nfet_01v8
M$5844 95 155 865 167 nfet_01v8 L=150000U W=140000U AS=21875000000P
+ AD=16800000000P PS=460000U PD=380000U
* device instance $5845 r0 *1 65.24,48.07 nfet_01v8
M$5845 2102 156 94 167 nfet_01v8 L=150000U W=140000U AS=16800000000P
+ AD=21875000000P PS=380000U PD=460000U
* device instance $5846 r0 *1 65.76,48.07 nfet_01v8
M$5846 615 156 95 167 nfet_01v8 L=150000U W=140000U AS=16800000000P
+ AD=21875000000P PS=380000U PD=460000U
* device instance $5847 r0 *1 65.205,48.47 nfet_01v8
M$5847 167 2210 2102 167 nfet_01v8 L=150000U W=210000U AS=21875000000P
+ AD=40400000000P PS=460000U PD=560000U
* device instance $5848 r0 *1 65.795,48.47 nfet_01v8
M$5848 167 750 615 167 nfet_01v8 L=150000U W=210000U AS=21875000000P
+ AD=40400000000P PS=460000U PD=560000U
* device instance $5849 r0 *1 65.205,48.86 nfet_01v8
M$5849 2210 2102 167 167 nfet_01v8 L=150000U W=210000U AS=40400000000P
+ AD=21875000000P PS=560000U PD=460000U
* device instance $5850 r0 *1 65.795,48.86 nfet_01v8
M$5850 750 615 167 167 nfet_01v8 L=150000U W=210000U AS=40400000000P
+ AD=21875000000P PS=560000U PD=460000U
* device instance $5851 r0 *1 65.24,49.26 nfet_01v8
M$5851 93 156 2210 167 nfet_01v8 L=150000U W=140000U AS=21875000000P
+ AD=16800000000P PS=460000U PD=380000U
* device instance $5852 r0 *1 65.76,49.26 nfet_01v8
M$5852 96 156 750 167 nfet_01v8 L=150000U W=140000U AS=21875000000P
+ AD=16800000000P PS=460000U PD=380000U
* device instance $5853 r0 *1 65.24,49.65 nfet_01v8
M$5853 3583 157 93 167 nfet_01v8 L=150000U W=140000U AS=16800000000P
+ AD=21875000000P PS=380000U PD=460000U
* device instance $5854 r0 *1 65.76,49.65 nfet_01v8
M$5854 1157 157 96 167 nfet_01v8 L=150000U W=140000U AS=16800000000P
+ AD=21875000000P PS=380000U PD=460000U
* device instance $5855 r0 *1 65.205,50.05 nfet_01v8
M$5855 167 2649 3583 167 nfet_01v8 L=150000U W=210000U AS=21875000000P
+ AD=40400000000P PS=460000U PD=560000U
* device instance $5856 r0 *1 65.795,50.05 nfet_01v8
M$5856 167 1717 1157 167 nfet_01v8 L=150000U W=210000U AS=21875000000P
+ AD=40400000000P PS=460000U PD=560000U
* device instance $5857 r0 *1 65.205,50.44 nfet_01v8
M$5857 2649 3583 167 167 nfet_01v8 L=150000U W=210000U AS=40400000000P
+ AD=21875000000P PS=560000U PD=460000U
* device instance $5858 r0 *1 65.795,50.44 nfet_01v8
M$5858 1717 1157 167 167 nfet_01v8 L=150000U W=210000U AS=40400000000P
+ AD=21875000000P PS=560000U PD=460000U
* device instance $5859 r0 *1 65.24,50.84 nfet_01v8
M$5859 94 157 2649 167 nfet_01v8 L=150000U W=140000U AS=21875000000P
+ AD=16800000000P PS=460000U PD=380000U
* device instance $5860 r0 *1 65.76,50.84 nfet_01v8
M$5860 95 157 1717 167 nfet_01v8 L=150000U W=140000U AS=21875000000P
+ AD=16800000000P PS=460000U PD=380000U
* device instance $5861 r0 *1 10.74,29.11 nfet_01v8
M$5861 3268 146 14 167 nfet_01v8 L=150000U W=140000U AS=16800000000P
+ AD=21875000000P PS=380000U PD=460000U
* device instance $5862 r0 *1 11.26,29.11 nfet_01v8
M$5862 1359 146 15 167 nfet_01v8 L=150000U W=140000U AS=16800000000P
+ AD=21875000000P PS=380000U PD=460000U
* device instance $5863 r0 *1 10.705,29.51 nfet_01v8
M$5863 167 2840 3268 167 nfet_01v8 L=150000U W=210000U AS=21875000000P
+ AD=40400000000P PS=460000U PD=560000U
* device instance $5864 r0 *1 11.295,29.51 nfet_01v8
M$5864 167 1949 1359 167 nfet_01v8 L=150000U W=210000U AS=21875000000P
+ AD=40400000000P PS=460000U PD=560000U
* device instance $5865 r0 *1 10.705,29.9 nfet_01v8
M$5865 2840 3268 167 167 nfet_01v8 L=150000U W=210000U AS=40400000000P
+ AD=21875000000P PS=560000U PD=460000U
* device instance $5866 r0 *1 11.295,29.9 nfet_01v8
M$5866 1949 1359 167 167 nfet_01v8 L=150000U W=210000U AS=40400000000P
+ AD=21875000000P PS=560000U PD=460000U
* device instance $5867 r0 *1 10.74,30.3 nfet_01v8
M$5867 13 146 2840 167 nfet_01v8 L=150000U W=140000U AS=21875000000P
+ AD=16800000000P PS=460000U PD=380000U
* device instance $5868 r0 *1 11.26,30.3 nfet_01v8
M$5868 16 146 1949 167 nfet_01v8 L=150000U W=140000U AS=21875000000P
+ AD=16800000000P PS=460000U PD=380000U
* device instance $5869 r0 *1 10.74,30.69 nfet_01v8
M$5869 3267 147 13 167 nfet_01v8 L=150000U W=140000U AS=16800000000P
+ AD=21875000000P PS=380000U PD=460000U
* device instance $5870 r0 *1 11.26,30.69 nfet_01v8
M$5870 4535 147 16 167 nfet_01v8 L=150000U W=140000U AS=16800000000P
+ AD=21875000000P PS=380000U PD=460000U
* device instance $5871 r0 *1 10.705,31.09 nfet_01v8
M$5871 167 2849 3267 167 nfet_01v8 L=150000U W=210000U AS=21875000000P
+ AD=40400000000P PS=460000U PD=560000U
* device instance $5872 r0 *1 11.295,31.09 nfet_01v8
M$5872 167 1948 4535 167 nfet_01v8 L=150000U W=210000U AS=21875000000P
+ AD=40400000000P PS=460000U PD=560000U
* device instance $5873 r0 *1 10.705,31.48 nfet_01v8
M$5873 2849 3267 167 167 nfet_01v8 L=150000U W=210000U AS=40400000000P
+ AD=21875000000P PS=560000U PD=460000U
* device instance $5874 r0 *1 11.295,31.48 nfet_01v8
M$5874 1948 4535 167 167 nfet_01v8 L=150000U W=210000U AS=40400000000P
+ AD=21875000000P PS=560000U PD=460000U
* device instance $5875 r0 *1 10.74,31.88 nfet_01v8
M$5875 14 147 2849 167 nfet_01v8 L=150000U W=140000U AS=21875000000P
+ AD=16800000000P PS=460000U PD=380000U
* device instance $5876 r0 *1 11.26,31.88 nfet_01v8
M$5876 15 147 1948 167 nfet_01v8 L=150000U W=140000U AS=21875000000P
+ AD=16800000000P PS=460000U PD=380000U
* device instance $5877 r0 *1 10.74,32.27 nfet_01v8
M$5877 2422 148 14 167 nfet_01v8 L=150000U W=140000U AS=16800000000P
+ AD=21875000000P PS=380000U PD=460000U
* device instance $5878 r0 *1 11.26,32.27 nfet_01v8
M$5878 1345 148 15 167 nfet_01v8 L=150000U W=140000U AS=16800000000P
+ AD=21875000000P PS=380000U PD=460000U
* device instance $5879 r0 *1 10.705,32.67 nfet_01v8
M$5879 167 2855 2422 167 nfet_01v8 L=150000U W=210000U AS=21875000000P
+ AD=40400000000P PS=460000U PD=560000U
* device instance $5880 r0 *1 11.295,32.67 nfet_01v8
M$5880 167 1932 1345 167 nfet_01v8 L=150000U W=210000U AS=21875000000P
+ AD=40400000000P PS=460000U PD=560000U
* device instance $5881 r0 *1 10.705,33.06 nfet_01v8
M$5881 2855 2422 167 167 nfet_01v8 L=150000U W=210000U AS=40400000000P
+ AD=21875000000P PS=560000U PD=460000U
* device instance $5882 r0 *1 11.295,33.06 nfet_01v8
M$5882 1932 1345 167 167 nfet_01v8 L=150000U W=210000U AS=40400000000P
+ AD=21875000000P PS=560000U PD=460000U
* device instance $5883 r0 *1 10.74,33.46 nfet_01v8
M$5883 13 148 2855 167 nfet_01v8 L=150000U W=140000U AS=21875000000P
+ AD=16800000000P PS=460000U PD=380000U
* device instance $5884 r0 *1 11.26,33.46 nfet_01v8
M$5884 16 148 1932 167 nfet_01v8 L=150000U W=140000U AS=21875000000P
+ AD=16800000000P PS=460000U PD=380000U
* device instance $5885 r0 *1 10.74,33.85 nfet_01v8
M$5885 3261 149 13 167 nfet_01v8 L=150000U W=140000U AS=16800000000P
+ AD=21875000000P PS=380000U PD=460000U
* device instance $5886 r0 *1 11.26,33.85 nfet_01v8
M$5886 1346 149 16 167 nfet_01v8 L=150000U W=140000U AS=16800000000P
+ AD=21875000000P PS=380000U PD=460000U
* device instance $5887 r0 *1 10.705,34.25 nfet_01v8
M$5887 167 2857 3261 167 nfet_01v8 L=150000U W=210000U AS=21875000000P
+ AD=40400000000P PS=460000U PD=560000U
* device instance $5888 r0 *1 11.295,34.25 nfet_01v8
M$5888 167 1934 1346 167 nfet_01v8 L=150000U W=210000U AS=21875000000P
+ AD=40400000000P PS=460000U PD=560000U
* device instance $5889 r0 *1 10.705,34.64 nfet_01v8
M$5889 2857 3261 167 167 nfet_01v8 L=150000U W=210000U AS=40400000000P
+ AD=21875000000P PS=560000U PD=460000U
* device instance $5890 r0 *1 11.295,34.64 nfet_01v8
M$5890 1934 1346 167 167 nfet_01v8 L=150000U W=210000U AS=40400000000P
+ AD=21875000000P PS=560000U PD=460000U
* device instance $5891 r0 *1 10.74,35.04 nfet_01v8
M$5891 14 149 2857 167 nfet_01v8 L=150000U W=140000U AS=21875000000P
+ AD=16800000000P PS=460000U PD=380000U
* device instance $5892 r0 *1 11.26,35.04 nfet_01v8
M$5892 15 149 1934 167 nfet_01v8 L=150000U W=140000U AS=21875000000P
+ AD=16800000000P PS=460000U PD=380000U
* device instance $5893 r0 *1 54.34,60.71 nfet_01v8
M$5893 3668 162 78 167 nfet_01v8 L=150000U W=140000U AS=16800000000P
+ AD=21875000000P PS=380000U PD=460000U
* device instance $5894 r0 *1 54.86,60.71 nfet_01v8
M$5894 1108 162 79 167 nfet_01v8 L=150000U W=140000U AS=16800000000P
+ AD=21875000000P PS=380000U PD=460000U
* device instance $5895 r0 *1 54.305,61.11 nfet_01v8
M$5895 167 2749 3668 167 nfet_01v8 L=150000U W=210000U AS=21875000000P
+ AD=40400000000P PS=460000U PD=560000U
* device instance $5896 r0 *1 54.895,61.11 nfet_01v8
M$5896 167 1660 1108 167 nfet_01v8 L=150000U W=210000U AS=21875000000P
+ AD=40400000000P PS=460000U PD=560000U
* device instance $5897 r0 *1 54.305,61.5 nfet_01v8
M$5897 2749 3668 167 167 nfet_01v8 L=150000U W=210000U AS=40400000000P
+ AD=21875000000P PS=560000U PD=460000U
* device instance $5898 r0 *1 54.895,61.5 nfet_01v8
M$5898 1660 1108 167 167 nfet_01v8 L=150000U W=210000U AS=40400000000P
+ AD=21875000000P PS=560000U PD=460000U
* device instance $5899 r0 *1 54.34,61.9 nfet_01v8
M$5899 77 162 2749 167 nfet_01v8 L=150000U W=140000U AS=21875000000P
+ AD=16800000000P PS=460000U PD=380000U
* device instance $5900 r0 *1 54.86,61.9 nfet_01v8
M$5900 80 162 1660 167 nfet_01v8 L=150000U W=140000U AS=21875000000P
+ AD=16800000000P PS=460000U PD=380000U
* device instance $5901 r0 *1 54.34,62.29 nfet_01v8
M$5901 3149 163 77 167 nfet_01v8 L=150000U W=140000U AS=16800000000P
+ AD=21875000000P PS=380000U PD=460000U
* device instance $5902 r0 *1 54.86,62.29 nfet_01v8
M$5902 4356 163 80 167 nfet_01v8 L=150000U W=140000U AS=16800000000P
+ AD=21875000000P PS=380000U PD=460000U
* device instance $5903 r0 *1 54.305,62.69 nfet_01v8
M$5903 167 2031 3149 167 nfet_01v8 L=150000U W=210000U AS=21875000000P
+ AD=40400000000P PS=460000U PD=560000U
* device instance $5904 r0 *1 54.895,62.69 nfet_01v8
M$5904 167 807 4356 167 nfet_01v8 L=150000U W=210000U AS=21875000000P
+ AD=40400000000P PS=460000U PD=560000U
* device instance $5905 r0 *1 54.305,63.08 nfet_01v8
M$5905 2031 3149 167 167 nfet_01v8 L=150000U W=210000U AS=40400000000P
+ AD=21875000000P PS=560000U PD=460000U
* device instance $5906 r0 *1 54.895,63.08 nfet_01v8
M$5906 807 4356 167 167 nfet_01v8 L=150000U W=210000U AS=40400000000P
+ AD=21875000000P PS=560000U PD=460000U
* device instance $5907 r0 *1 54.34,63.48 nfet_01v8
M$5907 78 163 2031 167 nfet_01v8 L=150000U W=140000U AS=21875000000P
+ AD=16800000000P PS=460000U PD=380000U
* device instance $5908 r0 *1 54.86,63.48 nfet_01v8
M$5908 79 163 807 167 nfet_01v8 L=150000U W=140000U AS=21875000000P
+ AD=16800000000P PS=460000U PD=380000U
* device instance $5909 r0 *1 54.34,63.87 nfet_01v8
M$5909 2068 164 78 167 nfet_01v8 L=150000U W=140000U AS=16800000000P
+ AD=21875000000P PS=380000U PD=460000U
* device instance $5910 r0 *1 54.86,63.87 nfet_01v8
M$5910 654 164 79 167 nfet_01v8 L=150000U W=140000U AS=16800000000P
+ AD=21875000000P PS=380000U PD=460000U
* device instance $5911 r0 *1 54.305,64.27 nfet_01v8
M$5911 167 2126 2068 167 nfet_01v8 L=150000U W=210000U AS=21875000000P
+ AD=40400000000P PS=460000U PD=560000U
* device instance $5912 r0 *1 54.895,64.27 nfet_01v8
M$5912 167 832 654 167 nfet_01v8 L=150000U W=210000U AS=21875000000P
+ AD=40400000000P PS=460000U PD=560000U
* device instance $5913 r0 *1 54.305,64.66 nfet_01v8
M$5913 2126 2068 167 167 nfet_01v8 L=150000U W=210000U AS=40400000000P
+ AD=21875000000P PS=560000U PD=460000U
* device instance $5914 r0 *1 54.895,64.66 nfet_01v8
M$5914 832 654 167 167 nfet_01v8 L=150000U W=210000U AS=40400000000P
+ AD=21875000000P PS=560000U PD=460000U
* device instance $5915 r0 *1 54.34,65.06 nfet_01v8
M$5915 77 164 2126 167 nfet_01v8 L=150000U W=140000U AS=21875000000P
+ AD=16800000000P PS=460000U PD=380000U
* device instance $5916 r0 *1 54.86,65.06 nfet_01v8
M$5916 80 164 832 167 nfet_01v8 L=150000U W=140000U AS=21875000000P
+ AD=16800000000P PS=460000U PD=380000U
* device instance $5917 r0 *1 54.34,65.45 nfet_01v8
M$5917 3155 165 77 167 nfet_01v8 L=150000U W=140000U AS=16800000000P
+ AD=21875000000P PS=380000U PD=460000U
* device instance $5918 r0 *1 54.86,65.45 nfet_01v8
M$5918 1200 165 80 167 nfet_01v8 L=150000U W=140000U AS=16800000000P
+ AD=21875000000P PS=380000U PD=460000U
* device instance $5919 r0 *1 54.305,65.85 nfet_01v8
M$5919 167 2676 3155 167 nfet_01v8 L=150000U W=210000U AS=21875000000P
+ AD=40400000000P PS=460000U PD=560000U
* device instance $5920 r0 *1 54.895,65.85 nfet_01v8
M$5920 167 1769 1200 167 nfet_01v8 L=150000U W=210000U AS=21875000000P
+ AD=40400000000P PS=460000U PD=560000U
* device instance $5921 r0 *1 54.305,66.24 nfet_01v8
M$5921 2676 3155 167 167 nfet_01v8 L=150000U W=210000U AS=40400000000P
+ AD=21875000000P PS=560000U PD=460000U
* device instance $5922 r0 *1 54.895,66.24 nfet_01v8
M$5922 1769 1200 167 167 nfet_01v8 L=150000U W=210000U AS=40400000000P
+ AD=21875000000P PS=560000U PD=460000U
* device instance $5923 r0 *1 54.34,66.64 nfet_01v8
M$5923 78 165 2676 167 nfet_01v8 L=150000U W=140000U AS=21875000000P
+ AD=16800000000P PS=460000U PD=380000U
* device instance $5924 r0 *1 54.86,66.64 nfet_01v8
M$5924 79 165 1769 167 nfet_01v8 L=150000U W=140000U AS=21875000000P
+ AD=16800000000P PS=460000U PD=380000U
* device instance $5925 r0 *1 10.74,44.91 nfet_01v8
M$5925 2511 154 14 167 nfet_01v8 L=150000U W=140000U AS=16800000000P
+ AD=21875000000P PS=380000U PD=460000U
* device instance $5926 r0 *1 11.26,44.91 nfet_01v8
M$5926 1340 154 15 167 nfet_01v8 L=150000U W=140000U AS=16800000000P
+ AD=21875000000P PS=380000U PD=460000U
* device instance $5927 r0 *1 10.705,45.31 nfet_01v8
M$5927 167 3051 2511 167 nfet_01v8 L=150000U W=210000U AS=21875000000P
+ AD=40400000000P PS=460000U PD=560000U
* device instance $5928 r0 *1 11.295,45.31 nfet_01v8
M$5928 167 1922 1340 167 nfet_01v8 L=150000U W=210000U AS=21875000000P
+ AD=40400000000P PS=460000U PD=560000U
* device instance $5929 r0 *1 10.705,45.7 nfet_01v8
M$5929 3051 2511 167 167 nfet_01v8 L=150000U W=210000U AS=40400000000P
+ AD=21875000000P PS=560000U PD=460000U
* device instance $5930 r0 *1 11.295,45.7 nfet_01v8
M$5930 1922 1340 167 167 nfet_01v8 L=150000U W=210000U AS=40400000000P
+ AD=21875000000P PS=560000U PD=460000U
* device instance $5931 r0 *1 10.74,46.1 nfet_01v8
M$5931 13 154 3051 167 nfet_01v8 L=150000U W=140000U AS=21875000000P
+ AD=16800000000P PS=460000U PD=380000U
* device instance $5932 r0 *1 11.26,46.1 nfet_01v8
M$5932 16 154 1922 167 nfet_01v8 L=150000U W=140000U AS=21875000000P
+ AD=16800000000P PS=460000U PD=380000U
* device instance $5933 r0 *1 10.74,46.49 nfet_01v8
M$5933 3728 155 13 167 nfet_01v8 L=150000U W=140000U AS=16800000000P
+ AD=21875000000P PS=380000U PD=460000U
* device instance $5934 r0 *1 11.26,46.49 nfet_01v8
M$5934 4449 155 16 167 nfet_01v8 L=150000U W=140000U AS=16800000000P
+ AD=21875000000P PS=380000U PD=460000U
* device instance $5935 r0 *1 10.705,46.89 nfet_01v8
M$5935 167 3056 3728 167 nfet_01v8 L=150000U W=210000U AS=21875000000P
+ AD=40400000000P PS=460000U PD=560000U
* device instance $5936 r0 *1 11.295,46.89 nfet_01v8
M$5936 167 1903 4449 167 nfet_01v8 L=150000U W=210000U AS=21875000000P
+ AD=40400000000P PS=460000U PD=560000U
* device instance $5937 r0 *1 10.705,47.28 nfet_01v8
M$5937 3056 3728 167 167 nfet_01v8 L=150000U W=210000U AS=40400000000P
+ AD=21875000000P PS=560000U PD=460000U
* device instance $5938 r0 *1 11.295,47.28 nfet_01v8
M$5938 1903 4449 167 167 nfet_01v8 L=150000U W=210000U AS=40400000000P
+ AD=21875000000P PS=560000U PD=460000U
* device instance $5939 r0 *1 10.74,47.68 nfet_01v8
M$5939 14 155 3056 167 nfet_01v8 L=150000U W=140000U AS=21875000000P
+ AD=16800000000P PS=460000U PD=380000U
* device instance $5940 r0 *1 11.26,47.68 nfet_01v8
M$5940 15 155 1903 167 nfet_01v8 L=150000U W=140000U AS=21875000000P
+ AD=16800000000P PS=460000U PD=380000U
* device instance $5941 r0 *1 10.74,48.07 nfet_01v8
M$5941 3721 156 14 167 nfet_01v8 L=150000U W=140000U AS=16800000000P
+ AD=21875000000P PS=380000U PD=460000U
* device instance $5942 r0 *1 11.26,48.07 nfet_01v8
M$5942 592 156 15 167 nfet_01v8 L=150000U W=140000U AS=16800000000P
+ AD=21875000000P PS=380000U PD=460000U
* device instance $5943 r0 *1 10.705,48.47 nfet_01v8
M$5943 167 3053 3721 167 nfet_01v8 L=150000U W=210000U AS=21875000000P
+ AD=40400000000P PS=460000U PD=560000U
* device instance $5944 r0 *1 11.295,48.47 nfet_01v8
M$5944 167 704 592 167 nfet_01v8 L=150000U W=210000U AS=21875000000P
+ AD=40400000000P PS=460000U PD=560000U
* device instance $5945 r0 *1 10.705,48.86 nfet_01v8
M$5945 3053 3721 167 167 nfet_01v8 L=150000U W=210000U AS=40400000000P
+ AD=21875000000P PS=560000U PD=460000U
* device instance $5946 r0 *1 11.295,48.86 nfet_01v8
M$5946 704 592 167 167 nfet_01v8 L=150000U W=210000U AS=40400000000P
+ AD=21875000000P PS=560000U PD=460000U
* device instance $5947 r0 *1 10.74,49.26 nfet_01v8
M$5947 13 156 3053 167 nfet_01v8 L=150000U W=140000U AS=21875000000P
+ AD=16800000000P PS=460000U PD=380000U
* device instance $5948 r0 *1 11.26,49.26 nfet_01v8
M$5948 16 156 704 167 nfet_01v8 L=150000U W=140000U AS=21875000000P
+ AD=16800000000P PS=460000U PD=380000U
* device instance $5949 r0 *1 10.74,49.65 nfet_01v8
M$5949 2545 157 13 167 nfet_01v8 L=150000U W=140000U AS=16800000000P
+ AD=21875000000P PS=380000U PD=460000U
* device instance $5950 r0 *1 11.26,49.65 nfet_01v8
M$5950 881 157 16 167 nfet_01v8 L=150000U W=140000U AS=16800000000P
+ AD=21875000000P PS=380000U PD=460000U
* device instance $5951 r0 *1 10.705,50.05 nfet_01v8
M$5951 167 3120 2545 167 nfet_01v8 L=150000U W=210000U AS=21875000000P
+ AD=40400000000P PS=460000U PD=560000U
* device instance $5952 r0 *1 11.295,50.05 nfet_01v8
M$5952 167 1391 881 167 nfet_01v8 L=150000U W=210000U AS=21875000000P
+ AD=40400000000P PS=460000U PD=560000U
* device instance $5953 r0 *1 10.705,50.44 nfet_01v8
M$5953 3120 2545 167 167 nfet_01v8 L=150000U W=210000U AS=40400000000P
+ AD=21875000000P PS=560000U PD=460000U
* device instance $5954 r0 *1 11.295,50.44 nfet_01v8
M$5954 1391 881 167 167 nfet_01v8 L=150000U W=210000U AS=40400000000P
+ AD=21875000000P PS=560000U PD=460000U
* device instance $5955 r0 *1 10.74,50.84 nfet_01v8
M$5955 14 157 3120 167 nfet_01v8 L=150000U W=140000U AS=21875000000P
+ AD=16800000000P PS=460000U PD=380000U
* device instance $5956 r0 *1 11.26,50.84 nfet_01v8
M$5956 15 157 1391 167 nfet_01v8 L=150000U W=140000U AS=21875000000P
+ AD=16800000000P PS=460000U PD=380000U
* device instance $5957 r0 *1 21.64,44.91 nfet_01v8
M$5957 3747 154 30 167 nfet_01v8 L=150000U W=140000U AS=16800000000P
+ AD=21875000000P PS=380000U PD=460000U
* device instance $5958 r0 *1 22.16,44.91 nfet_01v8
M$5958 919 154 31 167 nfet_01v8 L=150000U W=140000U AS=16800000000P
+ AD=21875000000P PS=380000U PD=460000U
* device instance $5959 r0 *1 21.605,45.31 nfet_01v8
M$5959 167 3095 3747 167 nfet_01v8 L=150000U W=210000U AS=21875000000P
+ AD=40400000000P PS=460000U PD=560000U
* device instance $5960 r0 *1 22.195,45.31 nfet_01v8
M$5960 167 1436 919 167 nfet_01v8 L=150000U W=210000U AS=21875000000P
+ AD=40400000000P PS=460000U PD=560000U
* device instance $5961 r0 *1 21.605,45.7 nfet_01v8
M$5961 3095 3747 167 167 nfet_01v8 L=150000U W=210000U AS=40400000000P
+ AD=21875000000P PS=560000U PD=460000U
* device instance $5962 r0 *1 22.195,45.7 nfet_01v8
M$5962 1436 919 167 167 nfet_01v8 L=150000U W=210000U AS=40400000000P
+ AD=21875000000P PS=560000U PD=460000U
* device instance $5963 r0 *1 21.64,46.1 nfet_01v8
M$5963 29 154 3095 167 nfet_01v8 L=150000U W=140000U AS=21875000000P
+ AD=16800000000P PS=460000U PD=380000U
* device instance $5964 r0 *1 22.16,46.1 nfet_01v8
M$5964 32 154 1436 167 nfet_01v8 L=150000U W=140000U AS=21875000000P
+ AD=16800000000P PS=460000U PD=380000U
* device instance $5965 r0 *1 21.64,46.49 nfet_01v8
M$5965 3748 155 29 167 nfet_01v8 L=150000U W=140000U AS=16800000000P
+ AD=21875000000P PS=380000U PD=460000U
* device instance $5966 r0 *1 22.16,46.49 nfet_01v8
M$5966 4463 155 32 167 nfet_01v8 L=150000U W=140000U AS=16800000000P
+ AD=21875000000P PS=380000U PD=460000U
* device instance $5967 r0 *1 21.605,46.89 nfet_01v8
M$5967 167 3107 3748 167 nfet_01v8 L=150000U W=210000U AS=21875000000P
+ AD=40400000000P PS=460000U PD=560000U
* device instance $5968 r0 *1 22.195,46.89 nfet_01v8
M$5968 167 1393 4463 167 nfet_01v8 L=150000U W=210000U AS=21875000000P
+ AD=40400000000P PS=460000U PD=560000U
* device instance $5969 r0 *1 21.605,47.28 nfet_01v8
M$5969 3107 3748 167 167 nfet_01v8 L=150000U W=210000U AS=40400000000P
+ AD=21875000000P PS=560000U PD=460000U
* device instance $5970 r0 *1 22.195,47.28 nfet_01v8
M$5970 1393 4463 167 167 nfet_01v8 L=150000U W=210000U AS=40400000000P
+ AD=21875000000P PS=560000U PD=460000U
* device instance $5971 r0 *1 21.64,47.68 nfet_01v8
M$5971 30 155 3107 167 nfet_01v8 L=150000U W=140000U AS=21875000000P
+ AD=16800000000P PS=460000U PD=380000U
* device instance $5972 r0 *1 22.16,47.68 nfet_01v8
M$5972 31 155 1393 167 nfet_01v8 L=150000U W=140000U AS=21875000000P
+ AD=16800000000P PS=460000U PD=380000U
* device instance $5973 r0 *1 21.64,48.07 nfet_01v8
M$5973 2109 156 30 167 nfet_01v8 L=150000U W=140000U AS=16800000000P
+ AD=21875000000P PS=380000U PD=460000U
* device instance $5974 r0 *1 22.16,48.07 nfet_01v8
M$5974 927 156 31 167 nfet_01v8 L=150000U W=140000U AS=16800000000P
+ AD=21875000000P PS=380000U PD=460000U
* device instance $5975 r0 *1 21.605,48.47 nfet_01v8
M$5975 167 2223 2109 167 nfet_01v8 L=150000U W=210000U AS=21875000000P
+ AD=40400000000P PS=460000U PD=560000U
* device instance $5976 r0 *1 22.195,48.47 nfet_01v8
M$5976 167 1445 927 167 nfet_01v8 L=150000U W=210000U AS=21875000000P
+ AD=40400000000P PS=460000U PD=560000U
* device instance $5977 r0 *1 21.605,48.86 nfet_01v8
M$5977 2223 2109 167 167 nfet_01v8 L=150000U W=210000U AS=40400000000P
+ AD=21875000000P PS=560000U PD=460000U
* device instance $5978 r0 *1 22.195,48.86 nfet_01v8
M$5978 1445 927 167 167 nfet_01v8 L=150000U W=210000U AS=40400000000P
+ AD=21875000000P PS=560000U PD=460000U
* device instance $5979 r0 *1 21.64,49.26 nfet_01v8
M$5979 29 156 2223 167 nfet_01v8 L=150000U W=140000U AS=21875000000P
+ AD=16800000000P PS=460000U PD=380000U
* device instance $5980 r0 *1 22.16,49.26 nfet_01v8
M$5980 32 156 1445 167 nfet_01v8 L=150000U W=140000U AS=21875000000P
+ AD=16800000000P PS=460000U PD=380000U
* device instance $5981 r0 *1 21.64,49.65 nfet_01v8
M$5981 3742 157 29 167 nfet_01v8 L=150000U W=140000U AS=16800000000P
+ AD=21875000000P PS=380000U PD=460000U
* device instance $5982 r0 *1 22.16,49.65 nfet_01v8
M$5982 925 157 32 167 nfet_01v8 L=150000U W=140000U AS=16800000000P
+ AD=21875000000P PS=380000U PD=460000U
* device instance $5983 r0 *1 21.605,50.05 nfet_01v8
M$5983 167 2958 3742 167 nfet_01v8 L=150000U W=210000U AS=21875000000P
+ AD=40400000000P PS=460000U PD=560000U
* device instance $5984 r0 *1 22.195,50.05 nfet_01v8
M$5984 167 1443 925 167 nfet_01v8 L=150000U W=210000U AS=21875000000P
+ AD=40400000000P PS=460000U PD=560000U
* device instance $5985 r0 *1 21.605,50.44 nfet_01v8
M$5985 2958 3742 167 167 nfet_01v8 L=150000U W=210000U AS=40400000000P
+ AD=21875000000P PS=560000U PD=460000U
* device instance $5986 r0 *1 22.195,50.44 nfet_01v8
M$5986 1443 925 167 167 nfet_01v8 L=150000U W=210000U AS=40400000000P
+ AD=21875000000P PS=560000U PD=460000U
* device instance $5987 r0 *1 21.64,50.84 nfet_01v8
M$5987 30 157 2958 167 nfet_01v8 L=150000U W=140000U AS=21875000000P
+ AD=16800000000P PS=460000U PD=380000U
* device instance $5988 r0 *1 22.16,50.84 nfet_01v8
M$5988 31 157 1443 167 nfet_01v8 L=150000U W=140000U AS=21875000000P
+ AD=16800000000P PS=460000U PD=380000U
* device instance $5989 r0 *1 32.54,44.91 nfet_01v8
M$5989 2374 154 46 167 nfet_01v8 L=150000U W=140000U AS=16800000000P
+ AD=21875000000P PS=380000U PD=460000U
* device instance $5990 r0 *1 33.06,44.91 nfet_01v8
M$5990 1258 154 47 167 nfet_01v8 L=150000U W=140000U AS=16800000000P
+ AD=21875000000P PS=380000U PD=460000U
* device instance $5991 r0 *1 32.505,45.31 nfet_01v8
M$5991 167 2775 2374 167 nfet_01v8 L=150000U W=210000U AS=21875000000P
+ AD=40400000000P PS=460000U PD=560000U
* device instance $5992 r0 *1 33.095,45.31 nfet_01v8
M$5992 167 1834 1258 167 nfet_01v8 L=150000U W=210000U AS=21875000000P
+ AD=40400000000P PS=460000U PD=560000U
* device instance $5993 r0 *1 32.505,45.7 nfet_01v8
M$5993 2775 2374 167 167 nfet_01v8 L=150000U W=210000U AS=40400000000P
+ AD=21875000000P PS=560000U PD=460000U
* device instance $5994 r0 *1 33.095,45.7 nfet_01v8
M$5994 1834 1258 167 167 nfet_01v8 L=150000U W=210000U AS=40400000000P
+ AD=21875000000P PS=560000U PD=460000U
* device instance $5995 r0 *1 32.54,46.1 nfet_01v8
M$5995 45 154 2775 167 nfet_01v8 L=150000U W=140000U AS=21875000000P
+ AD=16800000000P PS=460000U PD=380000U
* device instance $5996 r0 *1 33.06,46.1 nfet_01v8
M$5996 48 154 1834 167 nfet_01v8 L=150000U W=140000U AS=21875000000P
+ AD=16800000000P PS=460000U PD=380000U
* device instance $5997 r0 *1 32.54,46.49 nfet_01v8
M$5997 3625 155 45 167 nfet_01v8 L=150000U W=140000U AS=16800000000P
+ AD=21875000000P PS=380000U PD=460000U
* device instance $5998 r0 *1 33.06,46.49 nfet_01v8
M$5998 4396 155 48 167 nfet_01v8 L=150000U W=140000U AS=16800000000P
+ AD=21875000000P PS=380000U PD=460000U
* device instance $5999 r0 *1 32.505,46.89 nfet_01v8
M$5999 167 2130 3625 167 nfet_01v8 L=150000U W=210000U AS=21875000000P
+ AD=40400000000P PS=460000U PD=560000U
* device instance $6000 r0 *1 33.095,46.89 nfet_01v8
M$6000 167 719 4396 167 nfet_01v8 L=150000U W=210000U AS=21875000000P
+ AD=40400000000P PS=460000U PD=560000U
* device instance $6001 r0 *1 32.505,47.28 nfet_01v8
M$6001 2130 3625 167 167 nfet_01v8 L=150000U W=210000U AS=40400000000P
+ AD=21875000000P PS=560000U PD=460000U
* device instance $6002 r0 *1 33.095,47.28 nfet_01v8
M$6002 719 4396 167 167 nfet_01v8 L=150000U W=210000U AS=40400000000P
+ AD=21875000000P PS=560000U PD=460000U
* device instance $6003 r0 *1 32.54,47.68 nfet_01v8
M$6003 46 155 2130 167 nfet_01v8 L=150000U W=140000U AS=21875000000P
+ AD=16800000000P PS=460000U PD=380000U
* device instance $6004 r0 *1 33.06,47.68 nfet_01v8
M$6004 47 155 719 167 nfet_01v8 L=150000U W=140000U AS=21875000000P
+ AD=16800000000P PS=460000U PD=380000U
* device instance $6005 r0 *1 32.54,48.07 nfet_01v8
M$6005 2373 156 46 167 nfet_01v8 L=150000U W=140000U AS=16800000000P
+ AD=21875000000P PS=380000U PD=460000U
* device instance $6006 r0 *1 33.06,48.07 nfet_01v8
M$6006 591 156 47 167 nfet_01v8 L=150000U W=140000U AS=16800000000P
+ AD=21875000000P PS=380000U PD=460000U
* device instance $6007 r0 *1 32.505,48.47 nfet_01v8
M$6007 167 2774 2373 167 nfet_01v8 L=150000U W=210000U AS=21875000000P
+ AD=40400000000P PS=460000U PD=560000U
* device instance $6008 r0 *1 33.095,48.47 nfet_01v8
M$6008 167 703 591 167 nfet_01v8 L=150000U W=210000U AS=21875000000P
+ AD=40400000000P PS=460000U PD=560000U
* device instance $6009 r0 *1 32.505,48.86 nfet_01v8
M$6009 2774 2373 167 167 nfet_01v8 L=150000U W=210000U AS=40400000000P
+ AD=21875000000P PS=560000U PD=460000U
* device instance $6010 r0 *1 33.095,48.86 nfet_01v8
M$6010 703 591 167 167 nfet_01v8 L=150000U W=210000U AS=40400000000P
+ AD=21875000000P PS=560000U PD=460000U
* device instance $6011 r0 *1 32.54,49.26 nfet_01v8
M$6011 45 156 2774 167 nfet_01v8 L=150000U W=140000U AS=21875000000P
+ AD=16800000000P PS=460000U PD=380000U
* device instance $6012 r0 *1 33.06,49.26 nfet_01v8
M$6012 48 156 703 167 nfet_01v8 L=150000U W=140000U AS=21875000000P
+ AD=16800000000P PS=460000U PD=380000U
* device instance $6013 r0 *1 32.54,49.65 nfet_01v8
M$6013 3621 157 45 167 nfet_01v8 L=150000U W=140000U AS=16800000000P
+ AD=21875000000P PS=380000U PD=460000U
* device instance $6014 r0 *1 33.06,49.65 nfet_01v8
M$6014 1286 157 48 167 nfet_01v8 L=150000U W=140000U AS=16800000000P
+ AD=21875000000P PS=380000U PD=460000U
* device instance $6015 r0 *1 32.505,50.05 nfet_01v8
M$6015 167 2791 3621 167 nfet_01v8 L=150000U W=210000U AS=21875000000P
+ AD=40400000000P PS=460000U PD=560000U
* device instance $6016 r0 *1 33.095,50.05 nfet_01v8
M$6016 167 1863 1286 167 nfet_01v8 L=150000U W=210000U AS=21875000000P
+ AD=40400000000P PS=460000U PD=560000U
* device instance $6017 r0 *1 32.505,50.44 nfet_01v8
M$6017 2791 3621 167 167 nfet_01v8 L=150000U W=210000U AS=40400000000P
+ AD=21875000000P PS=560000U PD=460000U
* device instance $6018 r0 *1 33.095,50.44 nfet_01v8
M$6018 1863 1286 167 167 nfet_01v8 L=150000U W=210000U AS=40400000000P
+ AD=21875000000P PS=560000U PD=460000U
* device instance $6019 r0 *1 32.54,50.84 nfet_01v8
M$6019 46 157 2791 167 nfet_01v8 L=150000U W=140000U AS=21875000000P
+ AD=16800000000P PS=460000U PD=380000U
* device instance $6020 r0 *1 33.06,50.84 nfet_01v8
M$6020 47 157 1863 167 nfet_01v8 L=150000U W=140000U AS=21875000000P
+ AD=16800000000P PS=460000U PD=380000U
* device instance $6021 r0 *1 43.44,44.91 nfet_01v8
M$6021 2366 154 62 167 nfet_01v8 L=150000U W=140000U AS=16800000000P
+ AD=21875000000P PS=380000U PD=460000U
* device instance $6022 r0 *1 43.96,44.91 nfet_01v8
M$6022 1199 154 63 167 nfet_01v8 L=150000U W=140000U AS=16800000000P
+ AD=21875000000P PS=380000U PD=460000U
* device instance $6023 r0 *1 43.405,45.31 nfet_01v8
M$6023 167 2759 2366 167 nfet_01v8 L=150000U W=210000U AS=21875000000P
+ AD=40400000000P PS=460000U PD=560000U
* device instance $6024 r0 *1 43.995,45.31 nfet_01v8
M$6024 167 1768 1199 167 nfet_01v8 L=150000U W=210000U AS=21875000000P
+ AD=40400000000P PS=460000U PD=560000U
* device instance $6025 r0 *1 43.405,45.7 nfet_01v8
M$6025 2759 2366 167 167 nfet_01v8 L=150000U W=210000U AS=40400000000P
+ AD=21875000000P PS=560000U PD=460000U
* device instance $6026 r0 *1 43.995,45.7 nfet_01v8
M$6026 1768 1199 167 167 nfet_01v8 L=150000U W=210000U AS=40400000000P
+ AD=21875000000P PS=560000U PD=460000U
* device instance $6027 r0 *1 43.44,46.1 nfet_01v8
M$6027 61 154 2759 167 nfet_01v8 L=150000U W=140000U AS=21875000000P
+ AD=16800000000P PS=460000U PD=380000U
* device instance $6028 r0 *1 43.96,46.1 nfet_01v8
M$6028 64 154 1768 167 nfet_01v8 L=150000U W=140000U AS=21875000000P
+ AD=16800000000P PS=460000U PD=380000U
* device instance $6029 r0 *1 43.44,46.49 nfet_01v8
M$6029 3648 155 61 167 nfet_01v8 L=150000U W=140000U AS=16800000000P
+ AD=21875000000P PS=380000U PD=460000U
* device instance $6030 r0 *1 43.96,46.49 nfet_01v8
M$6030 4388 155 64 167 nfet_01v8 L=150000U W=140000U AS=16800000000P
+ AD=21875000000P PS=380000U PD=460000U
* device instance $6031 r0 *1 43.405,46.89 nfet_01v8
M$6031 167 2016 3648 167 nfet_01v8 L=150000U W=210000U AS=21875000000P
+ AD=40400000000P PS=460000U PD=560000U
* device instance $6032 r0 *1 43.995,46.89 nfet_01v8
M$6032 167 741 4388 167 nfet_01v8 L=150000U W=210000U AS=21875000000P
+ AD=40400000000P PS=460000U PD=560000U
* device instance $6033 r0 *1 43.405,47.28 nfet_01v8
M$6033 2016 3648 167 167 nfet_01v8 L=150000U W=210000U AS=40400000000P
+ AD=21875000000P PS=560000U PD=460000U
* device instance $6034 r0 *1 43.995,47.28 nfet_01v8
M$6034 741 4388 167 167 nfet_01v8 L=150000U W=210000U AS=40400000000P
+ AD=21875000000P PS=560000U PD=460000U
* device instance $6035 r0 *1 43.44,47.68 nfet_01v8
M$6035 62 155 2016 167 nfet_01v8 L=150000U W=140000U AS=21875000000P
+ AD=16800000000P PS=460000U PD=380000U
* device instance $6036 r0 *1 43.96,47.68 nfet_01v8
M$6036 63 155 741 167 nfet_01v8 L=150000U W=140000U AS=21875000000P
+ AD=16800000000P PS=460000U PD=380000U
* device instance $6037 r0 *1 43.44,48.07 nfet_01v8
M$6037 2081 156 62 167 nfet_01v8 L=150000U W=140000U AS=16800000000P
+ AD=21875000000P PS=380000U PD=460000U
* device instance $6038 r0 *1 43.96,48.07 nfet_01v8
M$6038 614 156 63 167 nfet_01v8 L=150000U W=140000U AS=16800000000P
+ AD=21875000000P PS=380000U PD=460000U
* device instance $6039 r0 *1 43.405,48.47 nfet_01v8
M$6039 167 2161 2081 167 nfet_01v8 L=150000U W=210000U AS=21875000000P
+ AD=40400000000P PS=460000U PD=560000U
* device instance $6040 r0 *1 43.995,48.47 nfet_01v8
M$6040 167 749 614 167 nfet_01v8 L=150000U W=210000U AS=21875000000P
+ AD=40400000000P PS=460000U PD=560000U
* device instance $6041 r0 *1 43.405,48.86 nfet_01v8
M$6041 2161 2081 167 167 nfet_01v8 L=150000U W=210000U AS=40400000000P
+ AD=21875000000P PS=560000U PD=460000U
* device instance $6042 r0 *1 43.995,48.86 nfet_01v8
M$6042 749 614 167 167 nfet_01v8 L=150000U W=210000U AS=40400000000P
+ AD=21875000000P PS=560000U PD=460000U
* device instance $6043 r0 *1 43.44,49.26 nfet_01v8
M$6043 61 156 2161 167 nfet_01v8 L=150000U W=140000U AS=21875000000P
+ AD=16800000000P PS=460000U PD=380000U
* device instance $6044 r0 *1 43.96,49.26 nfet_01v8
M$6044 64 156 749 167 nfet_01v8 L=150000U W=140000U AS=21875000000P
+ AD=16800000000P PS=460000U PD=380000U
* device instance $6045 r0 *1 43.44,49.65 nfet_01v8
M$6045 2371 157 61 167 nfet_01v8 L=150000U W=140000U AS=16800000000P
+ AD=21875000000P PS=380000U PD=460000U
* device instance $6046 r0 *1 43.96,49.65 nfet_01v8
M$6046 1193 157 64 167 nfet_01v8 L=150000U W=140000U AS=16800000000P
+ AD=21875000000P PS=380000U PD=460000U
* device instance $6047 r0 *1 43.405,50.05 nfet_01v8
M$6047 167 2770 2371 167 nfet_01v8 L=150000U W=210000U AS=21875000000P
+ AD=40400000000P PS=460000U PD=560000U
* device instance $6048 r0 *1 43.995,50.05 nfet_01v8
M$6048 167 1759 1193 167 nfet_01v8 L=150000U W=210000U AS=21875000000P
+ AD=40400000000P PS=460000U PD=560000U
* device instance $6049 r0 *1 43.405,50.44 nfet_01v8
M$6049 2770 2371 167 167 nfet_01v8 L=150000U W=210000U AS=40400000000P
+ AD=21875000000P PS=560000U PD=460000U
* device instance $6050 r0 *1 43.995,50.44 nfet_01v8
M$6050 1759 1193 167 167 nfet_01v8 L=150000U W=210000U AS=40400000000P
+ AD=21875000000P PS=560000U PD=460000U
* device instance $6051 r0 *1 43.44,50.84 nfet_01v8
M$6051 62 157 2770 167 nfet_01v8 L=150000U W=140000U AS=21875000000P
+ AD=16800000000P PS=460000U PD=380000U
* device instance $6052 r0 *1 43.96,50.84 nfet_01v8
M$6052 63 157 1759 167 nfet_01v8 L=150000U W=140000U AS=21875000000P
+ AD=16800000000P PS=460000U PD=380000U
* device instance $6053 r0 *1 54.34,44.91 nfet_01v8
M$6053 2331 154 78 167 nfet_01v8 L=150000U W=140000U AS=16800000000P
+ AD=21875000000P PS=380000U PD=460000U
* device instance $6054 r0 *1 54.86,44.91 nfet_01v8
M$6054 976 154 79 167 nfet_01v8 L=150000U W=140000U AS=16800000000P
+ AD=21875000000P PS=380000U PD=460000U
* device instance $6055 r0 *1 54.305,45.31 nfet_01v8
M$6055 167 2678 2331 167 nfet_01v8 L=150000U W=210000U AS=21875000000P
+ AD=40400000000P PS=460000U PD=560000U
* device instance $6056 r0 *1 54.895,45.31 nfet_01v8
M$6056 167 1506 976 167 nfet_01v8 L=150000U W=210000U AS=21875000000P
+ AD=40400000000P PS=460000U PD=560000U
* device instance $6057 r0 *1 54.305,45.7 nfet_01v8
M$6057 2678 2331 167 167 nfet_01v8 L=150000U W=210000U AS=40400000000P
+ AD=21875000000P PS=560000U PD=460000U
* device instance $6058 r0 *1 54.895,45.7 nfet_01v8
M$6058 1506 976 167 167 nfet_01v8 L=150000U W=210000U AS=40400000000P
+ AD=21875000000P PS=560000U PD=460000U
* device instance $6059 r0 *1 54.34,46.1 nfet_01v8
M$6059 77 154 2678 167 nfet_01v8 L=150000U W=140000U AS=21875000000P
+ AD=16800000000P PS=460000U PD=380000U
* device instance $6060 r0 *1 54.86,46.1 nfet_01v8
M$6060 80 154 1506 167 nfet_01v8 L=150000U W=140000U AS=21875000000P
+ AD=16800000000P PS=460000U PD=380000U
* device instance $6061 r0 *1 54.34,46.49 nfet_01v8
M$6061 3563 155 77 167 nfet_01v8 L=150000U W=140000U AS=16800000000P
+ AD=21875000000P PS=380000U PD=460000U
* device instance $6062 r0 *1 54.86,46.49 nfet_01v8
M$6062 4363 155 80 167 nfet_01v8 L=150000U W=140000U AS=16800000000P
+ AD=21875000000P PS=380000U PD=460000U
* device instance $6063 r0 *1 54.305,46.89 nfet_01v8
M$6063 167 2063 3563 167 nfet_01v8 L=150000U W=210000U AS=21875000000P
+ AD=40400000000P PS=460000U PD=560000U
* device instance $6064 r0 *1 54.895,46.89 nfet_01v8
M$6064 167 859 4363 167 nfet_01v8 L=150000U W=210000U AS=21875000000P
+ AD=40400000000P PS=460000U PD=560000U
* device instance $6065 r0 *1 54.305,47.28 nfet_01v8
M$6065 2063 3563 167 167 nfet_01v8 L=150000U W=210000U AS=40400000000P
+ AD=21875000000P PS=560000U PD=460000U
* device instance $6066 r0 *1 54.895,47.28 nfet_01v8
M$6066 859 4363 167 167 nfet_01v8 L=150000U W=210000U AS=40400000000P
+ AD=21875000000P PS=560000U PD=460000U
* device instance $6067 r0 *1 54.34,47.68 nfet_01v8
M$6067 78 155 2063 167 nfet_01v8 L=150000U W=140000U AS=21875000000P
+ AD=16800000000P PS=460000U PD=380000U
* device instance $6068 r0 *1 54.86,47.68 nfet_01v8
M$6068 79 155 859 167 nfet_01v8 L=150000U W=140000U AS=21875000000P
+ AD=16800000000P PS=460000U PD=380000U
* device instance $6069 r0 *1 54.34,48.07 nfet_01v8
M$6069 2096 156 78 167 nfet_01v8 L=150000U W=140000U AS=16800000000P
+ AD=21875000000P PS=380000U PD=460000U
* device instance $6070 r0 *1 54.86,48.07 nfet_01v8
M$6070 630 156 79 167 nfet_01v8 L=150000U W=140000U AS=16800000000P
+ AD=21875000000P PS=380000U PD=460000U
* device instance $6071 r0 *1 54.305,48.47 nfet_01v8
M$6071 167 2191 2096 167 nfet_01v8 L=150000U W=210000U AS=21875000000P
+ AD=40400000000P PS=460000U PD=560000U
* device instance $6072 r0 *1 54.895,48.47 nfet_01v8
M$6072 167 780 630 167 nfet_01v8 L=150000U W=210000U AS=21875000000P
+ AD=40400000000P PS=460000U PD=560000U
* device instance $6073 r0 *1 54.305,48.86 nfet_01v8
M$6073 2191 2096 167 167 nfet_01v8 L=150000U W=210000U AS=40400000000P
+ AD=21875000000P PS=560000U PD=460000U
* device instance $6074 r0 *1 54.895,48.86 nfet_01v8
M$6074 780 630 167 167 nfet_01v8 L=150000U W=210000U AS=40400000000P
+ AD=21875000000P PS=560000U PD=460000U
* device instance $6075 r0 *1 54.34,49.26 nfet_01v8
M$6075 77 156 2191 167 nfet_01v8 L=150000U W=140000U AS=21875000000P
+ AD=16800000000P PS=460000U PD=380000U
* device instance $6076 r0 *1 54.86,49.26 nfet_01v8
M$6076 80 156 780 167 nfet_01v8 L=150000U W=140000U AS=21875000000P
+ AD=16800000000P PS=460000U PD=380000U
* device instance $6077 r0 *1 54.34,49.65 nfet_01v8
M$6077 3564 157 77 167 nfet_01v8 L=150000U W=140000U AS=16800000000P
+ AD=21875000000P PS=380000U PD=460000U
* device instance $6078 r0 *1 54.86,49.65 nfet_01v8
M$6078 1122 157 80 167 nfet_01v8 L=150000U W=140000U AS=16800000000P
+ AD=21875000000P PS=380000U PD=460000U
* device instance $6079 r0 *1 54.305,50.05 nfet_01v8
M$6079 167 2641 3564 167 nfet_01v8 L=150000U W=210000U AS=21875000000P
+ AD=40400000000P PS=460000U PD=560000U
* device instance $6080 r0 *1 54.895,50.05 nfet_01v8
M$6080 167 1677 1122 167 nfet_01v8 L=150000U W=210000U AS=21875000000P
+ AD=40400000000P PS=460000U PD=560000U
* device instance $6081 r0 *1 54.305,50.44 nfet_01v8
M$6081 2641 3564 167 167 nfet_01v8 L=150000U W=210000U AS=40400000000P
+ AD=21875000000P PS=560000U PD=460000U
* device instance $6082 r0 *1 54.895,50.44 nfet_01v8
M$6082 1677 1122 167 167 nfet_01v8 L=150000U W=210000U AS=40400000000P
+ AD=21875000000P PS=560000U PD=460000U
* device instance $6083 r0 *1 54.34,50.84 nfet_01v8
M$6083 78 157 2641 167 nfet_01v8 L=150000U W=140000U AS=21875000000P
+ AD=16800000000P PS=460000U PD=380000U
* device instance $6084 r0 *1 54.86,50.84 nfet_01v8
M$6084 79 157 1677 167 nfet_01v8 L=150000U W=140000U AS=21875000000P
+ AD=16800000000P PS=460000U PD=380000U
* device instance $6085 r0 *1 65.24,60.71 nfet_01v8
M$6085 3575 162 94 167 nfet_01v8 L=150000U W=140000U AS=16800000000P
+ AD=21875000000P PS=380000U PD=460000U
* device instance $6086 r0 *1 65.76,60.71 nfet_01v8
M$6086 1068 162 95 167 nfet_01v8 L=150000U W=140000U AS=16800000000P
+ AD=21875000000P PS=380000U PD=460000U
* device instance $6087 r0 *1 65.205,61.11 nfet_01v8
M$6087 167 2578 3575 167 nfet_01v8 L=150000U W=210000U AS=21875000000P
+ AD=40400000000P PS=460000U PD=560000U
* device instance $6088 r0 *1 65.795,61.11 nfet_01v8
M$6088 167 1612 1068 167 nfet_01v8 L=150000U W=210000U AS=21875000000P
+ AD=40400000000P PS=460000U PD=560000U
* device instance $6089 r0 *1 65.205,61.5 nfet_01v8
M$6089 2578 3575 167 167 nfet_01v8 L=150000U W=210000U AS=40400000000P
+ AD=21875000000P PS=560000U PD=460000U
* device instance $6090 r0 *1 65.795,61.5 nfet_01v8
M$6090 1612 1068 167 167 nfet_01v8 L=150000U W=210000U AS=40400000000P
+ AD=21875000000P PS=560000U PD=460000U
* device instance $6091 r0 *1 65.24,61.9 nfet_01v8
M$6091 93 162 2578 167 nfet_01v8 L=150000U W=140000U AS=21875000000P
+ AD=16800000000P PS=460000U PD=380000U
* device instance $6092 r0 *1 65.76,61.9 nfet_01v8
M$6092 96 162 1612 167 nfet_01v8 L=150000U W=140000U AS=21875000000P
+ AD=16800000000P PS=460000U PD=380000U
* device instance $6093 r0 *1 65.24,62.29 nfet_01v8
M$6093 3181 163 93 167 nfet_01v8 L=150000U W=140000U AS=16800000000P
+ AD=21875000000P PS=380000U PD=460000U
* device instance $6094 r0 *1 65.76,62.29 nfet_01v8
M$6094 4406 163 96 167 nfet_01v8 L=150000U W=140000U AS=16800000000P
+ AD=21875000000P PS=380000U PD=460000U
* device instance $6095 r0 *1 65.205,62.69 nfet_01v8
M$6095 167 2632 3181 167 nfet_01v8 L=150000U W=210000U AS=21875000000P
+ AD=40400000000P PS=460000U PD=560000U
* device instance $6096 r0 *1 65.795,62.69 nfet_01v8
M$6096 167 737 4406 167 nfet_01v8 L=150000U W=210000U AS=21875000000P
+ AD=40400000000P PS=460000U PD=560000U
* device instance $6097 r0 *1 65.205,63.08 nfet_01v8
M$6097 2632 3181 167 167 nfet_01v8 L=150000U W=210000U AS=40400000000P
+ AD=21875000000P PS=560000U PD=460000U
* device instance $6098 r0 *1 65.795,63.08 nfet_01v8
M$6098 737 4406 167 167 nfet_01v8 L=150000U W=210000U AS=40400000000P
+ AD=21875000000P PS=560000U PD=460000U
* device instance $6099 r0 *1 65.24,63.48 nfet_01v8
M$6099 94 163 2632 167 nfet_01v8 L=150000U W=140000U AS=21875000000P
+ AD=16800000000P PS=460000U PD=380000U
* device instance $6100 r0 *1 65.76,63.48 nfet_01v8
M$6100 95 163 737 167 nfet_01v8 L=150000U W=140000U AS=21875000000P
+ AD=16800000000P PS=460000U PD=380000U
* device instance $6101 r0 *1 65.24,63.87 nfet_01v8
M$6101 3140 164 94 167 nfet_01v8 L=150000U W=140000U AS=16800000000P
+ AD=21875000000P PS=380000U PD=460000U
* device instance $6102 r0 *1 65.76,63.87 nfet_01v8
M$6102 602 164 95 167 nfet_01v8 L=150000U W=140000U AS=16800000000P
+ AD=21875000000P PS=380000U PD=460000U
* device instance $6103 r0 *1 65.205,64.27 nfet_01v8
M$6103 167 2173 3140 167 nfet_01v8 L=150000U W=210000U AS=21875000000P
+ AD=40400000000P PS=460000U PD=560000U
* device instance $6104 r0 *1 65.795,64.27 nfet_01v8
M$6104 167 724 602 167 nfet_01v8 L=150000U W=210000U AS=21875000000P
+ AD=40400000000P PS=460000U PD=560000U
* device instance $6105 r0 *1 65.205,64.66 nfet_01v8
M$6105 2173 3140 167 167 nfet_01v8 L=150000U W=210000U AS=40400000000P
+ AD=21875000000P PS=560000U PD=460000U
* device instance $6106 r0 *1 65.795,64.66 nfet_01v8
M$6106 724 602 167 167 nfet_01v8 L=150000U W=210000U AS=40400000000P
+ AD=21875000000P PS=560000U PD=460000U
* device instance $6107 r0 *1 65.24,65.06 nfet_01v8
M$6107 93 164 2173 167 nfet_01v8 L=150000U W=140000U AS=21875000000P
+ AD=16800000000P PS=460000U PD=380000U
* device instance $6108 r0 *1 65.76,65.06 nfet_01v8
M$6108 96 164 724 167 nfet_01v8 L=150000U W=140000U AS=21875000000P
+ AD=16800000000P PS=460000U PD=380000U
* device instance $6109 r0 *1 65.24,65.45 nfet_01v8
M$6109 3177 165 93 167 nfet_01v8 L=150000U W=140000U AS=16800000000P
+ AD=21875000000P PS=380000U PD=460000U
* device instance $6110 r0 *1 65.76,65.45 nfet_01v8
M$6110 913 165 96 167 nfet_01v8 L=150000U W=140000U AS=16800000000P
+ AD=21875000000P PS=380000U PD=460000U
* device instance $6111 r0 *1 65.205,65.85 nfet_01v8
M$6111 167 2931 3177 167 nfet_01v8 L=150000U W=210000U AS=21875000000P
+ AD=40400000000P PS=460000U PD=560000U
* device instance $6112 r0 *1 65.795,65.85 nfet_01v8
M$6112 167 1430 913 167 nfet_01v8 L=150000U W=210000U AS=21875000000P
+ AD=40400000000P PS=460000U PD=560000U
* device instance $6113 r0 *1 65.205,66.24 nfet_01v8
M$6113 2931 3177 167 167 nfet_01v8 L=150000U W=210000U AS=40400000000P
+ AD=21875000000P PS=560000U PD=460000U
* device instance $6114 r0 *1 65.795,66.24 nfet_01v8
M$6114 1430 913 167 167 nfet_01v8 L=150000U W=210000U AS=40400000000P
+ AD=21875000000P PS=560000U PD=460000U
* device instance $6115 r0 *1 65.24,66.64 nfet_01v8
M$6115 94 165 2931 167 nfet_01v8 L=150000U W=140000U AS=21875000000P
+ AD=16800000000P PS=460000U PD=380000U
* device instance $6116 r0 *1 65.76,66.64 nfet_01v8
M$6116 95 165 1430 167 nfet_01v8 L=150000U W=140000U AS=21875000000P
+ AD=16800000000P PS=460000U PD=380000U
* device instance $6117 r0 *1 87.04,52.81 nfet_01v8
M$6117 2543 158 126 167 nfet_01v8 L=150000U W=140000U AS=16800000000P
+ AD=21875000000P PS=380000U PD=460000U
* device instance $6118 r0 *1 87.56,52.81 nfet_01v8
M$6118 1164 158 127 167 nfet_01v8 L=150000U W=140000U AS=16800000000P
+ AD=21875000000P PS=380000U PD=460000U
* device instance $6119 r0 *1 87.005,53.21 nfet_01v8
M$6119 167 3118 2543 167 nfet_01v8 L=150000U W=210000U AS=21875000000P
+ AD=40400000000P PS=460000U PD=560000U
* device instance $6120 r0 *1 87.595,53.21 nfet_01v8
M$6120 167 1724 1164 167 nfet_01v8 L=150000U W=210000U AS=21875000000P
+ AD=40400000000P PS=460000U PD=560000U
* device instance $6121 r0 *1 87.005,53.6 nfet_01v8
M$6121 3118 2543 167 167 nfet_01v8 L=150000U W=210000U AS=40400000000P
+ AD=21875000000P PS=560000U PD=460000U
* device instance $6122 r0 *1 87.595,53.6 nfet_01v8
M$6122 1724 1164 167 167 nfet_01v8 L=150000U W=210000U AS=40400000000P
+ AD=21875000000P PS=560000U PD=460000U
* device instance $6123 r0 *1 87.04,54 nfet_01v8
M$6123 125 158 3118 167 nfet_01v8 L=150000U W=140000U AS=21875000000P
+ AD=16800000000P PS=460000U PD=380000U
* device instance $6124 r0 *1 87.56,54 nfet_01v8
M$6124 128 158 1724 167 nfet_01v8 L=150000U W=140000U AS=21875000000P
+ AD=16800000000P PS=460000U PD=380000U
* device instance $6125 r0 *1 87.04,54.39 nfet_01v8
M$6125 3162 159 125 167 nfet_01v8 L=150000U W=140000U AS=16800000000P
+ AD=21875000000P PS=380000U PD=460000U
* device instance $6126 r0 *1 87.56,54.39 nfet_01v8
M$6126 4453 159 128 167 nfet_01v8 L=150000U W=140000U AS=16800000000P
+ AD=21875000000P PS=380000U PD=460000U
* device instance $6127 r0 *1 87.005,54.79 nfet_01v8
M$6127 167 2138 3162 167 nfet_01v8 L=150000U W=210000U AS=21875000000P
+ AD=40400000000P PS=460000U PD=560000U
* device instance $6128 r0 *1 87.595,54.79 nfet_01v8
M$6128 167 708 4453 167 nfet_01v8 L=150000U W=210000U AS=21875000000P
+ AD=40400000000P PS=460000U PD=560000U
* device instance $6129 r0 *1 87.005,55.18 nfet_01v8
M$6129 2138 3162 167 167 nfet_01v8 L=150000U W=210000U AS=40400000000P
+ AD=21875000000P PS=560000U PD=460000U
* device instance $6130 r0 *1 87.595,55.18 nfet_01v8
M$6130 708 4453 167 167 nfet_01v8 L=150000U W=210000U AS=40400000000P
+ AD=21875000000P PS=560000U PD=460000U
* device instance $6131 r0 *1 87.04,55.58 nfet_01v8
M$6131 126 159 2138 167 nfet_01v8 L=150000U W=140000U AS=21875000000P
+ AD=16800000000P PS=460000U PD=380000U
* device instance $6132 r0 *1 87.56,55.58 nfet_01v8
M$6132 127 159 708 167 nfet_01v8 L=150000U W=140000U AS=21875000000P
+ AD=16800000000P PS=460000U PD=380000U
* device instance $6133 r0 *1 87.04,55.97 nfet_01v8
M$6133 2077 160 126 167 nfet_01v8 L=150000U W=140000U AS=16800000000P
+ AD=21875000000P PS=380000U PD=460000U
* device instance $6134 r0 *1 87.56,55.97 nfet_01v8
M$6134 581 160 127 167 nfet_01v8 L=150000U W=140000U AS=16800000000P
+ AD=21875000000P PS=380000U PD=460000U
* device instance $6135 r0 *1 87.005,56.37 nfet_01v8
M$6135 167 2156 2077 167 nfet_01v8 L=150000U W=210000U AS=21875000000P
+ AD=40400000000P PS=460000U PD=560000U
* device instance $6136 r0 *1 87.595,56.37 nfet_01v8
M$6136 167 676 581 167 nfet_01v8 L=150000U W=210000U AS=21875000000P
+ AD=40400000000P PS=460000U PD=560000U
* device instance $6137 r0 *1 87.005,56.76 nfet_01v8
M$6137 2156 2077 167 167 nfet_01v8 L=150000U W=210000U AS=40400000000P
+ AD=21875000000P PS=560000U PD=460000U
* device instance $6138 r0 *1 87.595,56.76 nfet_01v8
M$6138 676 581 167 167 nfet_01v8 L=150000U W=210000U AS=40400000000P
+ AD=21875000000P PS=560000U PD=460000U
* device instance $6139 r0 *1 87.04,57.16 nfet_01v8
M$6139 125 160 2156 167 nfet_01v8 L=150000U W=140000U AS=21875000000P
+ AD=16800000000P PS=460000U PD=380000U
* device instance $6140 r0 *1 87.56,57.16 nfet_01v8
M$6140 128 160 676 167 nfet_01v8 L=150000U W=140000U AS=21875000000P
+ AD=16800000000P PS=460000U PD=380000U
* device instance $6141 r0 *1 87.04,57.55 nfet_01v8
M$6141 3171 161 125 167 nfet_01v8 L=150000U W=140000U AS=16800000000P
+ AD=21875000000P PS=380000U PD=460000U
* device instance $6142 r0 *1 87.56,57.55 nfet_01v8
M$6142 1235 161 128 167 nfet_01v8 L=150000U W=140000U AS=16800000000P
+ AD=21875000000P PS=380000U PD=460000U
* device instance $6143 r0 *1 87.005,57.95 nfet_01v8
M$6143 167 2698 3171 167 nfet_01v8 L=150000U W=210000U AS=21875000000P
+ AD=40400000000P PS=460000U PD=560000U
* device instance $6144 r0 *1 87.595,57.95 nfet_01v8
M$6144 167 1807 1235 167 nfet_01v8 L=150000U W=210000U AS=21875000000P
+ AD=40400000000P PS=460000U PD=560000U
* device instance $6145 r0 *1 87.005,58.34 nfet_01v8
M$6145 2698 3171 167 167 nfet_01v8 L=150000U W=210000U AS=40400000000P
+ AD=21875000000P PS=560000U PD=460000U
* device instance $6146 r0 *1 87.595,58.34 nfet_01v8
M$6146 1807 1235 167 167 nfet_01v8 L=150000U W=210000U AS=40400000000P
+ AD=21875000000P PS=560000U PD=460000U
* device instance $6147 r0 *1 87.04,58.74 nfet_01v8
M$6147 126 161 2698 167 nfet_01v8 L=150000U W=140000U AS=21875000000P
+ AD=16800000000P PS=460000U PD=380000U
* device instance $6148 r0 *1 87.56,58.74 nfet_01v8
M$6148 127 161 1807 167 nfet_01v8 L=150000U W=140000U AS=21875000000P
+ AD=16800000000P PS=460000U PD=380000U
* device instance $6149 r0 *1 87.04,60.71 nfet_01v8
M$6149 3157 162 126 167 nfet_01v8 L=150000U W=140000U AS=16800000000P
+ AD=21875000000P PS=380000U PD=460000U
* device instance $6150 r0 *1 87.56,60.71 nfet_01v8
M$6150 1254 162 127 167 nfet_01v8 L=150000U W=140000U AS=16800000000P
+ AD=21875000000P PS=380000U PD=460000U
* device instance $6151 r0 *1 87.005,61.11 nfet_01v8
M$6151 167 2706 3157 167 nfet_01v8 L=150000U W=210000U AS=21875000000P
+ AD=40400000000P PS=460000U PD=560000U
* device instance $6152 r0 *1 87.595,61.11 nfet_01v8
M$6152 167 1828 1254 167 nfet_01v8 L=150000U W=210000U AS=21875000000P
+ AD=40400000000P PS=460000U PD=560000U
* device instance $6153 r0 *1 87.005,61.5 nfet_01v8
M$6153 2706 3157 167 167 nfet_01v8 L=150000U W=210000U AS=40400000000P
+ AD=21875000000P PS=560000U PD=460000U
* device instance $6154 r0 *1 87.595,61.5 nfet_01v8
M$6154 1828 1254 167 167 nfet_01v8 L=150000U W=210000U AS=40400000000P
+ AD=21875000000P PS=560000U PD=460000U
* device instance $6155 r0 *1 87.04,61.9 nfet_01v8
M$6155 125 162 2706 167 nfet_01v8 L=150000U W=140000U AS=21875000000P
+ AD=16800000000P PS=460000U PD=380000U
* device instance $6156 r0 *1 87.56,61.9 nfet_01v8
M$6156 128 162 1828 167 nfet_01v8 L=150000U W=140000U AS=21875000000P
+ AD=16800000000P PS=460000U PD=380000U
* device instance $6157 r0 *1 87.04,62.29 nfet_01v8
M$6157 3175 163 125 167 nfet_01v8 L=150000U W=140000U AS=16800000000P
+ AD=21875000000P PS=380000U PD=460000U
* device instance $6158 r0 *1 87.56,62.29 nfet_01v8
M$6158 4311 163 128 167 nfet_01v8 L=150000U W=140000U AS=16800000000P
+ AD=21875000000P PS=380000U PD=460000U
* device instance $6159 r0 *1 87.005,62.69 nfet_01v8
M$6159 167 2021 3175 167 nfet_01v8 L=150000U W=210000U AS=21875000000P
+ AD=40400000000P PS=460000U PD=560000U
* device instance $6160 r0 *1 87.595,62.69 nfet_01v8
M$6160 167 1577 4311 167 nfet_01v8 L=150000U W=210000U AS=21875000000P
+ AD=40400000000P PS=460000U PD=560000U
* device instance $6161 r0 *1 87.005,63.08 nfet_01v8
M$6161 2021 3175 167 167 nfet_01v8 L=150000U W=210000U AS=40400000000P
+ AD=21875000000P PS=560000U PD=460000U
* device instance $6162 r0 *1 87.595,63.08 nfet_01v8
M$6162 1577 4311 167 167 nfet_01v8 L=150000U W=210000U AS=40400000000P
+ AD=21875000000P PS=560000U PD=460000U
* device instance $6163 r0 *1 87.04,63.48 nfet_01v8
M$6163 126 163 2021 167 nfet_01v8 L=150000U W=140000U AS=21875000000P
+ AD=16800000000P PS=460000U PD=380000U
* device instance $6164 r0 *1 87.56,63.48 nfet_01v8
M$6164 127 163 1577 167 nfet_01v8 L=150000U W=140000U AS=21875000000P
+ AD=16800000000P PS=460000U PD=380000U
* device instance $6165 r0 *1 87.04,63.87 nfet_01v8
M$6165 2075 164 126 167 nfet_01v8 L=150000U W=140000U AS=16800000000P
+ AD=21875000000P PS=380000U PD=460000U
* device instance $6166 r0 *1 87.56,63.87 nfet_01v8
M$6166 667 164 127 167 nfet_01v8 L=150000U W=140000U AS=16800000000P
+ AD=21875000000P PS=380000U PD=460000U
* device instance $6167 r0 *1 87.005,64.27 nfet_01v8
M$6167 167 2151 2075 167 nfet_01v8 L=150000U W=210000U AS=21875000000P
+ AD=40400000000P PS=460000U PD=560000U
* device instance $6168 r0 *1 87.595,64.27 nfet_01v8
M$6168 167 856 667 167 nfet_01v8 L=150000U W=210000U AS=21875000000P
+ AD=40400000000P PS=460000U PD=560000U
* device instance $6169 r0 *1 87.005,64.66 nfet_01v8
M$6169 2151 2075 167 167 nfet_01v8 L=150000U W=210000U AS=40400000000P
+ AD=21875000000P PS=560000U PD=460000U
* device instance $6170 r0 *1 87.595,64.66 nfet_01v8
M$6170 856 667 167 167 nfet_01v8 L=150000U W=210000U AS=40400000000P
+ AD=21875000000P PS=560000U PD=460000U
* device instance $6171 r0 *1 87.04,65.06 nfet_01v8
M$6171 125 164 2151 167 nfet_01v8 L=150000U W=140000U AS=21875000000P
+ AD=16800000000P PS=460000U PD=380000U
* device instance $6172 r0 *1 87.56,65.06 nfet_01v8
M$6172 128 164 856 167 nfet_01v8 L=150000U W=140000U AS=21875000000P
+ AD=16800000000P PS=460000U PD=380000U
* device instance $6173 r0 *1 87.04,65.45 nfet_01v8
M$6173 3152 165 125 167 nfet_01v8 L=150000U W=140000U AS=16800000000P
+ AD=21875000000P PS=380000U PD=460000U
* device instance $6174 r0 *1 87.56,65.45 nfet_01v8
M$6174 1125 165 128 167 nfet_01v8 L=150000U W=140000U AS=16800000000P
+ AD=21875000000P PS=380000U PD=460000U
* device instance $6175 r0 *1 87.005,65.85 nfet_01v8
M$6175 167 2727 3152 167 nfet_01v8 L=150000U W=210000U AS=21875000000P
+ AD=40400000000P PS=460000U PD=560000U
* device instance $6176 r0 *1 87.595,65.85 nfet_01v8
M$6176 167 1680 1125 167 nfet_01v8 L=150000U W=210000U AS=21875000000P
+ AD=40400000000P PS=460000U PD=560000U
* device instance $6177 r0 *1 87.005,66.24 nfet_01v8
M$6177 2727 3152 167 167 nfet_01v8 L=150000U W=210000U AS=40400000000P
+ AD=21875000000P PS=560000U PD=460000U
* device instance $6178 r0 *1 87.595,66.24 nfet_01v8
M$6178 1680 1125 167 167 nfet_01v8 L=150000U W=210000U AS=40400000000P
+ AD=21875000000P PS=560000U PD=460000U
* device instance $6179 r0 *1 87.04,66.64 nfet_01v8
M$6179 126 165 2727 167 nfet_01v8 L=150000U W=140000U AS=21875000000P
+ AD=16800000000P PS=460000U PD=380000U
* device instance $6180 r0 *1 87.56,66.64 nfet_01v8
M$6180 127 165 1680 167 nfet_01v8 L=150000U W=140000U AS=21875000000P
+ AD=16800000000P PS=460000U PD=380000U
* device instance $6181 r0 *1 21.64,13.31 nfet_01v8
M$6181 3305 138 30 167 nfet_01v8 L=150000U W=140000U AS=16800000000P
+ AD=21875000000P PS=380000U PD=460000U
* device instance $6182 r0 *1 22.16,13.31 nfet_01v8
M$6182 1320 138 31 167 nfet_01v8 L=150000U W=140000U AS=16800000000P
+ AD=21875000000P PS=380000U PD=460000U
* device instance $6183 r0 *1 21.605,13.71 nfet_01v8
M$6183 167 2798 3305 167 nfet_01v8 L=150000U W=210000U AS=21875000000P
+ AD=40400000000P PS=460000U PD=560000U
* device instance $6184 r0 *1 22.195,13.71 nfet_01v8
M$6184 167 1900 1320 167 nfet_01v8 L=150000U W=210000U AS=21875000000P
+ AD=40400000000P PS=460000U PD=560000U
* device instance $6185 r0 *1 21.605,14.1 nfet_01v8
M$6185 2798 3305 167 167 nfet_01v8 L=150000U W=210000U AS=40400000000P
+ AD=21875000000P PS=560000U PD=460000U
* device instance $6186 r0 *1 22.195,14.1 nfet_01v8
M$6186 1900 1320 167 167 nfet_01v8 L=150000U W=210000U AS=40400000000P
+ AD=21875000000P PS=560000U PD=460000U
* device instance $6187 r0 *1 21.64,14.5 nfet_01v8
M$6187 29 138 2798 167 nfet_01v8 L=150000U W=140000U AS=21875000000P
+ AD=16800000000P PS=460000U PD=380000U
* device instance $6188 r0 *1 22.16,14.5 nfet_01v8
M$6188 32 138 1900 167 nfet_01v8 L=150000U W=140000U AS=21875000000P
+ AD=16800000000P PS=460000U PD=380000U
* device instance $6189 r0 *1 21.64,14.89 nfet_01v8
M$6189 3298 139 29 167 nfet_01v8 L=150000U W=140000U AS=16800000000P
+ AD=21875000000P PS=380000U PD=460000U
* device instance $6190 r0 *1 22.16,14.89 nfet_01v8
M$6190 4481 139 32 167 nfet_01v8 L=150000U W=140000U AS=16800000000P
+ AD=21875000000P PS=380000U PD=460000U
* device instance $6191 r0 *1 21.605,15.29 nfet_01v8
M$6191 167 1977 3298 167 nfet_01v8 L=150000U W=210000U AS=21875000000P
+ AD=40400000000P PS=460000U PD=560000U
* device instance $6192 r0 *1 22.195,15.29 nfet_01v8
M$6192 167 786 4481 167 nfet_01v8 L=150000U W=210000U AS=21875000000P
+ AD=40400000000P PS=460000U PD=560000U
* device instance $6193 r0 *1 21.605,15.68 nfet_01v8
M$6193 1977 3298 167 167 nfet_01v8 L=150000U W=210000U AS=40400000000P
+ AD=21875000000P PS=560000U PD=460000U
* device instance $6194 r0 *1 22.195,15.68 nfet_01v8
M$6194 786 4481 167 167 nfet_01v8 L=150000U W=210000U AS=40400000000P
+ AD=21875000000P PS=560000U PD=460000U
* device instance $6195 r0 *1 21.64,16.08 nfet_01v8
M$6195 30 139 1977 167 nfet_01v8 L=150000U W=140000U AS=21875000000P
+ AD=16800000000P PS=460000U PD=380000U
* device instance $6196 r0 *1 22.16,16.08 nfet_01v8
M$6196 31 139 786 167 nfet_01v8 L=150000U W=140000U AS=21875000000P
+ AD=16800000000P PS=460000U PD=380000U
* device instance $6197 r0 *1 21.64,16.47 nfet_01v8
M$6197 3300 140 30 167 nfet_01v8 L=150000U W=140000U AS=16800000000P
+ AD=21875000000P PS=380000U PD=460000U
* device instance $6198 r0 *1 22.16,16.47 nfet_01v8
M$6198 1334 140 31 167 nfet_01v8 L=150000U W=140000U AS=16800000000P
+ AD=21875000000P PS=380000U PD=460000U
* device instance $6199 r0 *1 21.605,16.87 nfet_01v8
M$6199 167 2682 3300 167 nfet_01v8 L=150000U W=210000U AS=21875000000P
+ AD=40400000000P PS=460000U PD=560000U
* device instance $6200 r0 *1 22.195,16.87 nfet_01v8
M$6200 167 1916 1334 167 nfet_01v8 L=150000U W=210000U AS=21875000000P
+ AD=40400000000P PS=460000U PD=560000U
* device instance $6201 r0 *1 21.605,17.26 nfet_01v8
M$6201 2682 3300 167 167 nfet_01v8 L=150000U W=210000U AS=40400000000P
+ AD=21875000000P PS=560000U PD=460000U
* device instance $6202 r0 *1 22.195,17.26 nfet_01v8
M$6202 1916 1334 167 167 nfet_01v8 L=150000U W=210000U AS=40400000000P
+ AD=21875000000P PS=560000U PD=460000U
* device instance $6203 r0 *1 21.64,17.66 nfet_01v8
M$6203 29 140 2682 167 nfet_01v8 L=150000U W=140000U AS=21875000000P
+ AD=16800000000P PS=460000U PD=380000U
* device instance $6204 r0 *1 22.16,17.66 nfet_01v8
M$6204 32 140 1916 167 nfet_01v8 L=150000U W=140000U AS=21875000000P
+ AD=16800000000P PS=460000U PD=380000U
* device instance $6205 r0 *1 21.64,18.05 nfet_01v8
M$6205 2341 141 29 167 nfet_01v8 L=150000U W=140000U AS=16800000000P
+ AD=21875000000P PS=380000U PD=460000U
* device instance $6206 r0 *1 22.16,18.05 nfet_01v8
M$6206 1335 141 32 167 nfet_01v8 L=150000U W=140000U AS=16800000000P
+ AD=21875000000P PS=380000U PD=460000U
* device instance $6207 r0 *1 21.605,18.45 nfet_01v8
M$6207 167 2709 2341 167 nfet_01v8 L=150000U W=210000U AS=21875000000P
+ AD=40400000000P PS=460000U PD=560000U
* device instance $6208 r0 *1 22.195,18.45 nfet_01v8
M$6208 167 1917 1335 167 nfet_01v8 L=150000U W=210000U AS=21875000000P
+ AD=40400000000P PS=460000U PD=560000U
* device instance $6209 r0 *1 21.605,18.84 nfet_01v8
M$6209 2709 2341 167 167 nfet_01v8 L=150000U W=210000U AS=40400000000P
+ AD=21875000000P PS=560000U PD=460000U
* device instance $6210 r0 *1 22.195,18.84 nfet_01v8
M$6210 1917 1335 167 167 nfet_01v8 L=150000U W=210000U AS=40400000000P
+ AD=21875000000P PS=560000U PD=460000U
* device instance $6211 r0 *1 21.64,19.24 nfet_01v8
M$6211 30 141 2709 167 nfet_01v8 L=150000U W=140000U AS=21875000000P
+ AD=16800000000P PS=460000U PD=380000U
* device instance $6212 r0 *1 22.16,19.24 nfet_01v8
M$6212 31 141 1917 167 nfet_01v8 L=150000U W=140000U AS=21875000000P
+ AD=16800000000P PS=460000U PD=380000U
* device instance $6213 r0 *1 32.54,13.31 nfet_01v8
M$6213 2485 138 46 167 nfet_01v8 L=150000U W=140000U AS=16800000000P
+ AD=21875000000P PS=380000U PD=460000U
* device instance $6214 r0 *1 33.06,13.31 nfet_01v8
M$6214 1028 138 47 167 nfet_01v8 L=150000U W=140000U AS=16800000000P
+ AD=21875000000P PS=380000U PD=460000U
* device instance $6215 r0 *1 32.505,13.71 nfet_01v8
M$6215 167 2991 2485 167 nfet_01v8 L=150000U W=210000U AS=21875000000P
+ AD=40400000000P PS=460000U PD=560000U
* device instance $6216 r0 *1 33.095,13.71 nfet_01v8
M$6216 167 1566 1028 167 nfet_01v8 L=150000U W=210000U AS=21875000000P
+ AD=40400000000P PS=460000U PD=560000U
* device instance $6217 r0 *1 32.505,14.1 nfet_01v8
M$6217 2991 2485 167 167 nfet_01v8 L=150000U W=210000U AS=40400000000P
+ AD=21875000000P PS=560000U PD=460000U
* device instance $6218 r0 *1 33.095,14.1 nfet_01v8
M$6218 1566 1028 167 167 nfet_01v8 L=150000U W=210000U AS=40400000000P
+ AD=21875000000P PS=560000U PD=460000U
* device instance $6219 r0 *1 32.54,14.5 nfet_01v8
M$6219 45 138 2991 167 nfet_01v8 L=150000U W=140000U AS=21875000000P
+ AD=16800000000P PS=460000U PD=380000U
* device instance $6220 r0 *1 33.06,14.5 nfet_01v8
M$6220 48 138 1566 167 nfet_01v8 L=150000U W=140000U AS=21875000000P
+ AD=16800000000P PS=460000U PD=380000U
* device instance $6221 r0 *1 32.54,14.89 nfet_01v8
M$6221 3245 139 45 167 nfet_01v8 L=150000U W=140000U AS=16800000000P
+ AD=21875000000P PS=380000U PD=460000U
* device instance $6222 r0 *1 33.06,14.89 nfet_01v8
M$6222 4494 139 48 167 nfet_01v8 L=150000U W=140000U AS=16800000000P
+ AD=21875000000P PS=380000U PD=460000U
* device instance $6223 r0 *1 32.505,15.29 nfet_01v8
M$6223 167 2988 3245 167 nfet_01v8 L=150000U W=210000U AS=21875000000P
+ AD=40400000000P PS=460000U PD=560000U
* device instance $6224 r0 *1 33.095,15.29 nfet_01v8
M$6224 167 1597 4494 167 nfet_01v8 L=150000U W=210000U AS=21875000000P
+ AD=40400000000P PS=460000U PD=560000U
* device instance $6225 r0 *1 32.505,15.68 nfet_01v8
M$6225 2988 3245 167 167 nfet_01v8 L=150000U W=210000U AS=40400000000P
+ AD=21875000000P PS=560000U PD=460000U
* device instance $6226 r0 *1 33.095,15.68 nfet_01v8
M$6226 1597 4494 167 167 nfet_01v8 L=150000U W=210000U AS=40400000000P
+ AD=21875000000P PS=560000U PD=460000U
* device instance $6227 r0 *1 32.54,16.08 nfet_01v8
M$6227 46 139 2988 167 nfet_01v8 L=150000U W=140000U AS=21875000000P
+ AD=16800000000P PS=460000U PD=380000U
* device instance $6228 r0 *1 33.06,16.08 nfet_01v8
M$6228 47 139 1597 167 nfet_01v8 L=150000U W=140000U AS=21875000000P
+ AD=16800000000P PS=460000U PD=380000U
* device instance $6229 r0 *1 32.54,16.47 nfet_01v8
M$6229 2085 140 46 167 nfet_01v8 L=150000U W=140000U AS=16800000000P
+ AD=21875000000P PS=380000U PD=460000U
* device instance $6230 r0 *1 33.06,16.47 nfet_01v8
M$6230 1054 140 47 167 nfet_01v8 L=150000U W=140000U AS=16800000000P
+ AD=21875000000P PS=380000U PD=460000U
* device instance $6231 r0 *1 32.505,16.87 nfet_01v8
M$6231 167 2169 2085 167 nfet_01v8 L=150000U W=210000U AS=21875000000P
+ AD=40400000000P PS=460000U PD=560000U
* device instance $6232 r0 *1 33.095,16.87 nfet_01v8
M$6232 167 1598 1054 167 nfet_01v8 L=150000U W=210000U AS=21875000000P
+ AD=40400000000P PS=460000U PD=560000U
* device instance $6233 r0 *1 32.505,17.26 nfet_01v8
M$6233 2169 2085 167 167 nfet_01v8 L=150000U W=210000U AS=40400000000P
+ AD=21875000000P PS=560000U PD=460000U
* device instance $6234 r0 *1 33.095,17.26 nfet_01v8
M$6234 1598 1054 167 167 nfet_01v8 L=150000U W=210000U AS=40400000000P
+ AD=21875000000P PS=560000U PD=460000U
* device instance $6235 r0 *1 32.54,17.66 nfet_01v8
M$6235 45 140 2169 167 nfet_01v8 L=150000U W=140000U AS=21875000000P
+ AD=16800000000P PS=460000U PD=380000U
* device instance $6236 r0 *1 33.06,17.66 nfet_01v8
M$6236 48 140 1598 167 nfet_01v8 L=150000U W=140000U AS=21875000000P
+ AD=16800000000P PS=460000U PD=380000U
* device instance $6237 r0 *1 32.54,18.05 nfet_01v8
M$6237 3250 141 45 167 nfet_01v8 L=150000U W=140000U AS=16800000000P
+ AD=21875000000P PS=380000U PD=460000U
* device instance $6238 r0 *1 33.06,18.05 nfet_01v8
M$6238 1053 141 48 167 nfet_01v8 L=150000U W=140000U AS=16800000000P
+ AD=21875000000P PS=380000U PD=460000U
* device instance $6239 r0 *1 32.505,18.45 nfet_01v8
M$6239 167 3013 3250 167 nfet_01v8 L=150000U W=210000U AS=21875000000P
+ AD=40400000000P PS=460000U PD=560000U
* device instance $6240 r0 *1 33.095,18.45 nfet_01v8
M$6240 167 1596 1053 167 nfet_01v8 L=150000U W=210000U AS=21875000000P
+ AD=40400000000P PS=460000U PD=560000U
* device instance $6241 r0 *1 32.505,18.84 nfet_01v8
M$6241 3013 3250 167 167 nfet_01v8 L=150000U W=210000U AS=40400000000P
+ AD=21875000000P PS=560000U PD=460000U
* device instance $6242 r0 *1 33.095,18.84 nfet_01v8
M$6242 1596 1053 167 167 nfet_01v8 L=150000U W=210000U AS=40400000000P
+ AD=21875000000P PS=560000U PD=460000U
* device instance $6243 r0 *1 32.54,19.24 nfet_01v8
M$6243 46 141 3013 167 nfet_01v8 L=150000U W=140000U AS=21875000000P
+ AD=16800000000P PS=460000U PD=380000U
* device instance $6244 r0 *1 33.06,19.24 nfet_01v8
M$6244 47 141 1596 167 nfet_01v8 L=150000U W=140000U AS=21875000000P
+ AD=16800000000P PS=460000U PD=380000U
* device instance $6245 r0 *1 43.44,13.31 nfet_01v8
M$6245 3243 138 62 167 nfet_01v8 L=150000U W=140000U AS=16800000000P
+ AD=21875000000P PS=380000U PD=460000U
* device instance $6246 r0 *1 43.96,13.31 nfet_01v8
M$6246 1057 138 63 167 nfet_01v8 L=150000U W=140000U AS=16800000000P
+ AD=21875000000P PS=380000U PD=460000U
* device instance $6247 r0 *1 43.405,13.71 nfet_01v8
M$6247 167 3015 3243 167 nfet_01v8 L=150000U W=210000U AS=21875000000P
+ AD=40400000000P PS=460000U PD=560000U
* device instance $6248 r0 *1 43.995,13.71 nfet_01v8
M$6248 167 1601 1057 167 nfet_01v8 L=150000U W=210000U AS=21875000000P
+ AD=40400000000P PS=460000U PD=560000U
* device instance $6249 r0 *1 43.405,14.1 nfet_01v8
M$6249 3015 3243 167 167 nfet_01v8 L=150000U W=210000U AS=40400000000P
+ AD=21875000000P PS=560000U PD=460000U
* device instance $6250 r0 *1 43.995,14.1 nfet_01v8
M$6250 1601 1057 167 167 nfet_01v8 L=150000U W=210000U AS=40400000000P
+ AD=21875000000P PS=560000U PD=460000U
* device instance $6251 r0 *1 43.44,14.5 nfet_01v8
M$6251 61 138 3015 167 nfet_01v8 L=150000U W=140000U AS=21875000000P
+ AD=16800000000P PS=460000U PD=380000U
* device instance $6252 r0 *1 43.96,14.5 nfet_01v8
M$6252 64 138 1601 167 nfet_01v8 L=150000U W=140000U AS=21875000000P
+ AD=16800000000P PS=460000U PD=380000U
* device instance $6253 r0 *1 43.44,14.89 nfet_01v8
M$6253 3199 139 61 167 nfet_01v8 L=150000U W=140000U AS=16800000000P
+ AD=21875000000P PS=380000U PD=460000U
* device instance $6254 r0 *1 43.96,14.89 nfet_01v8
M$6254 4496 139 64 167 nfet_01v8 L=150000U W=140000U AS=16800000000P
+ AD=21875000000P PS=380000U PD=460000U
* device instance $6255 r0 *1 43.405,15.29 nfet_01v8
M$6255 167 2026 3199 167 nfet_01v8 L=150000U W=210000U AS=21875000000P
+ AD=40400000000P PS=460000U PD=560000U
* device instance $6256 r0 *1 43.995,15.29 nfet_01v8
M$6256 167 781 4496 167 nfet_01v8 L=150000U W=210000U AS=21875000000P
+ AD=40400000000P PS=460000U PD=560000U
* device instance $6257 r0 *1 43.405,15.68 nfet_01v8
M$6257 2026 3199 167 167 nfet_01v8 L=150000U W=210000U AS=40400000000P
+ AD=21875000000P PS=560000U PD=460000U
* device instance $6258 r0 *1 43.995,15.68 nfet_01v8
M$6258 781 4496 167 167 nfet_01v8 L=150000U W=210000U AS=40400000000P
+ AD=21875000000P PS=560000U PD=460000U
* device instance $6259 r0 *1 43.44,16.08 nfet_01v8
M$6259 62 139 2026 167 nfet_01v8 L=150000U W=140000U AS=21875000000P
+ AD=16800000000P PS=460000U PD=380000U
* device instance $6260 r0 *1 43.96,16.08 nfet_01v8
M$6260 63 139 781 167 nfet_01v8 L=150000U W=140000U AS=21875000000P
+ AD=16800000000P PS=460000U PD=380000U
* device instance $6261 r0 *1 43.44,16.47 nfet_01v8
M$6261 2487 140 62 167 nfet_01v8 L=150000U W=140000U AS=16800000000P
+ AD=21875000000P PS=380000U PD=460000U
* device instance $6262 r0 *1 43.96,16.47 nfet_01v8
M$6262 1043 140 63 167 nfet_01v8 L=150000U W=140000U AS=16800000000P
+ AD=21875000000P PS=380000U PD=460000U
* device instance $6263 r0 *1 43.405,16.87 nfet_01v8
M$6263 167 2996 2487 167 nfet_01v8 L=150000U W=210000U AS=21875000000P
+ AD=40400000000P PS=460000U PD=560000U
* device instance $6264 r0 *1 43.995,16.87 nfet_01v8
M$6264 167 1584 1043 167 nfet_01v8 L=150000U W=210000U AS=21875000000P
+ AD=40400000000P PS=460000U PD=560000U
* device instance $6265 r0 *1 43.405,17.26 nfet_01v8
M$6265 2996 2487 167 167 nfet_01v8 L=150000U W=210000U AS=40400000000P
+ AD=21875000000P PS=560000U PD=460000U
* device instance $6266 r0 *1 43.995,17.26 nfet_01v8
M$6266 1584 1043 167 167 nfet_01v8 L=150000U W=210000U AS=40400000000P
+ AD=21875000000P PS=560000U PD=460000U
* device instance $6267 r0 *1 43.44,17.66 nfet_01v8
M$6267 61 140 2996 167 nfet_01v8 L=150000U W=140000U AS=21875000000P
+ AD=16800000000P PS=460000U PD=380000U
* device instance $6268 r0 *1 43.96,17.66 nfet_01v8
M$6268 64 140 1584 167 nfet_01v8 L=150000U W=140000U AS=21875000000P
+ AD=16800000000P PS=460000U PD=380000U
* device instance $6269 r0 *1 43.44,18.05 nfet_01v8
M$6269 2502 141 61 167 nfet_01v8 L=150000U W=140000U AS=16800000000P
+ AD=21875000000P PS=380000U PD=460000U
* device instance $6270 r0 *1 43.96,18.05 nfet_01v8
M$6270 1044 141 64 167 nfet_01v8 L=150000U W=140000U AS=16800000000P
+ AD=21875000000P PS=380000U PD=460000U
* device instance $6271 r0 *1 43.405,18.45 nfet_01v8
M$6271 167 3033 2502 167 nfet_01v8 L=150000U W=210000U AS=21875000000P
+ AD=40400000000P PS=460000U PD=560000U
* device instance $6272 r0 *1 43.995,18.45 nfet_01v8
M$6272 167 1585 1044 167 nfet_01v8 L=150000U W=210000U AS=21875000000P
+ AD=40400000000P PS=460000U PD=560000U
* device instance $6273 r0 *1 43.405,18.84 nfet_01v8
M$6273 3033 2502 167 167 nfet_01v8 L=150000U W=210000U AS=40400000000P
+ AD=21875000000P PS=560000U PD=460000U
* device instance $6274 r0 *1 43.995,18.84 nfet_01v8
M$6274 1585 1044 167 167 nfet_01v8 L=150000U W=210000U AS=40400000000P
+ AD=21875000000P PS=560000U PD=460000U
* device instance $6275 r0 *1 43.44,19.24 nfet_01v8
M$6275 62 141 3033 167 nfet_01v8 L=150000U W=140000U AS=21875000000P
+ AD=16800000000P PS=460000U PD=380000U
* device instance $6276 r0 *1 43.96,19.24 nfet_01v8
M$6276 63 141 1585 167 nfet_01v8 L=150000U W=140000U AS=21875000000P
+ AD=16800000000P PS=460000U PD=380000U
* device instance $6277 r0 *1 54.34,13.31 nfet_01v8
M$6277 2372 138 78 167 nfet_01v8 L=150000U W=140000U AS=16800000000P
+ AD=21875000000P PS=380000U PD=460000U
* device instance $6278 r0 *1 54.86,13.31 nfet_01v8
M$6278 1161 138 79 167 nfet_01v8 L=150000U W=140000U AS=16800000000P
+ AD=21875000000P PS=380000U PD=460000U
* device instance $6279 r0 *1 54.305,13.71 nfet_01v8
M$6279 167 2772 2372 167 nfet_01v8 L=150000U W=210000U AS=21875000000P
+ AD=40400000000P PS=460000U PD=560000U
* device instance $6280 r0 *1 54.895,13.71 nfet_01v8
M$6280 167 1721 1161 167 nfet_01v8 L=150000U W=210000U AS=21875000000P
+ AD=40400000000P PS=460000U PD=560000U
* device instance $6281 r0 *1 54.305,14.1 nfet_01v8
M$6281 2772 2372 167 167 nfet_01v8 L=150000U W=210000U AS=40400000000P
+ AD=21875000000P PS=560000U PD=460000U
* device instance $6282 r0 *1 54.895,14.1 nfet_01v8
M$6282 1721 1161 167 167 nfet_01v8 L=150000U W=210000U AS=40400000000P
+ AD=21875000000P PS=560000U PD=460000U
* device instance $6283 r0 *1 54.34,14.5 nfet_01v8
M$6283 77 138 2772 167 nfet_01v8 L=150000U W=140000U AS=21875000000P
+ AD=16800000000P PS=460000U PD=380000U
* device instance $6284 r0 *1 54.86,14.5 nfet_01v8
M$6284 80 138 1721 167 nfet_01v8 L=150000U W=140000U AS=21875000000P
+ AD=16800000000P PS=460000U PD=380000U
* device instance $6285 r0 *1 54.34,14.89 nfet_01v8
M$6285 3362 139 77 167 nfet_01v8 L=150000U W=140000U AS=16800000000P
+ AD=21875000000P PS=380000U PD=460000U
* device instance $6286 r0 *1 54.86,14.89 nfet_01v8
M$6286 4377 139 80 167 nfet_01v8 L=150000U W=140000U AS=16800000000P
+ AD=21875000000P PS=380000U PD=460000U
* device instance $6287 r0 *1 54.305,15.29 nfet_01v8
M$6287 167 2005 3362 167 nfet_01v8 L=150000U W=210000U AS=21875000000P
+ AD=40400000000P PS=460000U PD=560000U
* device instance $6288 r0 *1 54.895,15.29 nfet_01v8
M$6288 167 1716 4377 167 nfet_01v8 L=150000U W=210000U AS=21875000000P
+ AD=40400000000P PS=460000U PD=560000U
* device instance $6289 r0 *1 54.305,15.68 nfet_01v8
M$6289 2005 3362 167 167 nfet_01v8 L=150000U W=210000U AS=40400000000P
+ AD=21875000000P PS=560000U PD=460000U
* device instance $6290 r0 *1 54.895,15.68 nfet_01v8
M$6290 1716 4377 167 167 nfet_01v8 L=150000U W=210000U AS=40400000000P
+ AD=21875000000P PS=560000U PD=460000U
* device instance $6291 r0 *1 54.34,16.08 nfet_01v8
M$6291 78 139 2005 167 nfet_01v8 L=150000U W=140000U AS=21875000000P
+ AD=16800000000P PS=460000U PD=380000U
* device instance $6292 r0 *1 54.86,16.08 nfet_01v8
M$6292 79 139 1716 167 nfet_01v8 L=150000U W=140000U AS=21875000000P
+ AD=16800000000P PS=460000U PD=380000U
* device instance $6293 r0 *1 54.34,16.47 nfet_01v8
M$6293 2363 140 78 167 nfet_01v8 L=150000U W=140000U AS=16800000000P
+ AD=21875000000P PS=380000U PD=460000U
* device instance $6294 r0 *1 54.86,16.47 nfet_01v8
M$6294 1158 140 79 167 nfet_01v8 L=150000U W=140000U AS=16800000000P
+ AD=21875000000P PS=380000U PD=460000U
* device instance $6295 r0 *1 54.305,16.87 nfet_01v8
M$6295 167 2753 2363 167 nfet_01v8 L=150000U W=210000U AS=21875000000P
+ AD=40400000000P PS=460000U PD=560000U
* device instance $6296 r0 *1 54.895,16.87 nfet_01v8
M$6296 167 1718 1158 167 nfet_01v8 L=150000U W=210000U AS=21875000000P
+ AD=40400000000P PS=460000U PD=560000U
* device instance $6297 r0 *1 54.305,17.26 nfet_01v8
M$6297 2753 2363 167 167 nfet_01v8 L=150000U W=210000U AS=40400000000P
+ AD=21875000000P PS=560000U PD=460000U
* device instance $6298 r0 *1 54.895,17.26 nfet_01v8
M$6298 1718 1158 167 167 nfet_01v8 L=150000U W=210000U AS=40400000000P
+ AD=21875000000P PS=560000U PD=460000U
* device instance $6299 r0 *1 54.34,17.66 nfet_01v8
M$6299 77 140 2753 167 nfet_01v8 L=150000U W=140000U AS=21875000000P
+ AD=16800000000P PS=460000U PD=380000U
* device instance $6300 r0 *1 54.86,17.66 nfet_01v8
M$6300 80 140 1718 167 nfet_01v8 L=150000U W=140000U AS=21875000000P
+ AD=16800000000P PS=460000U PD=380000U
* device instance $6301 r0 *1 54.34,18.05 nfet_01v8
M$6301 2364 141 77 167 nfet_01v8 L=150000U W=140000U AS=16800000000P
+ AD=21875000000P PS=380000U PD=460000U
* device instance $6302 r0 *1 54.86,18.05 nfet_01v8
M$6302 1156 141 80 167 nfet_01v8 L=150000U W=140000U AS=16800000000P
+ AD=21875000000P PS=380000U PD=460000U
* device instance $6303 r0 *1 54.305,18.45 nfet_01v8
M$6303 167 2756 2364 167 nfet_01v8 L=150000U W=210000U AS=21875000000P
+ AD=40400000000P PS=460000U PD=560000U
* device instance $6304 r0 *1 54.895,18.45 nfet_01v8
M$6304 167 1715 1156 167 nfet_01v8 L=150000U W=210000U AS=21875000000P
+ AD=40400000000P PS=460000U PD=560000U
* device instance $6305 r0 *1 54.305,18.84 nfet_01v8
M$6305 2756 2364 167 167 nfet_01v8 L=150000U W=210000U AS=40400000000P
+ AD=21875000000P PS=560000U PD=460000U
* device instance $6306 r0 *1 54.895,18.84 nfet_01v8
M$6306 1715 1156 167 167 nfet_01v8 L=150000U W=210000U AS=40400000000P
+ AD=21875000000P PS=560000U PD=460000U
* device instance $6307 r0 *1 54.34,19.24 nfet_01v8
M$6307 78 141 2756 167 nfet_01v8 L=150000U W=140000U AS=21875000000P
+ AD=16800000000P PS=460000U PD=380000U
* device instance $6308 r0 *1 54.86,19.24 nfet_01v8
M$6308 79 141 1715 167 nfet_01v8 L=150000U W=140000U AS=21875000000P
+ AD=16800000000P PS=460000U PD=380000U
* device instance $6309 r0 *1 65.24,13.31 nfet_01v8
M$6309 3370 138 94 167 nfet_01v8 L=150000U W=140000U AS=16800000000P
+ AD=21875000000P PS=380000U PD=460000U
* device instance $6310 r0 *1 65.76,13.31 nfet_01v8
M$6310 1177 138 95 167 nfet_01v8 L=150000U W=140000U AS=16800000000P
+ AD=21875000000P PS=380000U PD=460000U
* device instance $6311 r0 *1 65.205,13.71 nfet_01v8
M$6311 167 2803 3370 167 nfet_01v8 L=150000U W=210000U AS=21875000000P
+ AD=40400000000P PS=460000U PD=560000U
* device instance $6312 r0 *1 65.795,13.71 nfet_01v8
M$6312 167 1740 1177 167 nfet_01v8 L=150000U W=210000U AS=21875000000P
+ AD=40400000000P PS=460000U PD=560000U
* device instance $6313 r0 *1 65.205,14.1 nfet_01v8
M$6313 2803 3370 167 167 nfet_01v8 L=150000U W=210000U AS=40400000000P
+ AD=21875000000P PS=560000U PD=460000U
* device instance $6314 r0 *1 65.795,14.1 nfet_01v8
M$6314 1740 1177 167 167 nfet_01v8 L=150000U W=210000U AS=40400000000P
+ AD=21875000000P PS=560000U PD=460000U
* device instance $6315 r0 *1 65.24,14.5 nfet_01v8
M$6315 93 138 2803 167 nfet_01v8 L=150000U W=140000U AS=21875000000P
+ AD=16800000000P PS=460000U PD=380000U
* device instance $6316 r0 *1 65.76,14.5 nfet_01v8
M$6316 96 138 1740 167 nfet_01v8 L=150000U W=140000U AS=21875000000P
+ AD=16800000000P PS=460000U PD=380000U
* device instance $6317 r0 *1 65.24,14.89 nfet_01v8
M$6317 3357 139 93 167 nfet_01v8 L=150000U W=140000U AS=16800000000P
+ AD=21875000000P PS=380000U PD=460000U
* device instance $6318 r0 *1 65.76,14.89 nfet_01v8
M$6318 4369 139 96 167 nfet_01v8 L=150000U W=140000U AS=16800000000P
+ AD=21875000000P PS=380000U PD=460000U
* device instance $6319 r0 *1 65.205,15.29 nfet_01v8
M$6319 167 1976 3357 167 nfet_01v8 L=150000U W=210000U AS=21875000000P
+ AD=40400000000P PS=460000U PD=560000U
* device instance $6320 r0 *1 65.795,15.29 nfet_01v8
M$6320 167 848 4369 167 nfet_01v8 L=150000U W=210000U AS=21875000000P
+ AD=40400000000P PS=460000U PD=560000U
* device instance $6321 r0 *1 65.205,15.68 nfet_01v8
M$6321 1976 3357 167 167 nfet_01v8 L=150000U W=210000U AS=40400000000P
+ AD=21875000000P PS=560000U PD=460000U
* device instance $6322 r0 *1 65.795,15.68 nfet_01v8
M$6322 848 4369 167 167 nfet_01v8 L=150000U W=210000U AS=40400000000P
+ AD=21875000000P PS=560000U PD=460000U
* device instance $6323 r0 *1 65.24,16.08 nfet_01v8
M$6323 94 139 1976 167 nfet_01v8 L=150000U W=140000U AS=21875000000P
+ AD=16800000000P PS=460000U PD=380000U
* device instance $6324 r0 *1 65.76,16.08 nfet_01v8
M$6324 95 139 848 167 nfet_01v8 L=150000U W=140000U AS=21875000000P
+ AD=16800000000P PS=460000U PD=380000U
* device instance $6325 r0 *1 65.24,16.47 nfet_01v8
M$6325 2106 140 94 167 nfet_01v8 L=150000U W=140000U AS=16800000000P
+ AD=21875000000P PS=380000U PD=460000U
* device instance $6326 r0 *1 65.76,16.47 nfet_01v8
M$6326 650 140 95 167 nfet_01v8 L=150000U W=140000U AS=16800000000P
+ AD=21875000000P PS=380000U PD=460000U
* device instance $6327 r0 *1 65.205,16.87 nfet_01v8
M$6327 167 2214 2106 167 nfet_01v8 L=150000U W=210000U AS=21875000000P
+ AD=40400000000P PS=460000U PD=560000U
* device instance $6328 r0 *1 65.795,16.87 nfet_01v8
M$6328 167 820 650 167 nfet_01v8 L=150000U W=210000U AS=21875000000P
+ AD=40400000000P PS=460000U PD=560000U
* device instance $6329 r0 *1 65.205,17.26 nfet_01v8
M$6329 2214 2106 167 167 nfet_01v8 L=150000U W=210000U AS=40400000000P
+ AD=21875000000P PS=560000U PD=460000U
* device instance $6330 r0 *1 65.795,17.26 nfet_01v8
M$6330 820 650 167 167 nfet_01v8 L=150000U W=210000U AS=40400000000P
+ AD=21875000000P PS=560000U PD=460000U
* device instance $6331 r0 *1 65.24,17.66 nfet_01v8
M$6331 93 140 2214 167 nfet_01v8 L=150000U W=140000U AS=21875000000P
+ AD=16800000000P PS=460000U PD=380000U
* device instance $6332 r0 *1 65.76,17.66 nfet_01v8
M$6332 96 140 820 167 nfet_01v8 L=150000U W=140000U AS=21875000000P
+ AD=16800000000P PS=460000U PD=380000U
* device instance $6333 r0 *1 65.24,18.05 nfet_01v8
M$6333 2380 141 93 167 nfet_01v8 L=150000U W=140000U AS=16800000000P
+ AD=21875000000P PS=380000U PD=460000U
* device instance $6334 r0 *1 65.76,18.05 nfet_01v8
M$6334 1179 141 96 167 nfet_01v8 L=150000U W=140000U AS=16800000000P
+ AD=21875000000P PS=380000U PD=460000U
* device instance $6335 r0 *1 65.205,18.45 nfet_01v8
M$6335 167 2782 2380 167 nfet_01v8 L=150000U W=210000U AS=21875000000P
+ AD=40400000000P PS=460000U PD=560000U
* device instance $6336 r0 *1 65.795,18.45 nfet_01v8
M$6336 167 1742 1179 167 nfet_01v8 L=150000U W=210000U AS=21875000000P
+ AD=40400000000P PS=460000U PD=560000U
* device instance $6337 r0 *1 65.205,18.84 nfet_01v8
M$6337 2782 2380 167 167 nfet_01v8 L=150000U W=210000U AS=40400000000P
+ AD=21875000000P PS=560000U PD=460000U
* device instance $6338 r0 *1 65.795,18.84 nfet_01v8
M$6338 1742 1179 167 167 nfet_01v8 L=150000U W=210000U AS=40400000000P
+ AD=21875000000P PS=560000U PD=460000U
* device instance $6339 r0 *1 65.24,19.24 nfet_01v8
M$6339 94 141 2782 167 nfet_01v8 L=150000U W=140000U AS=21875000000P
+ AD=16800000000P PS=460000U PD=380000U
* device instance $6340 r0 *1 65.76,19.24 nfet_01v8
M$6340 95 141 1742 167 nfet_01v8 L=150000U W=140000U AS=21875000000P
+ AD=16800000000P PS=460000U PD=380000U
* device instance $6341 r0 *1 76.14,13.31 nfet_01v8
M$6341 3374 138 110 167 nfet_01v8 L=150000U W=140000U AS=16800000000P
+ AD=21875000000P PS=380000U PD=460000U
* device instance $6342 r0 *1 76.66,13.31 nfet_01v8
M$6342 1120 138 111 167 nfet_01v8 L=150000U W=140000U AS=16800000000P
+ AD=21875000000P PS=380000U PD=460000U
* device instance $6343 r0 *1 76.105,13.71 nfet_01v8
M$6343 167 3024 3374 167 nfet_01v8 L=150000U W=210000U AS=21875000000P
+ AD=40400000000P PS=460000U PD=560000U
* device instance $6344 r0 *1 76.695,13.71 nfet_01v8
M$6344 167 1675 1120 167 nfet_01v8 L=150000U W=210000U AS=21875000000P
+ AD=40400000000P PS=460000U PD=560000U
* device instance $6345 r0 *1 76.105,14.1 nfet_01v8
M$6345 3024 3374 167 167 nfet_01v8 L=150000U W=210000U AS=40400000000P
+ AD=21875000000P PS=560000U PD=460000U
* device instance $6346 r0 *1 76.695,14.1 nfet_01v8
M$6346 1675 1120 167 167 nfet_01v8 L=150000U W=210000U AS=40400000000P
+ AD=21875000000P PS=560000U PD=460000U
* device instance $6347 r0 *1 76.14,14.5 nfet_01v8
M$6347 109 138 3024 167 nfet_01v8 L=150000U W=140000U AS=21875000000P
+ AD=16800000000P PS=460000U PD=380000U
* device instance $6348 r0 *1 76.66,14.5 nfet_01v8
M$6348 112 138 1675 167 nfet_01v8 L=150000U W=140000U AS=21875000000P
+ AD=16800000000P PS=460000U PD=380000U
* device instance $6349 r0 *1 76.14,14.89 nfet_01v8
M$6349 3399 139 109 167 nfet_01v8 L=150000U W=140000U AS=16800000000P
+ AD=21875000000P PS=380000U PD=460000U
* device instance $6350 r0 *1 76.66,14.89 nfet_01v8
M$6350 4343 139 112 167 nfet_01v8 L=150000U W=140000U AS=16800000000P
+ AD=21875000000P PS=380000U PD=460000U
* device instance $6351 r0 *1 76.105,15.29 nfet_01v8
M$6351 167 2925 3399 167 nfet_01v8 L=150000U W=210000U AS=21875000000P
+ AD=40400000000P PS=460000U PD=560000U
* device instance $6352 r0 *1 76.695,15.29 nfet_01v8
M$6352 167 1668 4343 167 nfet_01v8 L=150000U W=210000U AS=21875000000P
+ AD=40400000000P PS=460000U PD=560000U
* device instance $6353 r0 *1 76.105,15.68 nfet_01v8
M$6353 2925 3399 167 167 nfet_01v8 L=150000U W=210000U AS=40400000000P
+ AD=21875000000P PS=560000U PD=460000U
* device instance $6354 r0 *1 76.695,15.68 nfet_01v8
M$6354 1668 4343 167 167 nfet_01v8 L=150000U W=210000U AS=40400000000P
+ AD=21875000000P PS=560000U PD=460000U
* device instance $6355 r0 *1 76.14,16.08 nfet_01v8
M$6355 110 139 2925 167 nfet_01v8 L=150000U W=140000U AS=21875000000P
+ AD=16800000000P PS=460000U PD=380000U
* device instance $6356 r0 *1 76.66,16.08 nfet_01v8
M$6356 111 139 1668 167 nfet_01v8 L=150000U W=140000U AS=21875000000P
+ AD=16800000000P PS=460000U PD=380000U
* device instance $6357 r0 *1 76.14,16.47 nfet_01v8
M$6357 3404 140 110 167 nfet_01v8 L=150000U W=140000U AS=16800000000P
+ AD=21875000000P PS=380000U PD=460000U
* device instance $6358 r0 *1 76.66,16.47 nfet_01v8
M$6358 594 140 111 167 nfet_01v8 L=150000U W=140000U AS=16800000000P
+ AD=21875000000P PS=380000U PD=460000U
* device instance $6359 r0 *1 76.105,16.87 nfet_01v8
M$6359 167 2127 3404 167 nfet_01v8 L=150000U W=210000U AS=21875000000P
+ AD=40400000000P PS=460000U PD=560000U
* device instance $6360 r0 *1 76.695,16.87 nfet_01v8
M$6360 167 707 594 167 nfet_01v8 L=150000U W=210000U AS=21875000000P
+ AD=40400000000P PS=460000U PD=560000U
* device instance $6361 r0 *1 76.105,17.26 nfet_01v8
M$6361 2127 3404 167 167 nfet_01v8 L=150000U W=210000U AS=40400000000P
+ AD=21875000000P PS=560000U PD=460000U
* device instance $6362 r0 *1 76.695,17.26 nfet_01v8
M$6362 707 594 167 167 nfet_01v8 L=150000U W=210000U AS=40400000000P
+ AD=21875000000P PS=560000U PD=460000U
* device instance $6363 r0 *1 76.14,17.66 nfet_01v8
M$6363 109 140 2127 167 nfet_01v8 L=150000U W=140000U AS=21875000000P
+ AD=16800000000P PS=460000U PD=380000U
* device instance $6364 r0 *1 76.66,17.66 nfet_01v8
M$6364 112 140 707 167 nfet_01v8 L=150000U W=140000U AS=21875000000P
+ AD=16800000000P PS=460000U PD=380000U
* device instance $6365 r0 *1 76.14,18.05 nfet_01v8
M$6365 2453 141 109 167 nfet_01v8 L=150000U W=140000U AS=16800000000P
+ AD=21875000000P PS=380000U PD=460000U
* device instance $6366 r0 *1 76.66,18.05 nfet_01v8
M$6366 1114 141 112 167 nfet_01v8 L=150000U W=140000U AS=16800000000P
+ AD=21875000000P PS=380000U PD=460000U
* device instance $6367 r0 *1 76.105,18.45 nfet_01v8
M$6367 167 2926 2453 167 nfet_01v8 L=150000U W=210000U AS=21875000000P
+ AD=40400000000P PS=460000U PD=560000U
* device instance $6368 r0 *1 76.695,18.45 nfet_01v8
M$6368 167 1667 1114 167 nfet_01v8 L=150000U W=210000U AS=21875000000P
+ AD=40400000000P PS=460000U PD=560000U
* device instance $6369 r0 *1 76.105,18.84 nfet_01v8
M$6369 2926 2453 167 167 nfet_01v8 L=150000U W=210000U AS=40400000000P
+ AD=21875000000P PS=560000U PD=460000U
* device instance $6370 r0 *1 76.695,18.84 nfet_01v8
M$6370 1667 1114 167 167 nfet_01v8 L=150000U W=210000U AS=40400000000P
+ AD=21875000000P PS=560000U PD=460000U
* device instance $6371 r0 *1 76.14,19.24 nfet_01v8
M$6371 110 141 2926 167 nfet_01v8 L=150000U W=140000U AS=21875000000P
+ AD=16800000000P PS=460000U PD=380000U
* device instance $6372 r0 *1 76.66,19.24 nfet_01v8
M$6372 111 141 1667 167 nfet_01v8 L=150000U W=140000U AS=21875000000P
+ AD=16800000000P PS=460000U PD=380000U
* device instance $6373 r0 *1 10.74,5.41 nfet_01v8
M$6373 3222 134 14 167 nfet_01v8 L=150000U W=140000U AS=16800000000P
+ AD=21875000000P PS=380000U PD=460000U
* device instance $6374 r0 *1 11.26,5.41 nfet_01v8
M$6374 1024 134 15 167 nfet_01v8 L=150000U W=140000U AS=16800000000P
+ AD=21875000000P PS=380000U PD=460000U
* device instance $6375 r0 *1 10.705,5.81 nfet_01v8
M$6375 167 3106 3222 167 nfet_01v8 L=150000U W=210000U AS=21875000000P
+ AD=40400000000P PS=460000U PD=560000U
* device instance $6376 r0 *1 11.295,5.81 nfet_01v8
M$6376 167 1561 1024 167 nfet_01v8 L=150000U W=210000U AS=21875000000P
+ AD=40400000000P PS=460000U PD=560000U
* device instance $6377 r0 *1 10.705,6.2 nfet_01v8
M$6377 3106 3222 167 167 nfet_01v8 L=150000U W=210000U AS=40400000000P
+ AD=21875000000P PS=560000U PD=460000U
* device instance $6378 r0 *1 11.295,6.2 nfet_01v8
M$6378 1561 1024 167 167 nfet_01v8 L=150000U W=210000U AS=40400000000P
+ AD=21875000000P PS=560000U PD=460000U
* device instance $6379 r0 *1 10.74,6.6 nfet_01v8
M$6379 13 134 3106 167 nfet_01v8 L=150000U W=140000U AS=21875000000P
+ AD=16800000000P PS=460000U PD=380000U
* device instance $6380 r0 *1 11.26,6.6 nfet_01v8
M$6380 16 134 1561 167 nfet_01v8 L=150000U W=140000U AS=21875000000P
+ AD=16800000000P PS=460000U PD=380000U
* device instance $6381 r0 *1 10.74,6.99 nfet_01v8
M$6381 3213 135 13 167 nfet_01v8 L=150000U W=140000U AS=16800000000P
+ AD=21875000000P PS=380000U PD=460000U
* device instance $6382 r0 *1 11.26,6.99 nfet_01v8
M$6382 4504 135 16 167 nfet_01v8 L=150000U W=140000U AS=16800000000P
+ AD=21875000000P PS=380000U PD=460000U
* device instance $6383 r0 *1 10.705,7.39 nfet_01v8
M$6383 167 3068 3213 167 nfet_01v8 L=150000U W=210000U AS=21875000000P
+ AD=40400000000P PS=460000U PD=560000U
* device instance $6384 r0 *1 11.295,7.39 nfet_01v8
M$6384 167 864 4504 167 nfet_01v8 L=150000U W=210000U AS=21875000000P
+ AD=40400000000P PS=460000U PD=560000U
* device instance $6385 r0 *1 10.705,7.78 nfet_01v8
M$6385 3068 3213 167 167 nfet_01v8 L=150000U W=210000U AS=40400000000P
+ AD=21875000000P PS=560000U PD=460000U
* device instance $6386 r0 *1 11.295,7.78 nfet_01v8
M$6386 864 4504 167 167 nfet_01v8 L=150000U W=210000U AS=40400000000P
+ AD=21875000000P PS=560000U PD=460000U
* device instance $6387 r0 *1 10.74,8.18 nfet_01v8
M$6387 14 135 3068 167 nfet_01v8 L=150000U W=140000U AS=21875000000P
+ AD=16800000000P PS=460000U PD=380000U
* device instance $6388 r0 *1 11.26,8.18 nfet_01v8
M$6388 15 135 864 167 nfet_01v8 L=150000U W=140000U AS=21875000000P
+ AD=16800000000P PS=460000U PD=380000U
* device instance $6389 r0 *1 10.74,8.57 nfet_01v8
M$6389 2116 136 14 167 nfet_01v8 L=150000U W=140000U AS=16800000000P
+ AD=21875000000P PS=380000U PD=460000U
* device instance $6390 r0 *1 11.26,8.57 nfet_01v8
M$6390 628 136 15 167 nfet_01v8 L=150000U W=140000U AS=16800000000P
+ AD=21875000000P PS=380000U PD=460000U
* device instance $6391 r0 *1 10.705,8.97 nfet_01v8
M$6391 167 2240 2116 167 nfet_01v8 L=150000U W=210000U AS=21875000000P
+ AD=40400000000P PS=460000U PD=560000U
* device instance $6392 r0 *1 11.295,8.97 nfet_01v8
M$6392 167 776 628 167 nfet_01v8 L=150000U W=210000U AS=21875000000P
+ AD=40400000000P PS=460000U PD=560000U
* device instance $6393 r0 *1 10.705,9.36 nfet_01v8
M$6393 2240 2116 167 167 nfet_01v8 L=150000U W=210000U AS=40400000000P
+ AD=21875000000P PS=560000U PD=460000U
* device instance $6394 r0 *1 11.295,9.36 nfet_01v8
M$6394 776 628 167 167 nfet_01v8 L=150000U W=210000U AS=40400000000P
+ AD=21875000000P PS=560000U PD=460000U
* device instance $6395 r0 *1 10.74,9.76 nfet_01v8
M$6395 13 136 2240 167 nfet_01v8 L=150000U W=140000U AS=21875000000P
+ AD=16800000000P PS=460000U PD=380000U
* device instance $6396 r0 *1 11.26,9.76 nfet_01v8
M$6396 16 136 776 167 nfet_01v8 L=150000U W=140000U AS=21875000000P
+ AD=16800000000P PS=460000U PD=380000U
* device instance $6397 r0 *1 10.74,10.15 nfet_01v8
M$6397 2432 137 13 167 nfet_01v8 L=150000U W=140000U AS=16800000000P
+ AD=21875000000P PS=380000U PD=460000U
* device instance $6398 r0 *1 11.26,10.15 nfet_01v8
M$6398 1298 137 16 167 nfet_01v8 L=150000U W=140000U AS=16800000000P
+ AD=21875000000P PS=380000U PD=460000U
* device instance $6399 r0 *1 10.705,10.55 nfet_01v8
M$6399 167 2882 2432 167 nfet_01v8 L=150000U W=210000U AS=21875000000P
+ AD=40400000000P PS=460000U PD=560000U
* device instance $6400 r0 *1 11.295,10.55 nfet_01v8
M$6400 167 1875 1298 167 nfet_01v8 L=150000U W=210000U AS=21875000000P
+ AD=40400000000P PS=460000U PD=560000U
* device instance $6401 r0 *1 10.705,10.94 nfet_01v8
M$6401 2882 2432 167 167 nfet_01v8 L=150000U W=210000U AS=40400000000P
+ AD=21875000000P PS=560000U PD=460000U
* device instance $6402 r0 *1 11.295,10.94 nfet_01v8
M$6402 1875 1298 167 167 nfet_01v8 L=150000U W=210000U AS=40400000000P
+ AD=21875000000P PS=560000U PD=460000U
* device instance $6403 r0 *1 10.74,11.34 nfet_01v8
M$6403 14 137 2882 167 nfet_01v8 L=150000U W=140000U AS=21875000000P
+ AD=16800000000P PS=460000U PD=380000U
* device instance $6404 r0 *1 11.26,11.34 nfet_01v8
M$6404 15 137 1875 167 nfet_01v8 L=150000U W=140000U AS=21875000000P
+ AD=16800000000P PS=460000U PD=380000U
* device instance $6405 r0 *1 21.64,5.41 nfet_01v8
M$6405 2475 134 30 167 nfet_01v8 L=150000U W=140000U AS=16800000000P
+ AD=21875000000P PS=380000U PD=460000U
* device instance $6406 r0 *1 22.16,5.41 nfet_01v8
M$6406 999 134 31 167 nfet_01v8 L=150000U W=140000U AS=16800000000P
+ AD=21875000000P PS=380000U PD=460000U
* device instance $6407 r0 *1 21.605,5.81 nfet_01v8
M$6407 167 2973 2475 167 nfet_01v8 L=150000U W=210000U AS=21875000000P
+ AD=40400000000P PS=460000U PD=560000U
* device instance $6408 r0 *1 22.195,5.81 nfet_01v8
M$6408 167 1534 999 167 nfet_01v8 L=150000U W=210000U AS=21875000000P
+ AD=40400000000P PS=460000U PD=560000U
* device instance $6409 r0 *1 21.605,6.2 nfet_01v8
M$6409 2973 2475 167 167 nfet_01v8 L=150000U W=210000U AS=40400000000P
+ AD=21875000000P PS=560000U PD=460000U
* device instance $6410 r0 *1 22.195,6.2 nfet_01v8
M$6410 1534 999 167 167 nfet_01v8 L=150000U W=210000U AS=40400000000P
+ AD=21875000000P PS=560000U PD=460000U
* device instance $6411 r0 *1 21.64,6.6 nfet_01v8
M$6411 29 134 2973 167 nfet_01v8 L=150000U W=140000U AS=21875000000P
+ AD=16800000000P PS=460000U PD=380000U
* device instance $6412 r0 *1 22.16,6.6 nfet_01v8
M$6412 32 134 1534 167 nfet_01v8 L=150000U W=140000U AS=21875000000P
+ AD=16800000000P PS=460000U PD=380000U
* device instance $6413 r0 *1 21.64,6.99 nfet_01v8
M$6413 3223 135 29 167 nfet_01v8 L=150000U W=140000U AS=16800000000P
+ AD=21875000000P PS=380000U PD=460000U
* device instance $6414 r0 *1 22.16,6.99 nfet_01v8
M$6414 4509 135 32 167 nfet_01v8 L=150000U W=140000U AS=16800000000P
+ AD=21875000000P PS=380000U PD=460000U
* device instance $6415 r0 *1 21.605,7.39 nfet_01v8
M$6415 167 2047 3223 167 nfet_01v8 L=150000U W=210000U AS=21875000000P
+ AD=40400000000P PS=460000U PD=560000U
* device instance $6416 r0 *1 22.195,7.39 nfet_01v8
M$6416 167 849 4509 167 nfet_01v8 L=150000U W=210000U AS=21875000000P
+ AD=40400000000P PS=460000U PD=560000U
* device instance $6417 r0 *1 21.605,7.78 nfet_01v8
M$6417 2047 3223 167 167 nfet_01v8 L=150000U W=210000U AS=40400000000P
+ AD=21875000000P PS=560000U PD=460000U
* device instance $6418 r0 *1 22.195,7.78 nfet_01v8
M$6418 849 4509 167 167 nfet_01v8 L=150000U W=210000U AS=40400000000P
+ AD=21875000000P PS=560000U PD=460000U
* device instance $6419 r0 *1 21.64,8.18 nfet_01v8
M$6419 30 135 2047 167 nfet_01v8 L=150000U W=140000U AS=21875000000P
+ AD=16800000000P PS=460000U PD=380000U
* device instance $6420 r0 *1 22.16,8.18 nfet_01v8
M$6420 31 135 849 167 nfet_01v8 L=150000U W=140000U AS=21875000000P
+ AD=16800000000P PS=460000U PD=380000U
* device instance $6421 r0 *1 21.64,8.57 nfet_01v8
M$6421 3214 136 30 167 nfet_01v8 L=150000U W=140000U AS=16800000000P
+ AD=21875000000P PS=380000U PD=460000U
* device instance $6422 r0 *1 22.16,8.57 nfet_01v8
M$6422 659 136 31 167 nfet_01v8 L=150000U W=140000U AS=16800000000P
+ AD=21875000000P PS=380000U PD=460000U
* device instance $6423 r0 *1 21.605,8.97 nfet_01v8
M$6423 167 2960 3214 167 nfet_01v8 L=150000U W=210000U AS=21875000000P
+ AD=40400000000P PS=460000U PD=560000U
* device instance $6424 r0 *1 22.195,8.97 nfet_01v8
M$6424 167 839 659 167 nfet_01v8 L=150000U W=210000U AS=21875000000P
+ AD=40400000000P PS=460000U PD=560000U
* device instance $6425 r0 *1 21.605,9.36 nfet_01v8
M$6425 2960 3214 167 167 nfet_01v8 L=150000U W=210000U AS=40400000000P
+ AD=21875000000P PS=560000U PD=460000U
* device instance $6426 r0 *1 22.195,9.36 nfet_01v8
M$6426 839 659 167 167 nfet_01v8 L=150000U W=210000U AS=40400000000P
+ AD=21875000000P PS=560000U PD=460000U
* device instance $6427 r0 *1 21.64,9.76 nfet_01v8
M$6427 29 136 2960 167 nfet_01v8 L=150000U W=140000U AS=21875000000P
+ AD=16800000000P PS=460000U PD=380000U
* device instance $6428 r0 *1 22.16,9.76 nfet_01v8
M$6428 32 136 839 167 nfet_01v8 L=150000U W=140000U AS=21875000000P
+ AD=16800000000P PS=460000U PD=380000U
* device instance $6429 r0 *1 21.64,10.15 nfet_01v8
M$6429 3293 137 29 167 nfet_01v8 L=150000U W=140000U AS=16800000000P
+ AD=21875000000P PS=380000U PD=460000U
* device instance $6430 r0 *1 22.16,10.15 nfet_01v8
M$6430 1300 137 32 167 nfet_01v8 L=150000U W=140000U AS=16800000000P
+ AD=21875000000P PS=380000U PD=460000U
* device instance $6431 r0 *1 21.605,10.55 nfet_01v8
M$6431 167 2726 3293 167 nfet_01v8 L=150000U W=210000U AS=21875000000P
+ AD=40400000000P PS=460000U PD=560000U
* device instance $6432 r0 *1 22.195,10.55 nfet_01v8
M$6432 167 1878 1300 167 nfet_01v8 L=150000U W=210000U AS=21875000000P
+ AD=40400000000P PS=460000U PD=560000U
* device instance $6433 r0 *1 21.605,10.94 nfet_01v8
M$6433 2726 3293 167 167 nfet_01v8 L=150000U W=210000U AS=40400000000P
+ AD=21875000000P PS=560000U PD=460000U
* device instance $6434 r0 *1 22.195,10.94 nfet_01v8
M$6434 1878 1300 167 167 nfet_01v8 L=150000U W=210000U AS=40400000000P
+ AD=21875000000P PS=560000U PD=460000U
* device instance $6435 r0 *1 21.64,11.34 nfet_01v8
M$6435 30 137 2726 167 nfet_01v8 L=150000U W=140000U AS=21875000000P
+ AD=16800000000P PS=460000U PD=380000U
* device instance $6436 r0 *1 22.16,11.34 nfet_01v8
M$6436 31 137 1878 167 nfet_01v8 L=150000U W=140000U AS=21875000000P
+ AD=16800000000P PS=460000U PD=380000U
* device instance $6437 r0 *1 32.54,5.41 nfet_01v8
M$6437 3256 134 46 167 nfet_01v8 L=150000U W=140000U AS=16800000000P
+ AD=21875000000P PS=380000U PD=460000U
* device instance $6438 r0 *1 33.06,5.41 nfet_01v8
M$6438 1034 134 47 167 nfet_01v8 L=150000U W=140000U AS=16800000000P
+ AD=21875000000P PS=380000U PD=460000U
* device instance $6439 r0 *1 32.505,5.81 nfet_01v8
M$6439 167 2970 3256 167 nfet_01v8 L=150000U W=210000U AS=21875000000P
+ AD=40400000000P PS=460000U PD=560000U
* device instance $6440 r0 *1 33.095,5.81 nfet_01v8
M$6440 167 1573 1034 167 nfet_01v8 L=150000U W=210000U AS=21875000000P
+ AD=40400000000P PS=460000U PD=560000U
* device instance $6441 r0 *1 32.505,6.2 nfet_01v8
M$6441 2970 3256 167 167 nfet_01v8 L=150000U W=210000U AS=40400000000P
+ AD=21875000000P PS=560000U PD=460000U
* device instance $6442 r0 *1 33.095,6.2 nfet_01v8
M$6442 1573 1034 167 167 nfet_01v8 L=150000U W=210000U AS=40400000000P
+ AD=21875000000P PS=560000U PD=460000U
* device instance $6443 r0 *1 32.54,6.6 nfet_01v8
M$6443 45 134 2970 167 nfet_01v8 L=150000U W=140000U AS=21875000000P
+ AD=16800000000P PS=460000U PD=380000U
* device instance $6444 r0 *1 33.06,6.6 nfet_01v8
M$6444 48 134 1573 167 nfet_01v8 L=150000U W=140000U AS=21875000000P
+ AD=16800000000P PS=460000U PD=380000U
* device instance $6445 r0 *1 32.54,6.99 nfet_01v8
M$6445 3251 135 45 167 nfet_01v8 L=150000U W=140000U AS=16800000000P
+ AD=21875000000P PS=380000U PD=460000U
* device instance $6446 r0 *1 33.06,6.99 nfet_01v8
M$6446 4289 135 48 167 nfet_01v8 L=150000U W=140000U AS=16800000000P
+ AD=21875000000P PS=380000U PD=460000U
* device instance $6447 r0 *1 32.505,7.39 nfet_01v8
M$6447 167 2959 3251 167 nfet_01v8 L=150000U W=210000U AS=21875000000P
+ AD=40400000000P PS=460000U PD=560000U
* device instance $6448 r0 *1 33.095,7.39 nfet_01v8
M$6448 167 802 4289 167 nfet_01v8 L=150000U W=210000U AS=21875000000P
+ AD=40400000000P PS=460000U PD=560000U
* device instance $6449 r0 *1 32.505,7.78 nfet_01v8
M$6449 2959 3251 167 167 nfet_01v8 L=150000U W=210000U AS=40400000000P
+ AD=21875000000P PS=560000U PD=460000U
* device instance $6450 r0 *1 33.095,7.78 nfet_01v8
M$6450 802 4289 167 167 nfet_01v8 L=150000U W=210000U AS=40400000000P
+ AD=21875000000P PS=560000U PD=460000U
* device instance $6451 r0 *1 32.54,8.18 nfet_01v8
M$6451 46 135 2959 167 nfet_01v8 L=150000U W=140000U AS=21875000000P
+ AD=16800000000P PS=460000U PD=380000U
* device instance $6452 r0 *1 33.06,8.18 nfet_01v8
M$6452 47 135 802 167 nfet_01v8 L=150000U W=140000U AS=21875000000P
+ AD=16800000000P PS=460000U PD=380000U
* device instance $6453 r0 *1 32.54,8.57 nfet_01v8
M$6453 2457 136 46 167 nfet_01v8 L=150000U W=140000U AS=16800000000P
+ AD=21875000000P PS=380000U PD=460000U
* device instance $6454 r0 *1 33.06,8.57 nfet_01v8
M$6454 1033 136 47 167 nfet_01v8 L=150000U W=140000U AS=16800000000P
+ AD=21875000000P PS=380000U PD=460000U
* device instance $6455 r0 *1 32.505,8.97 nfet_01v8
M$6455 167 2935 2457 167 nfet_01v8 L=150000U W=210000U AS=21875000000P
+ AD=40400000000P PS=460000U PD=560000U
* device instance $6456 r0 *1 33.095,8.97 nfet_01v8
M$6456 167 1572 1033 167 nfet_01v8 L=150000U W=210000U AS=21875000000P
+ AD=40400000000P PS=460000U PD=560000U
* device instance $6457 r0 *1 32.505,9.36 nfet_01v8
M$6457 2935 2457 167 167 nfet_01v8 L=150000U W=210000U AS=40400000000P
+ AD=21875000000P PS=560000U PD=460000U
* device instance $6458 r0 *1 33.095,9.36 nfet_01v8
M$6458 1572 1033 167 167 nfet_01v8 L=150000U W=210000U AS=40400000000P
+ AD=21875000000P PS=560000U PD=460000U
* device instance $6459 r0 *1 32.54,9.76 nfet_01v8
M$6459 45 136 2935 167 nfet_01v8 L=150000U W=140000U AS=21875000000P
+ AD=16800000000P PS=460000U PD=380000U
* device instance $6460 r0 *1 33.06,9.76 nfet_01v8
M$6460 48 136 1572 167 nfet_01v8 L=150000U W=140000U AS=21875000000P
+ AD=16800000000P PS=460000U PD=380000U
* device instance $6461 r0 *1 32.54,10.15 nfet_01v8
M$6461 3191 137 45 167 nfet_01v8 L=150000U W=140000U AS=16800000000P
+ AD=21875000000P PS=380000U PD=460000U
* device instance $6462 r0 *1 33.06,10.15 nfet_01v8
M$6462 1005 137 48 167 nfet_01v8 L=150000U W=140000U AS=16800000000P
+ AD=21875000000P PS=380000U PD=460000U
* device instance $6463 r0 *1 32.505,10.55 nfet_01v8
M$6463 167 2948 3191 167 nfet_01v8 L=150000U W=210000U AS=21875000000P
+ AD=40400000000P PS=460000U PD=560000U
* device instance $6464 r0 *1 33.095,10.55 nfet_01v8
M$6464 167 1540 1005 167 nfet_01v8 L=150000U W=210000U AS=21875000000P
+ AD=40400000000P PS=460000U PD=560000U
* device instance $6465 r0 *1 32.505,10.94 nfet_01v8
M$6465 2948 3191 167 167 nfet_01v8 L=150000U W=210000U AS=40400000000P
+ AD=21875000000P PS=560000U PD=460000U
* device instance $6466 r0 *1 33.095,10.94 nfet_01v8
M$6466 1540 1005 167 167 nfet_01v8 L=150000U W=210000U AS=40400000000P
+ AD=21875000000P PS=560000U PD=460000U
* device instance $6467 r0 *1 32.54,11.34 nfet_01v8
M$6467 46 137 2948 167 nfet_01v8 L=150000U W=140000U AS=21875000000P
+ AD=16800000000P PS=460000U PD=380000U
* device instance $6468 r0 *1 33.06,11.34 nfet_01v8
M$6468 47 137 1540 167 nfet_01v8 L=150000U W=140000U AS=21875000000P
+ AD=16800000000P PS=460000U PD=380000U
* device instance $6469 r0 *1 43.44,5.41 nfet_01v8
M$6469 2526 134 62 167 nfet_01v8 L=150000U W=140000U AS=16800000000P
+ AD=21875000000P PS=380000U PD=460000U
* device instance $6470 r0 *1 43.96,5.41 nfet_01v8
M$6470 952 134 63 167 nfet_01v8 L=150000U W=140000U AS=16800000000P
+ AD=21875000000P PS=380000U PD=460000U
* device instance $6471 r0 *1 43.405,5.81 nfet_01v8
M$6471 167 3085 2526 167 nfet_01v8 L=150000U W=210000U AS=21875000000P
+ AD=40400000000P PS=460000U PD=560000U
* device instance $6472 r0 *1 43.995,5.81 nfet_01v8
M$6472 167 1478 952 167 nfet_01v8 L=150000U W=210000U AS=21875000000P
+ AD=40400000000P PS=460000U PD=560000U
* device instance $6473 r0 *1 43.405,6.2 nfet_01v8
M$6473 3085 2526 167 167 nfet_01v8 L=150000U W=210000U AS=40400000000P
+ AD=21875000000P PS=560000U PD=460000U
* device instance $6474 r0 *1 43.995,6.2 nfet_01v8
M$6474 1478 952 167 167 nfet_01v8 L=150000U W=210000U AS=40400000000P
+ AD=21875000000P PS=560000U PD=460000U
* device instance $6475 r0 *1 43.44,6.6 nfet_01v8
M$6475 61 134 3085 167 nfet_01v8 L=150000U W=140000U AS=21875000000P
+ AD=16800000000P PS=460000U PD=380000U
* device instance $6476 r0 *1 43.96,6.6 nfet_01v8
M$6476 64 134 1478 167 nfet_01v8 L=150000U W=140000U AS=21875000000P
+ AD=16800000000P PS=460000U PD=380000U
* device instance $6477 r0 *1 43.44,6.99 nfet_01v8
M$6477 3226 135 61 167 nfet_01v8 L=150000U W=140000U AS=16800000000P
+ AD=21875000000P PS=380000U PD=460000U
* device instance $6478 r0 *1 43.96,6.99 nfet_01v8
M$6478 4291 135 64 167 nfet_01v8 L=150000U W=140000U AS=16800000000P
+ AD=21875000000P PS=380000U PD=460000U
* device instance $6479 r0 *1 43.405,7.39 nfet_01v8
M$6479 167 3100 3226 167 nfet_01v8 L=150000U W=210000U AS=21875000000P
+ AD=40400000000P PS=460000U PD=560000U
* device instance $6480 r0 *1 43.995,7.39 nfet_01v8
M$6480 167 778 4291 167 nfet_01v8 L=150000U W=210000U AS=21875000000P
+ AD=40400000000P PS=460000U PD=560000U
* device instance $6481 r0 *1 43.405,7.78 nfet_01v8
M$6481 3100 3226 167 167 nfet_01v8 L=150000U W=210000U AS=40400000000P
+ AD=21875000000P PS=560000U PD=460000U
* device instance $6482 r0 *1 43.995,7.78 nfet_01v8
M$6482 778 4291 167 167 nfet_01v8 L=150000U W=210000U AS=40400000000P
+ AD=21875000000P PS=560000U PD=460000U
* device instance $6483 r0 *1 43.44,8.18 nfet_01v8
M$6483 62 135 3100 167 nfet_01v8 L=150000U W=140000U AS=21875000000P
+ AD=16800000000P PS=460000U PD=380000U
* device instance $6484 r0 *1 43.96,8.18 nfet_01v8
M$6484 63 135 778 167 nfet_01v8 L=150000U W=140000U AS=21875000000P
+ AD=16800000000P PS=460000U PD=380000U
* device instance $6485 r0 *1 43.44,8.57 nfet_01v8
M$6485 3227 136 62 167 nfet_01v8 L=150000U W=140000U AS=16800000000P
+ AD=21875000000P PS=380000U PD=460000U
* device instance $6486 r0 *1 43.96,8.57 nfet_01v8
M$6486 1038 136 63 167 nfet_01v8 L=150000U W=140000U AS=16800000000P
+ AD=21875000000P PS=380000U PD=460000U
* device instance $6487 r0 *1 43.405,8.97 nfet_01v8
M$6487 167 3055 3227 167 nfet_01v8 L=150000U W=210000U AS=21875000000P
+ AD=40400000000P PS=460000U PD=560000U
* device instance $6488 r0 *1 43.995,8.97 nfet_01v8
M$6488 167 1579 1038 167 nfet_01v8 L=150000U W=210000U AS=21875000000P
+ AD=40400000000P PS=460000U PD=560000U
* device instance $6489 r0 *1 43.405,9.36 nfet_01v8
M$6489 3055 3227 167 167 nfet_01v8 L=150000U W=210000U AS=40400000000P
+ AD=21875000000P PS=560000U PD=460000U
* device instance $6490 r0 *1 43.995,9.36 nfet_01v8
M$6490 1579 1038 167 167 nfet_01v8 L=150000U W=210000U AS=40400000000P
+ AD=21875000000P PS=560000U PD=460000U
* device instance $6491 r0 *1 43.44,9.76 nfet_01v8
M$6491 61 136 3055 167 nfet_01v8 L=150000U W=140000U AS=21875000000P
+ AD=16800000000P PS=460000U PD=380000U
* device instance $6492 r0 *1 43.96,9.76 nfet_01v8
M$6492 64 136 1579 167 nfet_01v8 L=150000U W=140000U AS=21875000000P
+ AD=16800000000P PS=460000U PD=380000U
* device instance $6493 r0 *1 43.44,10.15 nfet_01v8
M$6493 3194 137 61 167 nfet_01v8 L=150000U W=140000U AS=16800000000P
+ AD=21875000000P PS=380000U PD=460000U
* device instance $6494 r0 *1 43.96,10.15 nfet_01v8
M$6494 1009 137 64 167 nfet_01v8 L=150000U W=140000U AS=16800000000P
+ AD=21875000000P PS=380000U PD=460000U
* device instance $6495 r0 *1 43.405,10.55 nfet_01v8
M$6495 167 2939 3194 167 nfet_01v8 L=150000U W=210000U AS=21875000000P
+ AD=40400000000P PS=460000U PD=560000U
* device instance $6496 r0 *1 43.995,10.55 nfet_01v8
M$6496 167 1544 1009 167 nfet_01v8 L=150000U W=210000U AS=21875000000P
+ AD=40400000000P PS=460000U PD=560000U
* device instance $6497 r0 *1 43.405,10.94 nfet_01v8
M$6497 2939 3194 167 167 nfet_01v8 L=150000U W=210000U AS=40400000000P
+ AD=21875000000P PS=560000U PD=460000U
* device instance $6498 r0 *1 43.995,10.94 nfet_01v8
M$6498 1544 1009 167 167 nfet_01v8 L=150000U W=210000U AS=40400000000P
+ AD=21875000000P PS=560000U PD=460000U
* device instance $6499 r0 *1 43.44,11.34 nfet_01v8
M$6499 62 137 2939 167 nfet_01v8 L=150000U W=140000U AS=21875000000P
+ AD=16800000000P PS=460000U PD=380000U
* device instance $6500 r0 *1 43.96,11.34 nfet_01v8
M$6500 63 137 1544 167 nfet_01v8 L=150000U W=140000U AS=21875000000P
+ AD=16800000000P PS=460000U PD=380000U
* device instance $6501 r0 *1 54.34,5.41 nfet_01v8
M$6501 3338 134 78 167 nfet_01v8 L=150000U W=140000U AS=16800000000P
+ AD=21875000000P PS=380000U PD=460000U
* device instance $6502 r0 *1 54.86,5.41 nfet_01v8
M$6502 1081 134 79 167 nfet_01v8 L=150000U W=140000U AS=16800000000P
+ AD=21875000000P PS=380000U PD=460000U
* device instance $6503 r0 *1 54.305,5.81 nfet_01v8
M$6503 167 3097 3338 167 nfet_01v8 L=150000U W=210000U AS=21875000000P
+ AD=40400000000P PS=460000U PD=560000U
* device instance $6504 r0 *1 54.895,5.81 nfet_01v8
M$6504 167 1626 1081 167 nfet_01v8 L=150000U W=210000U AS=21875000000P
+ AD=40400000000P PS=460000U PD=560000U
* device instance $6505 r0 *1 54.305,6.2 nfet_01v8
M$6505 3097 3338 167 167 nfet_01v8 L=150000U W=210000U AS=40400000000P
+ AD=21875000000P PS=560000U PD=460000U
* device instance $6506 r0 *1 54.895,6.2 nfet_01v8
M$6506 1626 1081 167 167 nfet_01v8 L=150000U W=210000U AS=40400000000P
+ AD=21875000000P PS=560000U PD=460000U
* device instance $6507 r0 *1 54.34,6.6 nfet_01v8
M$6507 77 134 3097 167 nfet_01v8 L=150000U W=140000U AS=21875000000P
+ AD=16800000000P PS=460000U PD=380000U
* device instance $6508 r0 *1 54.86,6.6 nfet_01v8
M$6508 80 134 1626 167 nfet_01v8 L=150000U W=140000U AS=21875000000P
+ AD=16800000000P PS=460000U PD=380000U
* device instance $6509 r0 *1 54.34,6.99 nfet_01v8
M$6509 3339 135 77 167 nfet_01v8 L=150000U W=140000U AS=16800000000P
+ AD=21875000000P PS=380000U PD=460000U
* device instance $6510 r0 *1 54.86,6.99 nfet_01v8
M$6510 4329 135 80 167 nfet_01v8 L=150000U W=140000U AS=16800000000P
+ AD=21875000000P PS=380000U PD=460000U
* device instance $6511 r0 *1 54.305,7.39 nfet_01v8
M$6511 167 2012 3339 167 nfet_01v8 L=150000U W=210000U AS=21875000000P
+ AD=40400000000P PS=460000U PD=560000U
* device instance $6512 r0 *1 54.895,7.39 nfet_01v8
M$6512 167 1627 4329 167 nfet_01v8 L=150000U W=210000U AS=21875000000P
+ AD=40400000000P PS=460000U PD=560000U
* device instance $6513 r0 *1 54.305,7.78 nfet_01v8
M$6513 2012 3339 167 167 nfet_01v8 L=150000U W=210000U AS=40400000000P
+ AD=21875000000P PS=560000U PD=460000U
* device instance $6514 r0 *1 54.895,7.78 nfet_01v8
M$6514 1627 4329 167 167 nfet_01v8 L=150000U W=210000U AS=40400000000P
+ AD=21875000000P PS=560000U PD=460000U
* device instance $6515 r0 *1 54.34,8.18 nfet_01v8
M$6515 78 135 2012 167 nfet_01v8 L=150000U W=140000U AS=21875000000P
+ AD=16800000000P PS=460000U PD=380000U
* device instance $6516 r0 *1 54.86,8.18 nfet_01v8
M$6516 79 135 1627 167 nfet_01v8 L=150000U W=140000U AS=21875000000P
+ AD=16800000000P PS=460000U PD=380000U
* device instance $6517 r0 *1 54.34,8.57 nfet_01v8
M$6517 2100 136 78 167 nfet_01v8 L=150000U W=140000U AS=16800000000P
+ AD=21875000000P PS=380000U PD=460000U
* device instance $6518 r0 *1 54.86,8.57 nfet_01v8
M$6518 610 136 79 167 nfet_01v8 L=150000U W=140000U AS=16800000000P
+ AD=21875000000P PS=380000U PD=460000U
* device instance $6519 r0 *1 54.305,8.97 nfet_01v8
M$6519 167 2198 2100 167 nfet_01v8 L=150000U W=210000U AS=21875000000P
+ AD=40400000000P PS=460000U PD=560000U
* device instance $6520 r0 *1 54.895,8.97 nfet_01v8
M$6520 167 738 610 167 nfet_01v8 L=150000U W=210000U AS=21875000000P
+ AD=40400000000P PS=460000U PD=560000U
* device instance $6521 r0 *1 54.305,9.36 nfet_01v8
M$6521 2198 2100 167 167 nfet_01v8 L=150000U W=210000U AS=40400000000P
+ AD=21875000000P PS=560000U PD=460000U
* device instance $6522 r0 *1 54.895,9.36 nfet_01v8
M$6522 738 610 167 167 nfet_01v8 L=150000U W=210000U AS=40400000000P
+ AD=21875000000P PS=560000U PD=460000U
* device instance $6523 r0 *1 54.34,9.76 nfet_01v8
M$6523 77 136 2198 167 nfet_01v8 L=150000U W=140000U AS=21875000000P
+ AD=16800000000P PS=460000U PD=380000U
* device instance $6524 r0 *1 54.86,9.76 nfet_01v8
M$6524 80 136 738 167 nfet_01v8 L=150000U W=140000U AS=21875000000P
+ AD=16800000000P PS=460000U PD=380000U
* device instance $6525 r0 *1 54.34,10.15 nfet_01v8
M$6525 3462 137 77 167 nfet_01v8 L=150000U W=140000U AS=16800000000P
+ AD=21875000000P PS=380000U PD=460000U
* device instance $6526 r0 *1 54.86,10.15 nfet_01v8
M$6526 1174 137 80 167 nfet_01v8 L=150000U W=140000U AS=16800000000P
+ AD=21875000000P PS=380000U PD=460000U
* device instance $6527 r0 *1 54.305,10.55 nfet_01v8
M$6527 167 2712 3462 167 nfet_01v8 L=150000U W=210000U AS=21875000000P
+ AD=40400000000P PS=460000U PD=560000U
* device instance $6528 r0 *1 54.895,10.55 nfet_01v8
M$6528 167 1737 1174 167 nfet_01v8 L=150000U W=210000U AS=21875000000P
+ AD=40400000000P PS=460000U PD=560000U
* device instance $6529 r0 *1 54.305,10.94 nfet_01v8
M$6529 2712 3462 167 167 nfet_01v8 L=150000U W=210000U AS=40400000000P
+ AD=21875000000P PS=560000U PD=460000U
* device instance $6530 r0 *1 54.895,10.94 nfet_01v8
M$6530 1737 1174 167 167 nfet_01v8 L=150000U W=210000U AS=40400000000P
+ AD=21875000000P PS=560000U PD=460000U
* device instance $6531 r0 *1 54.34,11.34 nfet_01v8
M$6531 78 137 2712 167 nfet_01v8 L=150000U W=140000U AS=21875000000P
+ AD=16800000000P PS=460000U PD=380000U
* device instance $6532 r0 *1 54.86,11.34 nfet_01v8
M$6532 79 137 1737 167 nfet_01v8 L=150000U W=140000U AS=21875000000P
+ AD=16800000000P PS=460000U PD=380000U
* device instance $6533 r0 *1 65.24,5.41 nfet_01v8
M$6533 2527 134 94 167 nfet_01v8 L=150000U W=140000U AS=16800000000P
+ AD=21875000000P PS=380000U PD=460000U
* device instance $6534 r0 *1 65.76,5.41 nfet_01v8
M$6534 1092 134 95 167 nfet_01v8 L=150000U W=140000U AS=16800000000P
+ AD=21875000000P PS=380000U PD=460000U
* device instance $6535 r0 *1 65.205,5.81 nfet_01v8
M$6535 167 3090 2527 167 nfet_01v8 L=150000U W=210000U AS=21875000000P
+ AD=40400000000P PS=460000U PD=560000U
* device instance $6536 r0 *1 65.795,5.81 nfet_01v8
M$6536 167 1639 1092 167 nfet_01v8 L=150000U W=210000U AS=21875000000P
+ AD=40400000000P PS=460000U PD=560000U
* device instance $6537 r0 *1 65.205,6.2 nfet_01v8
M$6537 3090 2527 167 167 nfet_01v8 L=150000U W=210000U AS=40400000000P
+ AD=21875000000P PS=560000U PD=460000U
* device instance $6538 r0 *1 65.795,6.2 nfet_01v8
M$6538 1639 1092 167 167 nfet_01v8 L=150000U W=210000U AS=40400000000P
+ AD=21875000000P PS=560000U PD=460000U
* device instance $6539 r0 *1 65.24,6.6 nfet_01v8
M$6539 93 134 3090 167 nfet_01v8 L=150000U W=140000U AS=21875000000P
+ AD=16800000000P PS=460000U PD=380000U
* device instance $6540 r0 *1 65.76,6.6 nfet_01v8
M$6540 96 134 1639 167 nfet_01v8 L=150000U W=140000U AS=21875000000P
+ AD=16800000000P PS=460000U PD=380000U
* device instance $6541 r0 *1 65.24,6.99 nfet_01v8
M$6541 3352 135 93 167 nfet_01v8 L=150000U W=140000U AS=16800000000P
+ AD=21875000000P PS=380000U PD=460000U
* device instance $6542 r0 *1 65.76,6.99 nfet_01v8
M$6542 4316 135 96 167 nfet_01v8 L=150000U W=140000U AS=16800000000P
+ AD=21875000000P PS=380000U PD=460000U
* device instance $6543 r0 *1 65.205,7.39 nfet_01v8
M$6543 167 1981 3352 167 nfet_01v8 L=150000U W=210000U AS=21875000000P
+ AD=40400000000P PS=460000U PD=560000U
* device instance $6544 r0 *1 65.795,7.39 nfet_01v8
M$6544 167 696 4316 167 nfet_01v8 L=150000U W=210000U AS=21875000000P
+ AD=40400000000P PS=460000U PD=560000U
* device instance $6545 r0 *1 65.205,7.78 nfet_01v8
M$6545 1981 3352 167 167 nfet_01v8 L=150000U W=210000U AS=40400000000P
+ AD=21875000000P PS=560000U PD=460000U
* device instance $6546 r0 *1 65.795,7.78 nfet_01v8
M$6546 696 4316 167 167 nfet_01v8 L=150000U W=210000U AS=40400000000P
+ AD=21875000000P PS=560000U PD=460000U
* device instance $6547 r0 *1 65.24,8.18 nfet_01v8
M$6547 94 135 1981 167 nfet_01v8 L=150000U W=140000U AS=21875000000P
+ AD=16800000000P PS=460000U PD=380000U
* device instance $6548 r0 *1 65.76,8.18 nfet_01v8
M$6548 95 135 696 167 nfet_01v8 L=150000U W=140000U AS=21875000000P
+ AD=16800000000P PS=460000U PD=380000U
* device instance $6549 r0 *1 65.24,8.57 nfet_01v8
M$6549 2510 136 94 167 nfet_01v8 L=150000U W=140000U AS=16800000000P
+ AD=21875000000P PS=380000U PD=460000U
* device instance $6550 r0 *1 65.76,8.57 nfet_01v8
M$6550 590 136 95 167 nfet_01v8 L=150000U W=140000U AS=16800000000P
+ AD=21875000000P PS=380000U PD=460000U
* device instance $6551 r0 *1 65.205,8.97 nfet_01v8
M$6551 167 3050 2510 167 nfet_01v8 L=150000U W=210000U AS=21875000000P
+ AD=40400000000P PS=460000U PD=560000U
* device instance $6552 r0 *1 65.795,8.97 nfet_01v8
M$6552 167 701 590 167 nfet_01v8 L=150000U W=210000U AS=21875000000P
+ AD=40400000000P PS=460000U PD=560000U
* device instance $6553 r0 *1 65.205,9.36 nfet_01v8
M$6553 3050 2510 167 167 nfet_01v8 L=150000U W=210000U AS=40400000000P
+ AD=21875000000P PS=560000U PD=460000U
* device instance $6554 r0 *1 65.795,9.36 nfet_01v8
M$6554 701 590 167 167 nfet_01v8 L=150000U W=210000U AS=40400000000P
+ AD=21875000000P PS=560000U PD=460000U
* device instance $6555 r0 *1 65.24,9.76 nfet_01v8
M$6555 93 136 3050 167 nfet_01v8 L=150000U W=140000U AS=21875000000P
+ AD=16800000000P PS=460000U PD=380000U
* device instance $6556 r0 *1 65.76,9.76 nfet_01v8
M$6556 96 136 701 167 nfet_01v8 L=150000U W=140000U AS=21875000000P
+ AD=16800000000P PS=460000U PD=380000U
* device instance $6557 r0 *1 65.24,10.15 nfet_01v8
M$6557 2342 137 93 167 nfet_01v8 L=150000U W=140000U AS=16800000000P
+ AD=21875000000P PS=380000U PD=460000U
* device instance $6558 r0 *1 65.76,10.15 nfet_01v8
M$6558 1175 137 96 167 nfet_01v8 L=150000U W=140000U AS=16800000000P
+ AD=21875000000P PS=380000U PD=460000U
* device instance $6559 r0 *1 65.205,10.55 nfet_01v8
M$6559 167 2710 2342 167 nfet_01v8 L=150000U W=210000U AS=21875000000P
+ AD=40400000000P PS=460000U PD=560000U
* device instance $6560 r0 *1 65.795,10.55 nfet_01v8
M$6560 167 1738 1175 167 nfet_01v8 L=150000U W=210000U AS=21875000000P
+ AD=40400000000P PS=460000U PD=560000U
* device instance $6561 r0 *1 65.205,10.94 nfet_01v8
M$6561 2710 2342 167 167 nfet_01v8 L=150000U W=210000U AS=40400000000P
+ AD=21875000000P PS=560000U PD=460000U
* device instance $6562 r0 *1 65.795,10.94 nfet_01v8
M$6562 1738 1175 167 167 nfet_01v8 L=150000U W=210000U AS=40400000000P
+ AD=21875000000P PS=560000U PD=460000U
* device instance $6563 r0 *1 65.24,11.34 nfet_01v8
M$6563 94 137 2710 167 nfet_01v8 L=150000U W=140000U AS=21875000000P
+ AD=16800000000P PS=460000U PD=380000U
* device instance $6564 r0 *1 65.76,11.34 nfet_01v8
M$6564 95 137 1738 167 nfet_01v8 L=150000U W=140000U AS=21875000000P
+ AD=16800000000P PS=460000U PD=380000U
* device instance $6565 r0 *1 76.14,5.41 nfet_01v8
M$6565 2501 134 110 167 nfet_01v8 L=150000U W=140000U AS=16800000000P
+ AD=21875000000P PS=380000U PD=460000U
* device instance $6566 r0 *1 76.66,5.41 nfet_01v8
M$6566 1099 134 111 167 nfet_01v8 L=150000U W=140000U AS=16800000000P
+ AD=21875000000P PS=380000U PD=460000U
* device instance $6567 r0 *1 76.105,5.81 nfet_01v8
M$6567 167 3032 2501 167 nfet_01v8 L=150000U W=210000U AS=21875000000P
+ AD=40400000000P PS=460000U PD=560000U
* device instance $6568 r0 *1 76.695,5.81 nfet_01v8
M$6568 167 1648 1099 167 nfet_01v8 L=150000U W=210000U AS=21875000000P
+ AD=40400000000P PS=460000U PD=560000U
* device instance $6569 r0 *1 76.105,6.2 nfet_01v8
M$6569 3032 2501 167 167 nfet_01v8 L=150000U W=210000U AS=40400000000P
+ AD=21875000000P PS=560000U PD=460000U
* device instance $6570 r0 *1 76.695,6.2 nfet_01v8
M$6570 1648 1099 167 167 nfet_01v8 L=150000U W=210000U AS=40400000000P
+ AD=21875000000P PS=560000U PD=460000U
* device instance $6571 r0 *1 76.14,6.6 nfet_01v8
M$6571 109 134 3032 167 nfet_01v8 L=150000U W=140000U AS=21875000000P
+ AD=16800000000P PS=460000U PD=380000U
* device instance $6572 r0 *1 76.66,6.6 nfet_01v8
M$6572 112 134 1648 167 nfet_01v8 L=150000U W=140000U AS=21875000000P
+ AD=16800000000P PS=460000U PD=380000U
* device instance $6573 r0 *1 76.14,6.99 nfet_01v8
M$6573 3389 135 109 167 nfet_01v8 L=150000U W=140000U AS=16800000000P
+ AD=21875000000P PS=380000U PD=460000U
* device instance $6574 r0 *1 76.66,6.99 nfet_01v8
M$6574 4331 135 112 167 nfet_01v8 L=150000U W=140000U AS=16800000000P
+ AD=21875000000P PS=380000U PD=460000U
* device instance $6575 r0 *1 76.105,7.39 nfet_01v8
M$6575 167 2046 3389 167 nfet_01v8 L=150000U W=210000U AS=21875000000P
+ AD=40400000000P PS=460000U PD=560000U
* device instance $6576 r0 *1 76.695,7.39 nfet_01v8
M$6576 167 1649 4331 167 nfet_01v8 L=150000U W=210000U AS=21875000000P
+ AD=40400000000P PS=460000U PD=560000U
* device instance $6577 r0 *1 76.105,7.78 nfet_01v8
M$6577 2046 3389 167 167 nfet_01v8 L=150000U W=210000U AS=40400000000P
+ AD=21875000000P PS=560000U PD=460000U
* device instance $6578 r0 *1 76.695,7.78 nfet_01v8
M$6578 1649 4331 167 167 nfet_01v8 L=150000U W=210000U AS=40400000000P
+ AD=21875000000P PS=560000U PD=460000U
* device instance $6579 r0 *1 76.14,8.18 nfet_01v8
M$6579 110 135 2046 167 nfet_01v8 L=150000U W=140000U AS=21875000000P
+ AD=16800000000P PS=460000U PD=380000U
* device instance $6580 r0 *1 76.66,8.18 nfet_01v8
M$6580 111 135 1649 167 nfet_01v8 L=150000U W=140000U AS=21875000000P
+ AD=16800000000P PS=460000U PD=380000U
* device instance $6581 r0 *1 76.14,8.57 nfet_01v8
M$6581 2489 136 110 167 nfet_01v8 L=150000U W=140000U AS=16800000000P
+ AD=21875000000P PS=380000U PD=460000U
* device instance $6582 r0 *1 76.66,8.57 nfet_01v8
M$6582 580 136 111 167 nfet_01v8 L=150000U W=140000U AS=16800000000P
+ AD=21875000000P PS=380000U PD=460000U
* device instance $6583 r0 *1 76.105,8.97 nfet_01v8
M$6583 167 2998 2489 167 nfet_01v8 L=150000U W=210000U AS=21875000000P
+ AD=40400000000P PS=460000U PD=560000U
* device instance $6584 r0 *1 76.695,8.97 nfet_01v8
M$6584 167 673 580 167 nfet_01v8 L=150000U W=210000U AS=21875000000P
+ AD=40400000000P PS=460000U PD=560000U
* device instance $6585 r0 *1 76.105,9.36 nfet_01v8
M$6585 2998 2489 167 167 nfet_01v8 L=150000U W=210000U AS=40400000000P
+ AD=21875000000P PS=560000U PD=460000U
* device instance $6586 r0 *1 76.695,9.36 nfet_01v8
M$6586 673 580 167 167 nfet_01v8 L=150000U W=210000U AS=40400000000P
+ AD=21875000000P PS=560000U PD=460000U
* device instance $6587 r0 *1 76.14,9.76 nfet_01v8
M$6587 109 136 2998 167 nfet_01v8 L=150000U W=140000U AS=21875000000P
+ AD=16800000000P PS=460000U PD=380000U
* device instance $6588 r0 *1 76.66,9.76 nfet_01v8
M$6588 112 136 673 167 nfet_01v8 L=150000U W=140000U AS=21875000000P
+ AD=16800000000P PS=460000U PD=380000U
* device instance $6589 r0 *1 76.14,10.15 nfet_01v8
M$6589 2537 137 109 167 nfet_01v8 L=150000U W=140000U AS=16800000000P
+ AD=21875000000P PS=380000U PD=460000U
* device instance $6590 r0 *1 76.66,10.15 nfet_01v8
M$6590 1066 137 112 167 nfet_01v8 L=150000U W=140000U AS=16800000000P
+ AD=21875000000P PS=380000U PD=460000U
* device instance $6591 r0 *1 76.105,10.55 nfet_01v8
M$6591 167 3110 2537 167 nfet_01v8 L=150000U W=210000U AS=21875000000P
+ AD=40400000000P PS=460000U PD=560000U
* device instance $6592 r0 *1 76.695,10.55 nfet_01v8
M$6592 167 1610 1066 167 nfet_01v8 L=150000U W=210000U AS=21875000000P
+ AD=40400000000P PS=460000U PD=560000U
* device instance $6593 r0 *1 76.105,10.94 nfet_01v8
M$6593 3110 2537 167 167 nfet_01v8 L=150000U W=210000U AS=40400000000P
+ AD=21875000000P PS=560000U PD=460000U
* device instance $6594 r0 *1 76.695,10.94 nfet_01v8
M$6594 1610 1066 167 167 nfet_01v8 L=150000U W=210000U AS=40400000000P
+ AD=21875000000P PS=560000U PD=460000U
* device instance $6595 r0 *1 76.14,11.34 nfet_01v8
M$6595 110 137 3110 167 nfet_01v8 L=150000U W=140000U AS=21875000000P
+ AD=16800000000P PS=460000U PD=380000U
* device instance $6596 r0 *1 76.66,11.34 nfet_01v8
M$6596 111 137 1610 167 nfet_01v8 L=150000U W=140000U AS=21875000000P
+ AD=16800000000P PS=460000U PD=380000U
* device instance $6597 r0 *1 87.04,5.41 nfet_01v8
M$6597 2492 134 126 167 nfet_01v8 L=150000U W=140000U AS=16800000000P
+ AD=21875000000P PS=380000U PD=460000U
* device instance $6598 r0 *1 87.56,5.41 nfet_01v8
M$6598 1107 134 127 167 nfet_01v8 L=150000U W=140000U AS=16800000000P
+ AD=21875000000P PS=380000U PD=460000U
* device instance $6599 r0 *1 87.005,5.81 nfet_01v8
M$6599 167 3003 2492 167 nfet_01v8 L=150000U W=210000U AS=21875000000P
+ AD=40400000000P PS=460000U PD=560000U
* device instance $6600 r0 *1 87.595,5.81 nfet_01v8
M$6600 167 1659 1107 167 nfet_01v8 L=150000U W=210000U AS=21875000000P
+ AD=40400000000P PS=460000U PD=560000U
* device instance $6601 r0 *1 87.005,6.2 nfet_01v8
M$6601 3003 2492 167 167 nfet_01v8 L=150000U W=210000U AS=40400000000P
+ AD=21875000000P PS=560000U PD=460000U
* device instance $6602 r0 *1 87.595,6.2 nfet_01v8
M$6602 1659 1107 167 167 nfet_01v8 L=150000U W=210000U AS=40400000000P
+ AD=21875000000P PS=560000U PD=460000U
* device instance $6603 r0 *1 87.04,6.6 nfet_01v8
M$6603 125 134 3003 167 nfet_01v8 L=150000U W=140000U AS=21875000000P
+ AD=16800000000P PS=460000U PD=380000U
* device instance $6604 r0 *1 87.56,6.6 nfet_01v8
M$6604 128 134 1659 167 nfet_01v8 L=150000U W=140000U AS=21875000000P
+ AD=16800000000P PS=460000U PD=380000U
* device instance $6605 r0 *1 87.04,6.99 nfet_01v8
M$6605 3383 135 125 167 nfet_01v8 L=150000U W=140000U AS=16800000000P
+ AD=21875000000P PS=380000U PD=460000U
* device instance $6606 r0 *1 87.56,6.99 nfet_01v8
M$6606 4340 135 128 167 nfet_01v8 L=150000U W=140000U AS=16800000000P
+ AD=21875000000P PS=380000U PD=460000U
* device instance $6607 r0 *1 87.005,7.39 nfet_01v8
M$6607 167 2015 3383 167 nfet_01v8 L=150000U W=210000U AS=21875000000P
+ AD=40400000000P PS=460000U PD=560000U
* device instance $6608 r0 *1 87.595,7.39 nfet_01v8
M$6608 167 692 4340 167 nfet_01v8 L=150000U W=210000U AS=21875000000P
+ AD=40400000000P PS=460000U PD=560000U
* device instance $6609 r0 *1 87.005,7.78 nfet_01v8
M$6609 2015 3383 167 167 nfet_01v8 L=150000U W=210000U AS=40400000000P
+ AD=21875000000P PS=560000U PD=460000U
* device instance $6610 r0 *1 87.595,7.78 nfet_01v8
M$6610 692 4340 167 167 nfet_01v8 L=150000U W=210000U AS=40400000000P
+ AD=21875000000P PS=560000U PD=460000U
* device instance $6611 r0 *1 87.04,8.18 nfet_01v8
M$6611 126 135 2015 167 nfet_01v8 L=150000U W=140000U AS=21875000000P
+ AD=16800000000P PS=460000U PD=380000U
* device instance $6612 r0 *1 87.56,8.18 nfet_01v8
M$6612 127 135 692 167 nfet_01v8 L=150000U W=140000U AS=21875000000P
+ AD=16800000000P PS=460000U PD=380000U
* device instance $6613 r0 *1 87.04,8.57 nfet_01v8
M$6613 2486 136 126 167 nfet_01v8 L=150000U W=140000U AS=16800000000P
+ AD=21875000000P PS=380000U PD=460000U
* device instance $6614 r0 *1 87.56,8.57 nfet_01v8
M$6614 587 136 127 167 nfet_01v8 L=150000U W=140000U AS=16800000000P
+ AD=21875000000P PS=380000U PD=460000U
* device instance $6615 r0 *1 87.005,8.97 nfet_01v8
M$6615 167 2992 2486 167 nfet_01v8 L=150000U W=210000U AS=21875000000P
+ AD=40400000000P PS=460000U PD=560000U
* device instance $6616 r0 *1 87.595,8.97 nfet_01v8
M$6616 167 691 587 167 nfet_01v8 L=150000U W=210000U AS=21875000000P
+ AD=40400000000P PS=460000U PD=560000U
* device instance $6617 r0 *1 87.005,9.36 nfet_01v8
M$6617 2992 2486 167 167 nfet_01v8 L=150000U W=210000U AS=40400000000P
+ AD=21875000000P PS=560000U PD=460000U
* device instance $6618 r0 *1 87.595,9.36 nfet_01v8
M$6618 691 587 167 167 nfet_01v8 L=150000U W=210000U AS=40400000000P
+ AD=21875000000P PS=560000U PD=460000U
* device instance $6619 r0 *1 87.04,9.76 nfet_01v8
M$6619 125 136 2992 167 nfet_01v8 L=150000U W=140000U AS=21875000000P
+ AD=16800000000P PS=460000U PD=380000U
* device instance $6620 r0 *1 87.56,9.76 nfet_01v8
M$6620 128 136 691 167 nfet_01v8 L=150000U W=140000U AS=21875000000P
+ AD=16800000000P PS=460000U PD=380000U
* device instance $6621 r0 *1 87.04,10.15 nfet_01v8
M$6621 3390 137 125 167 nfet_01v8 L=150000U W=140000U AS=16800000000P
+ AD=21875000000P PS=380000U PD=460000U
* device instance $6622 r0 *1 87.56,10.15 nfet_01v8
M$6622 1060 137 128 167 nfet_01v8 L=150000U W=140000U AS=16800000000P
+ AD=21875000000P PS=380000U PD=460000U
* device instance $6623 r0 *1 87.005,10.55 nfet_01v8
M$6623 167 3064 3390 167 nfet_01v8 L=150000U W=210000U AS=21875000000P
+ AD=40400000000P PS=460000U PD=560000U
* device instance $6624 r0 *1 87.595,10.55 nfet_01v8
M$6624 167 1604 1060 167 nfet_01v8 L=150000U W=210000U AS=21875000000P
+ AD=40400000000P PS=460000U PD=560000U
* device instance $6625 r0 *1 87.005,10.94 nfet_01v8
M$6625 3064 3390 167 167 nfet_01v8 L=150000U W=210000U AS=40400000000P
+ AD=21875000000P PS=560000U PD=460000U
* device instance $6626 r0 *1 87.595,10.94 nfet_01v8
M$6626 1604 1060 167 167 nfet_01v8 L=150000U W=210000U AS=40400000000P
+ AD=21875000000P PS=560000U PD=460000U
* device instance $6627 r0 *1 87.04,11.34 nfet_01v8
M$6627 126 137 3064 167 nfet_01v8 L=150000U W=140000U AS=21875000000P
+ AD=16800000000P PS=460000U PD=380000U
* device instance $6628 r0 *1 87.56,11.34 nfet_01v8
M$6628 127 137 1604 167 nfet_01v8 L=150000U W=140000U AS=21875000000P
+ AD=16800000000P PS=460000U PD=380000U
* device instance $6629 r0 *1 87.04,13.31 nfet_01v8
M$6629 3398 138 126 167 nfet_01v8 L=150000U W=140000U AS=16800000000P
+ AD=21875000000P PS=380000U PD=460000U
* device instance $6630 r0 *1 87.56,13.31 nfet_01v8
M$6630 1113 138 127 167 nfet_01v8 L=150000U W=140000U AS=16800000000P
+ AD=21875000000P PS=380000U PD=460000U
* device instance $6631 r0 *1 87.005,13.71 nfet_01v8
M$6631 167 2934 3398 167 nfet_01v8 L=150000U W=210000U AS=21875000000P
+ AD=40400000000P PS=460000U PD=560000U
* device instance $6632 r0 *1 87.595,13.71 nfet_01v8
M$6632 167 1666 1113 167 nfet_01v8 L=150000U W=210000U AS=21875000000P
+ AD=40400000000P PS=460000U PD=560000U
* device instance $6633 r0 *1 87.005,14.1 nfet_01v8
M$6633 2934 3398 167 167 nfet_01v8 L=150000U W=210000U AS=40400000000P
+ AD=21875000000P PS=560000U PD=460000U
* device instance $6634 r0 *1 87.595,14.1 nfet_01v8
M$6634 1666 1113 167 167 nfet_01v8 L=150000U W=210000U AS=40400000000P
+ AD=21875000000P PS=560000U PD=460000U
* device instance $6635 r0 *1 87.04,14.5 nfet_01v8
M$6635 125 138 2934 167 nfet_01v8 L=150000U W=140000U AS=21875000000P
+ AD=16800000000P PS=460000U PD=380000U
* device instance $6636 r0 *1 87.56,14.5 nfet_01v8
M$6636 128 138 1666 167 nfet_01v8 L=150000U W=140000U AS=21875000000P
+ AD=16800000000P PS=460000U PD=380000U
* device instance $6637 r0 *1 87.04,14.89 nfet_01v8
M$6637 3393 139 125 167 nfet_01v8 L=150000U W=140000U AS=16800000000P
+ AD=21875000000P PS=380000U PD=460000U
* device instance $6638 r0 *1 87.56,14.89 nfet_01v8
M$6638 4319 139 128 167 nfet_01v8 L=150000U W=140000U AS=16800000000P
+ AD=21875000000P PS=380000U PD=460000U
* device instance $6639 r0 *1 87.005,15.29 nfet_01v8
M$6639 167 1991 3393 167 nfet_01v8 L=150000U W=210000U AS=21875000000P
+ AD=40400000000P PS=460000U PD=560000U
* device instance $6640 r0 *1 87.595,15.29 nfet_01v8
M$6640 167 1615 4319 167 nfet_01v8 L=150000U W=210000U AS=21875000000P
+ AD=40400000000P PS=460000U PD=560000U
* device instance $6641 r0 *1 87.005,15.68 nfet_01v8
M$6641 1991 3393 167 167 nfet_01v8 L=150000U W=210000U AS=40400000000P
+ AD=21875000000P PS=560000U PD=460000U
* device instance $6642 r0 *1 87.595,15.68 nfet_01v8
M$6642 1615 4319 167 167 nfet_01v8 L=150000U W=210000U AS=40400000000P
+ AD=21875000000P PS=560000U PD=460000U
* device instance $6643 r0 *1 87.04,16.08 nfet_01v8
M$6643 126 139 1991 167 nfet_01v8 L=150000U W=140000U AS=21875000000P
+ AD=16800000000P PS=460000U PD=380000U
* device instance $6644 r0 *1 87.56,16.08 nfet_01v8
M$6644 127 139 1615 167 nfet_01v8 L=150000U W=140000U AS=21875000000P
+ AD=16800000000P PS=460000U PD=380000U
* device instance $6645 r0 *1 87.04,16.47 nfet_01v8
M$6645 2119 140 126 167 nfet_01v8 L=150000U W=140000U AS=16800000000P
+ AD=21875000000P PS=380000U PD=460000U
* device instance $6646 r0 *1 87.56,16.47 nfet_01v8
M$6646 1073 140 127 167 nfet_01v8 L=150000U W=140000U AS=16800000000P
+ AD=21875000000P PS=380000U PD=460000U
* device instance $6647 r0 *1 87.005,16.87 nfet_01v8
M$6647 167 2246 2119 167 nfet_01v8 L=150000U W=210000U AS=21875000000P
+ AD=40400000000P PS=460000U PD=560000U
* device instance $6648 r0 *1 87.595,16.87 nfet_01v8
M$6648 167 1618 1073 167 nfet_01v8 L=150000U W=210000U AS=21875000000P
+ AD=40400000000P PS=460000U PD=560000U
* device instance $6649 r0 *1 87.005,17.26 nfet_01v8
M$6649 2246 2119 167 167 nfet_01v8 L=150000U W=210000U AS=40400000000P
+ AD=21875000000P PS=560000U PD=460000U
* device instance $6650 r0 *1 87.595,17.26 nfet_01v8
M$6650 1618 1073 167 167 nfet_01v8 L=150000U W=210000U AS=40400000000P
+ AD=21875000000P PS=560000U PD=460000U
* device instance $6651 r0 *1 87.04,17.66 nfet_01v8
M$6651 125 140 2246 167 nfet_01v8 L=150000U W=140000U AS=21875000000P
+ AD=16800000000P PS=460000U PD=380000U
* device instance $6652 r0 *1 87.56,17.66 nfet_01v8
M$6652 128 140 1618 167 nfet_01v8 L=150000U W=140000U AS=21875000000P
+ AD=16800000000P PS=460000U PD=380000U
* device instance $6653 r0 *1 87.04,18.05 nfet_01v8
M$6653 3395 141 125 167 nfet_01v8 L=150000U W=140000U AS=16800000000P
+ AD=21875000000P PS=380000U PD=460000U
* device instance $6654 r0 *1 87.56,18.05 nfet_01v8
M$6654 1070 141 128 167 nfet_01v8 L=150000U W=140000U AS=16800000000P
+ AD=21875000000P PS=380000U PD=460000U
* device instance $6655 r0 *1 87.005,18.45 nfet_01v8
M$6655 167 2929 3395 167 nfet_01v8 L=150000U W=210000U AS=21875000000P
+ AD=40400000000P PS=460000U PD=560000U
* device instance $6656 r0 *1 87.595,18.45 nfet_01v8
M$6656 167 1614 1070 167 nfet_01v8 L=150000U W=210000U AS=21875000000P
+ AD=40400000000P PS=460000U PD=560000U
* device instance $6657 r0 *1 87.005,18.84 nfet_01v8
M$6657 2929 3395 167 167 nfet_01v8 L=150000U W=210000U AS=40400000000P
+ AD=21875000000P PS=560000U PD=460000U
* device instance $6658 r0 *1 87.595,18.84 nfet_01v8
M$6658 1614 1070 167 167 nfet_01v8 L=150000U W=210000U AS=40400000000P
+ AD=21875000000P PS=560000U PD=460000U
* device instance $6659 r0 *1 87.04,19.24 nfet_01v8
M$6659 126 141 2929 167 nfet_01v8 L=150000U W=140000U AS=21875000000P
+ AD=16800000000P PS=460000U PD=380000U
* device instance $6660 r0 *1 87.56,19.24 nfet_01v8
M$6660 127 141 1614 167 nfet_01v8 L=150000U W=140000U AS=21875000000P
+ AD=16800000000P PS=460000U PD=380000U
* device instance $6661 r0 *1 21.64,29.11 nfet_01v8
M$6661 2401 146 30 167 nfet_01v8 L=150000U W=140000U AS=16800000000P
+ AD=21875000000P PS=380000U PD=460000U
* device instance $6662 r0 *1 22.16,29.11 nfet_01v8
M$6662 1370 146 31 167 nfet_01v8 L=150000U W=140000U AS=16800000000P
+ AD=21875000000P PS=380000U PD=460000U
* device instance $6663 r0 *1 21.605,29.51 nfet_01v8
M$6663 167 2816 2401 167 nfet_01v8 L=150000U W=210000U AS=21875000000P
+ AD=40400000000P PS=460000U PD=560000U
* device instance $6664 r0 *1 22.195,29.51 nfet_01v8
M$6664 167 1962 1370 167 nfet_01v8 L=150000U W=210000U AS=21875000000P
+ AD=40400000000P PS=460000U PD=560000U
* device instance $6665 r0 *1 21.605,29.9 nfet_01v8
M$6665 2816 2401 167 167 nfet_01v8 L=150000U W=210000U AS=40400000000P
+ AD=21875000000P PS=560000U PD=460000U
* device instance $6666 r0 *1 22.195,29.9 nfet_01v8
M$6666 1962 1370 167 167 nfet_01v8 L=150000U W=210000U AS=40400000000P
+ AD=21875000000P PS=560000U PD=460000U
* device instance $6667 r0 *1 21.64,30.3 nfet_01v8
M$6667 29 146 2816 167 nfet_01v8 L=150000U W=140000U AS=21875000000P
+ AD=16800000000P PS=460000U PD=380000U
* device instance $6668 r0 *1 22.16,30.3 nfet_01v8
M$6668 32 146 1962 167 nfet_01v8 L=150000U W=140000U AS=21875000000P
+ AD=16800000000P PS=460000U PD=380000U
* device instance $6669 r0 *1 21.64,30.69 nfet_01v8
M$6669 3259 147 29 167 nfet_01v8 L=150000U W=140000U AS=16800000000P
+ AD=21875000000P PS=380000U PD=460000U
* device instance $6670 r0 *1 22.16,30.69 nfet_01v8
M$6670 4516 147 32 167 nfet_01v8 L=150000U W=140000U AS=16800000000P
+ AD=21875000000P PS=380000U PD=460000U
* device instance $6671 r0 *1 21.605,31.09 nfet_01v8
M$6671 167 1974 3259 167 nfet_01v8 L=150000U W=210000U AS=21875000000P
+ AD=40400000000P PS=460000U PD=560000U
* device instance $6672 r0 *1 22.195,31.09 nfet_01v8
M$6672 167 826 4516 167 nfet_01v8 L=150000U W=210000U AS=21875000000P
+ AD=40400000000P PS=460000U PD=560000U
* device instance $6673 r0 *1 21.605,31.48 nfet_01v8
M$6673 1974 3259 167 167 nfet_01v8 L=150000U W=210000U AS=40400000000P
+ AD=21875000000P PS=560000U PD=460000U
* device instance $6674 r0 *1 22.195,31.48 nfet_01v8
M$6674 826 4516 167 167 nfet_01v8 L=150000U W=210000U AS=40400000000P
+ AD=21875000000P PS=560000U PD=460000U
* device instance $6675 r0 *1 21.64,31.88 nfet_01v8
M$6675 30 147 1974 167 nfet_01v8 L=150000U W=140000U AS=21875000000P
+ AD=16800000000P PS=460000U PD=380000U
* device instance $6676 r0 *1 22.16,31.88 nfet_01v8
M$6676 31 147 826 167 nfet_01v8 L=150000U W=140000U AS=21875000000P
+ AD=16800000000P PS=460000U PD=380000U
* device instance $6677 r0 *1 21.64,32.27 nfet_01v8
M$6677 2111 148 30 167 nfet_01v8 L=150000U W=140000U AS=16800000000P
+ AD=21875000000P PS=380000U PD=460000U
* device instance $6678 r0 *1 22.16,32.27 nfet_01v8
M$6678 1220 148 31 167 nfet_01v8 L=150000U W=140000U AS=16800000000P
+ AD=21875000000P PS=380000U PD=460000U
* device instance $6679 r0 *1 21.605,32.67 nfet_01v8
M$6679 167 2229 2111 167 nfet_01v8 L=150000U W=210000U AS=21875000000P
+ AD=40400000000P PS=460000U PD=560000U
* device instance $6680 r0 *1 22.195,32.67 nfet_01v8
M$6680 167 1791 1220 167 nfet_01v8 L=150000U W=210000U AS=21875000000P
+ AD=40400000000P PS=460000U PD=560000U
* device instance $6681 r0 *1 21.605,33.06 nfet_01v8
M$6681 2229 2111 167 167 nfet_01v8 L=150000U W=210000U AS=40400000000P
+ AD=21875000000P PS=560000U PD=460000U
* device instance $6682 r0 *1 22.195,33.06 nfet_01v8
M$6682 1791 1220 167 167 nfet_01v8 L=150000U W=210000U AS=40400000000P
+ AD=21875000000P PS=560000U PD=460000U
* device instance $6683 r0 *1 21.64,33.46 nfet_01v8
M$6683 29 148 2229 167 nfet_01v8 L=150000U W=140000U AS=21875000000P
+ AD=16800000000P PS=460000U PD=380000U
* device instance $6684 r0 *1 22.16,33.46 nfet_01v8
M$6684 32 148 1791 167 nfet_01v8 L=150000U W=140000U AS=21875000000P
+ AD=16800000000P PS=460000U PD=380000U
* device instance $6685 r0 *1 21.64,33.85 nfet_01v8
M$6685 3285 149 29 167 nfet_01v8 L=150000U W=140000U AS=16800000000P
+ AD=21875000000P PS=380000U PD=460000U
* device instance $6686 r0 *1 22.16,33.85 nfet_01v8
M$6686 1210 149 32 167 nfet_01v8 L=150000U W=140000U AS=16800000000P
+ AD=21875000000P PS=380000U PD=460000U
* device instance $6687 r0 *1 21.605,34.25 nfet_01v8
M$6687 167 2804 3285 167 nfet_01v8 L=150000U W=210000U AS=21875000000P
+ AD=40400000000P PS=460000U PD=560000U
* device instance $6688 r0 *1 22.195,34.25 nfet_01v8
M$6688 167 1780 1210 167 nfet_01v8 L=150000U W=210000U AS=21875000000P
+ AD=40400000000P PS=460000U PD=560000U
* device instance $6689 r0 *1 21.605,34.64 nfet_01v8
M$6689 2804 3285 167 167 nfet_01v8 L=150000U W=210000U AS=40400000000P
+ AD=21875000000P PS=560000U PD=460000U
* device instance $6690 r0 *1 22.195,34.64 nfet_01v8
M$6690 1780 1210 167 167 nfet_01v8 L=150000U W=210000U AS=40400000000P
+ AD=21875000000P PS=560000U PD=460000U
* device instance $6691 r0 *1 21.64,35.04 nfet_01v8
M$6691 30 149 2804 167 nfet_01v8 L=150000U W=140000U AS=21875000000P
+ AD=16800000000P PS=460000U PD=380000U
* device instance $6692 r0 *1 22.16,35.04 nfet_01v8
M$6692 31 149 1780 167 nfet_01v8 L=150000U W=140000U AS=21875000000P
+ AD=16800000000P PS=460000U PD=380000U
* device instance $6693 r0 *1 32.54,29.11 nfet_01v8
M$6693 3658 146 46 167 nfet_01v8 L=150000U W=140000U AS=16800000000P
+ AD=21875000000P PS=380000U PD=460000U
* device instance $6694 r0 *1 33.06,29.11 nfet_01v8
M$6694 1201 146 47 167 nfet_01v8 L=150000U W=140000U AS=16800000000P
+ AD=21875000000P PS=380000U PD=460000U
* device instance $6695 r0 *1 32.505,29.51 nfet_01v8
M$6695 167 2871 3658 167 nfet_01v8 L=150000U W=210000U AS=21875000000P
+ AD=40400000000P PS=460000U PD=560000U
* device instance $6696 r0 *1 33.095,29.51 nfet_01v8
M$6696 167 1770 1201 167 nfet_01v8 L=150000U W=210000U AS=21875000000P
+ AD=40400000000P PS=460000U PD=560000U
* device instance $6697 r0 *1 32.505,29.9 nfet_01v8
M$6697 2871 3658 167 167 nfet_01v8 L=150000U W=210000U AS=40400000000P
+ AD=21875000000P PS=560000U PD=460000U
* device instance $6698 r0 *1 33.095,29.9 nfet_01v8
M$6698 1770 1201 167 167 nfet_01v8 L=150000U W=210000U AS=40400000000P
+ AD=21875000000P PS=560000U PD=460000U
* device instance $6699 r0 *1 32.54,30.3 nfet_01v8
M$6699 45 146 2871 167 nfet_01v8 L=150000U W=140000U AS=21875000000P
+ AD=16800000000P PS=460000U PD=380000U
* device instance $6700 r0 *1 33.06,30.3 nfet_01v8
M$6700 48 146 1770 167 nfet_01v8 L=150000U W=140000U AS=21875000000P
+ AD=16800000000P PS=460000U PD=380000U
* device instance $6701 r0 *1 32.54,30.69 nfet_01v8
M$6701 3661 147 45 167 nfet_01v8 L=150000U W=140000U AS=16800000000P
+ AD=21875000000P PS=380000U PD=460000U
* device instance $6702 r0 *1 33.06,30.69 nfet_01v8
M$6702 4390 147 48 167 nfet_01v8 L=150000U W=140000U AS=16800000000P
+ AD=21875000000P PS=380000U PD=460000U
* device instance $6703 r0 *1 32.505,31.09 nfet_01v8
M$6703 167 1995 3661 167 nfet_01v8 L=150000U W=210000U AS=21875000000P
+ AD=40400000000P PS=460000U PD=560000U
* device instance $6704 r0 *1 33.095,31.09 nfet_01v8
M$6704 167 1771 4390 167 nfet_01v8 L=150000U W=210000U AS=21875000000P
+ AD=40400000000P PS=460000U PD=560000U
* device instance $6705 r0 *1 32.505,31.48 nfet_01v8
M$6705 1995 3661 167 167 nfet_01v8 L=150000U W=210000U AS=40400000000P
+ AD=21875000000P PS=560000U PD=460000U
* device instance $6706 r0 *1 33.095,31.48 nfet_01v8
M$6706 1771 4390 167 167 nfet_01v8 L=150000U W=210000U AS=40400000000P
+ AD=21875000000P PS=560000U PD=460000U
* device instance $6707 r0 *1 32.54,31.88 nfet_01v8
M$6707 46 147 1995 167 nfet_01v8 L=150000U W=140000U AS=21875000000P
+ AD=16800000000P PS=460000U PD=380000U
* device instance $6708 r0 *1 33.06,31.88 nfet_01v8
M$6708 47 147 1771 167 nfet_01v8 L=150000U W=140000U AS=21875000000P
+ AD=16800000000P PS=460000U PD=380000U
* device instance $6709 r0 *1 32.54,32.27 nfet_01v8
M$6709 3654 148 46 167 nfet_01v8 L=150000U W=140000U AS=16800000000P
+ AD=21875000000P PS=380000U PD=460000U
* device instance $6710 r0 *1 33.06,32.27 nfet_01v8
M$6710 604 148 47 167 nfet_01v8 L=150000U W=140000U AS=16800000000P
+ AD=21875000000P PS=380000U PD=460000U
* device instance $6711 r0 *1 32.505,32.67 nfet_01v8
M$6711 167 2196 3654 167 nfet_01v8 L=150000U W=210000U AS=21875000000P
+ AD=40400000000P PS=460000U PD=560000U
* device instance $6712 r0 *1 33.095,32.67 nfet_01v8
M$6712 167 727 604 167 nfet_01v8 L=150000U W=210000U AS=21875000000P
+ AD=40400000000P PS=460000U PD=560000U
* device instance $6713 r0 *1 32.505,33.06 nfet_01v8
M$6713 2196 3654 167 167 nfet_01v8 L=150000U W=210000U AS=40400000000P
+ AD=21875000000P PS=560000U PD=460000U
* device instance $6714 r0 *1 33.095,33.06 nfet_01v8
M$6714 727 604 167 167 nfet_01v8 L=150000U W=210000U AS=40400000000P
+ AD=21875000000P PS=560000U PD=460000U
* device instance $6715 r0 *1 32.54,33.46 nfet_01v8
M$6715 45 148 2196 167 nfet_01v8 L=150000U W=140000U AS=21875000000P
+ AD=16800000000P PS=460000U PD=380000U
* device instance $6716 r0 *1 33.06,33.46 nfet_01v8
M$6716 48 148 727 167 nfet_01v8 L=150000U W=140000U AS=21875000000P
+ AD=16800000000P PS=460000U PD=380000U
* device instance $6717 r0 *1 32.54,33.85 nfet_01v8
M$6717 3653 149 45 167 nfet_01v8 L=150000U W=140000U AS=16800000000P
+ AD=21875000000P PS=380000U PD=460000U
* device instance $6718 r0 *1 33.06,33.85 nfet_01v8
M$6718 1273 149 48 167 nfet_01v8 L=150000U W=140000U AS=16800000000P
+ AD=21875000000P PS=380000U PD=460000U
* device instance $6719 r0 *1 32.505,34.25 nfet_01v8
M$6719 167 2884 3653 167 nfet_01v8 L=150000U W=210000U AS=21875000000P
+ AD=40400000000P PS=460000U PD=560000U
* device instance $6720 r0 *1 33.095,34.25 nfet_01v8
M$6720 167 1850 1273 167 nfet_01v8 L=150000U W=210000U AS=21875000000P
+ AD=40400000000P PS=460000U PD=560000U
* device instance $6721 r0 *1 32.505,34.64 nfet_01v8
M$6721 2884 3653 167 167 nfet_01v8 L=150000U W=210000U AS=40400000000P
+ AD=21875000000P PS=560000U PD=460000U
* device instance $6722 r0 *1 33.095,34.64 nfet_01v8
M$6722 1850 1273 167 167 nfet_01v8 L=150000U W=210000U AS=40400000000P
+ AD=21875000000P PS=560000U PD=460000U
* device instance $6723 r0 *1 32.54,35.04 nfet_01v8
M$6723 46 149 2884 167 nfet_01v8 L=150000U W=140000U AS=21875000000P
+ AD=16800000000P PS=460000U PD=380000U
* device instance $6724 r0 *1 33.06,35.04 nfet_01v8
M$6724 47 149 1850 167 nfet_01v8 L=150000U W=140000U AS=21875000000P
+ AD=16800000000P PS=460000U PD=380000U
* device instance $6725 r0 *1 43.44,29.11 nfet_01v8
M$6725 2350 146 62 167 nfet_01v8 L=150000U W=140000U AS=16800000000P
+ AD=21875000000P PS=380000U PD=460000U
* device instance $6726 r0 *1 43.96,29.11 nfet_01v8
M$6726 1262 146 63 167 nfet_01v8 L=150000U W=140000U AS=16800000000P
+ AD=21875000000P PS=380000U PD=460000U
* device instance $6727 r0 *1 43.405,29.51 nfet_01v8
M$6727 167 2728 2350 167 nfet_01v8 L=150000U W=210000U AS=21875000000P
+ AD=40400000000P PS=460000U PD=560000U
* device instance $6728 r0 *1 43.995,29.51 nfet_01v8
M$6728 167 1839 1262 167 nfet_01v8 L=150000U W=210000U AS=21875000000P
+ AD=40400000000P PS=460000U PD=560000U
* device instance $6729 r0 *1 43.405,29.9 nfet_01v8
M$6729 2728 2350 167 167 nfet_01v8 L=150000U W=210000U AS=40400000000P
+ AD=21875000000P PS=560000U PD=460000U
* device instance $6730 r0 *1 43.995,29.9 nfet_01v8
M$6730 1839 1262 167 167 nfet_01v8 L=150000U W=210000U AS=40400000000P
+ AD=21875000000P PS=560000U PD=460000U
* device instance $6731 r0 *1 43.44,30.3 nfet_01v8
M$6731 61 146 2728 167 nfet_01v8 L=150000U W=140000U AS=21875000000P
+ AD=16800000000P PS=460000U PD=380000U
* device instance $6732 r0 *1 43.96,30.3 nfet_01v8
M$6732 64 146 1839 167 nfet_01v8 L=150000U W=140000U AS=21875000000P
+ AD=16800000000P PS=460000U PD=380000U
* device instance $6733 r0 *1 43.44,30.69 nfet_01v8
M$6733 3686 147 61 167 nfet_01v8 L=150000U W=140000U AS=16800000000P
+ AD=21875000000P PS=380000U PD=460000U
* device instance $6734 r0 *1 43.96,30.69 nfet_01v8
M$6734 4411 147 64 167 nfet_01v8 L=150000U W=140000U AS=16800000000P
+ AD=21875000000P PS=380000U PD=460000U
* device instance $6735 r0 *1 43.405,31.09 nfet_01v8
M$6735 167 2204 3686 167 nfet_01v8 L=150000U W=210000U AS=21875000000P
+ AD=40400000000P PS=460000U PD=560000U
* device instance $6736 r0 *1 43.995,31.09 nfet_01v8
M$6736 167 1837 4411 167 nfet_01v8 L=150000U W=210000U AS=21875000000P
+ AD=40400000000P PS=460000U PD=560000U
* device instance $6737 r0 *1 43.405,31.48 nfet_01v8
M$6737 2204 3686 167 167 nfet_01v8 L=150000U W=210000U AS=40400000000P
+ AD=21875000000P PS=560000U PD=460000U
* device instance $6738 r0 *1 43.995,31.48 nfet_01v8
M$6738 1837 4411 167 167 nfet_01v8 L=150000U W=210000U AS=40400000000P
+ AD=21875000000P PS=560000U PD=460000U
* device instance $6739 r0 *1 43.44,31.88 nfet_01v8
M$6739 62 147 2204 167 nfet_01v8 L=150000U W=140000U AS=21875000000P
+ AD=16800000000P PS=460000U PD=380000U
* device instance $6740 r0 *1 43.96,31.88 nfet_01v8
M$6740 63 147 1837 167 nfet_01v8 L=150000U W=140000U AS=21875000000P
+ AD=16800000000P PS=460000U PD=380000U
* device instance $6741 r0 *1 43.44,32.27 nfet_01v8
M$6741 2101 148 62 167 nfet_01v8 L=150000U W=140000U AS=16800000000P
+ AD=21875000000P PS=380000U PD=460000U
* device instance $6742 r0 *1 43.96,32.27 nfet_01v8
M$6742 1279 148 63 167 nfet_01v8 L=150000U W=140000U AS=16800000000P
+ AD=21875000000P PS=380000U PD=460000U
* device instance $6743 r0 *1 43.405,32.67 nfet_01v8
M$6743 167 2209 2101 167 nfet_01v8 L=150000U W=210000U AS=21875000000P
+ AD=40400000000P PS=460000U PD=560000U
* device instance $6744 r0 *1 43.995,32.67 nfet_01v8
M$6744 167 1856 1279 167 nfet_01v8 L=150000U W=210000U AS=21875000000P
+ AD=40400000000P PS=460000U PD=560000U
* device instance $6745 r0 *1 43.405,33.06 nfet_01v8
M$6745 2209 2101 167 167 nfet_01v8 L=150000U W=210000U AS=40400000000P
+ AD=21875000000P PS=560000U PD=460000U
* device instance $6746 r0 *1 43.995,33.06 nfet_01v8
M$6746 1856 1279 167 167 nfet_01v8 L=150000U W=210000U AS=40400000000P
+ AD=21875000000P PS=560000U PD=460000U
* device instance $6747 r0 *1 43.44,33.46 nfet_01v8
M$6747 61 148 2209 167 nfet_01v8 L=150000U W=140000U AS=21875000000P
+ AD=16800000000P PS=460000U PD=380000U
* device instance $6748 r0 *1 43.96,33.46 nfet_01v8
M$6748 64 148 1856 167 nfet_01v8 L=150000U W=140000U AS=21875000000P
+ AD=16800000000P PS=460000U PD=380000U
* device instance $6749 r0 *1 43.44,33.85 nfet_01v8
M$6749 3681 149 61 167 nfet_01v8 L=150000U W=140000U AS=16800000000P
+ AD=21875000000P PS=380000U PD=460000U
* device instance $6750 r0 *1 43.96,33.85 nfet_01v8
M$6750 1277 149 64 167 nfet_01v8 L=150000U W=140000U AS=16800000000P
+ AD=21875000000P PS=380000U PD=460000U
* device instance $6751 r0 *1 43.405,34.25 nfet_01v8
M$6751 167 2743 3681 167 nfet_01v8 L=150000U W=210000U AS=21875000000P
+ AD=40400000000P PS=460000U PD=560000U
* device instance $6752 r0 *1 43.995,34.25 nfet_01v8
M$6752 167 1854 1277 167 nfet_01v8 L=150000U W=210000U AS=21875000000P
+ AD=40400000000P PS=460000U PD=560000U
* device instance $6753 r0 *1 43.405,34.64 nfet_01v8
M$6753 2743 3681 167 167 nfet_01v8 L=150000U W=210000U AS=40400000000P
+ AD=21875000000P PS=560000U PD=460000U
* device instance $6754 r0 *1 43.995,34.64 nfet_01v8
M$6754 1854 1277 167 167 nfet_01v8 L=150000U W=210000U AS=40400000000P
+ AD=21875000000P PS=560000U PD=460000U
* device instance $6755 r0 *1 43.44,35.04 nfet_01v8
M$6755 62 149 2743 167 nfet_01v8 L=150000U W=140000U AS=21875000000P
+ AD=16800000000P PS=460000U PD=380000U
* device instance $6756 r0 *1 43.96,35.04 nfet_01v8
M$6756 63 149 1854 167 nfet_01v8 L=150000U W=140000U AS=21875000000P
+ AD=16800000000P PS=460000U PD=380000U
* device instance $6757 r0 *1 54.34,29.11 nfet_01v8
M$6757 3477 146 78 167 nfet_01v8 L=150000U W=140000U AS=16800000000P
+ AD=21875000000P PS=380000U PD=460000U
* device instance $6758 r0 *1 54.86,29.11 nfet_01v8
M$6758 1148 146 79 167 nfet_01v8 L=150000U W=140000U AS=16800000000P
+ AD=21875000000P PS=380000U PD=460000U
* device instance $6759 r0 *1 54.305,29.51 nfet_01v8
M$6759 167 2872 3477 167 nfet_01v8 L=150000U W=210000U AS=21875000000P
+ AD=40400000000P PS=460000U PD=560000U
* device instance $6760 r0 *1 54.895,29.51 nfet_01v8
M$6760 167 1705 1148 167 nfet_01v8 L=150000U W=210000U AS=21875000000P
+ AD=40400000000P PS=460000U PD=560000U
* device instance $6761 r0 *1 54.305,29.9 nfet_01v8
M$6761 2872 3477 167 167 nfet_01v8 L=150000U W=210000U AS=40400000000P
+ AD=21875000000P PS=560000U PD=460000U
* device instance $6762 r0 *1 54.895,29.9 nfet_01v8
M$6762 1705 1148 167 167 nfet_01v8 L=150000U W=210000U AS=40400000000P
+ AD=21875000000P PS=560000U PD=460000U
* device instance $6763 r0 *1 54.34,30.3 nfet_01v8
M$6763 77 146 2872 167 nfet_01v8 L=150000U W=140000U AS=21875000000P
+ AD=16800000000P PS=460000U PD=380000U
* device instance $6764 r0 *1 54.86,30.3 nfet_01v8
M$6764 80 146 1705 167 nfet_01v8 L=150000U W=140000U AS=21875000000P
+ AD=16800000000P PS=460000U PD=380000U
* device instance $6765 r0 *1 54.34,30.69 nfet_01v8
M$6765 3474 147 77 167 nfet_01v8 L=150000U W=140000U AS=16800000000P
+ AD=21875000000P PS=380000U PD=460000U
* device instance $6766 r0 *1 54.86,30.69 nfet_01v8
M$6766 4355 147 80 167 nfet_01v8 L=150000U W=140000U AS=16800000000P
+ AD=21875000000P PS=380000U PD=460000U
* device instance $6767 r0 *1 54.305,31.09 nfet_01v8
M$6767 167 2878 3474 167 nfet_01v8 L=150000U W=210000U AS=21875000000P
+ AD=40400000000P PS=460000U PD=560000U
* device instance $6768 r0 *1 54.895,31.09 nfet_01v8
M$6768 167 1706 4355 167 nfet_01v8 L=150000U W=210000U AS=21875000000P
+ AD=40400000000P PS=460000U PD=560000U
* device instance $6769 r0 *1 54.305,31.48 nfet_01v8
M$6769 2878 3474 167 167 nfet_01v8 L=150000U W=210000U AS=40400000000P
+ AD=21875000000P PS=560000U PD=460000U
* device instance $6770 r0 *1 54.895,31.48 nfet_01v8
M$6770 1706 4355 167 167 nfet_01v8 L=150000U W=210000U AS=40400000000P
+ AD=21875000000P PS=560000U PD=460000U
* device instance $6771 r0 *1 54.34,31.88 nfet_01v8
M$6771 78 147 2878 167 nfet_01v8 L=150000U W=140000U AS=21875000000P
+ AD=16800000000P PS=460000U PD=380000U
* device instance $6772 r0 *1 54.86,31.88 nfet_01v8
M$6772 79 147 1706 167 nfet_01v8 L=150000U W=140000U AS=21875000000P
+ AD=16800000000P PS=460000U PD=380000U
* device instance $6773 r0 *1 54.34,32.27 nfet_01v8
M$6773 3469 148 78 167 nfet_01v8 L=150000U W=140000U AS=16800000000P
+ AD=21875000000P PS=380000U PD=460000U
* device instance $6774 r0 *1 54.86,32.27 nfet_01v8
M$6774 1139 148 79 167 nfet_01v8 L=150000U W=140000U AS=16800000000P
+ AD=21875000000P PS=380000U PD=460000U
* device instance $6775 r0 *1 54.305,32.67 nfet_01v8
M$6775 167 2244 3469 167 nfet_01v8 L=150000U W=210000U AS=21875000000P
+ AD=40400000000P PS=460000U PD=560000U
* device instance $6776 r0 *1 54.895,32.67 nfet_01v8
M$6776 167 1696 1139 167 nfet_01v8 L=150000U W=210000U AS=21875000000P
+ AD=40400000000P PS=460000U PD=560000U
* device instance $6777 r0 *1 54.305,33.06 nfet_01v8
M$6777 2244 3469 167 167 nfet_01v8 L=150000U W=210000U AS=40400000000P
+ AD=21875000000P PS=560000U PD=460000U
* device instance $6778 r0 *1 54.895,33.06 nfet_01v8
M$6778 1696 1139 167 167 nfet_01v8 L=150000U W=210000U AS=40400000000P
+ AD=21875000000P PS=560000U PD=460000U
* device instance $6779 r0 *1 54.34,33.46 nfet_01v8
M$6779 77 148 2244 167 nfet_01v8 L=150000U W=140000U AS=21875000000P
+ AD=16800000000P PS=460000U PD=380000U
* device instance $6780 r0 *1 54.86,33.46 nfet_01v8
M$6780 80 148 1696 167 nfet_01v8 L=150000U W=140000U AS=21875000000P
+ AD=16800000000P PS=460000U PD=380000U
* device instance $6781 r0 *1 54.34,33.85 nfet_01v8
M$6781 2451 149 77 167 nfet_01v8 L=150000U W=140000U AS=16800000000P
+ AD=21875000000P PS=380000U PD=460000U
* device instance $6782 r0 *1 54.86,33.85 nfet_01v8
M$6782 1140 149 80 167 nfet_01v8 L=150000U W=140000U AS=16800000000P
+ AD=21875000000P PS=380000U PD=460000U
* device instance $6783 r0 *1 54.305,34.25 nfet_01v8
M$6783 167 2920 2451 167 nfet_01v8 L=150000U W=210000U AS=21875000000P
+ AD=40400000000P PS=460000U PD=560000U
* device instance $6784 r0 *1 54.895,34.25 nfet_01v8
M$6784 167 1697 1140 167 nfet_01v8 L=150000U W=210000U AS=21875000000P
+ AD=40400000000P PS=460000U PD=560000U
* device instance $6785 r0 *1 54.305,34.64 nfet_01v8
M$6785 2920 2451 167 167 nfet_01v8 L=150000U W=210000U AS=40400000000P
+ AD=21875000000P PS=560000U PD=460000U
* device instance $6786 r0 *1 54.895,34.64 nfet_01v8
M$6786 1697 1140 167 167 nfet_01v8 L=150000U W=210000U AS=40400000000P
+ AD=21875000000P PS=560000U PD=460000U
* device instance $6787 r0 *1 54.34,35.04 nfet_01v8
M$6787 78 149 2920 167 nfet_01v8 L=150000U W=140000U AS=21875000000P
+ AD=16800000000P PS=460000U PD=380000U
* device instance $6788 r0 *1 54.86,35.04 nfet_01v8
M$6788 79 149 1697 167 nfet_01v8 L=150000U W=140000U AS=21875000000P
+ AD=16800000000P PS=460000U PD=380000U
* device instance $6789 r0 *1 65.24,29.11 nfet_01v8
M$6789 3467 146 94 167 nfet_01v8 L=150000U W=140000U AS=16800000000P
+ AD=21875000000P PS=380000U PD=460000U
* device instance $6790 r0 *1 65.76,29.11 nfet_01v8
M$6790 978 146 95 167 nfet_01v8 L=150000U W=140000U AS=16800000000P
+ AD=21875000000P PS=380000U PD=460000U
* device instance $6791 r0 *1 65.205,29.51 nfet_01v8
M$6791 167 2870 3467 167 nfet_01v8 L=150000U W=210000U AS=21875000000P
+ AD=40400000000P PS=460000U PD=560000U
* device instance $6792 r0 *1 65.795,29.51 nfet_01v8
M$6792 167 1510 978 167 nfet_01v8 L=150000U W=210000U AS=21875000000P
+ AD=40400000000P PS=460000U PD=560000U
* device instance $6793 r0 *1 65.205,29.9 nfet_01v8
M$6793 2870 3467 167 167 nfet_01v8 L=150000U W=210000U AS=40400000000P
+ AD=21875000000P PS=560000U PD=460000U
* device instance $6794 r0 *1 65.795,29.9 nfet_01v8
M$6794 1510 978 167 167 nfet_01v8 L=150000U W=210000U AS=40400000000P
+ AD=21875000000P PS=560000U PD=460000U
* device instance $6795 r0 *1 65.24,30.3 nfet_01v8
M$6795 93 146 2870 167 nfet_01v8 L=150000U W=140000U AS=21875000000P
+ AD=16800000000P PS=460000U PD=380000U
* device instance $6796 r0 *1 65.76,30.3 nfet_01v8
M$6796 96 146 1510 167 nfet_01v8 L=150000U W=140000U AS=21875000000P
+ AD=16800000000P PS=460000U PD=380000U
* device instance $6797 r0 *1 65.24,30.69 nfet_01v8
M$6797 3468 147 93 167 nfet_01v8 L=150000U W=140000U AS=16800000000P
+ AD=21875000000P PS=380000U PD=460000U
* device instance $6798 r0 *1 65.76,30.69 nfet_01v8
M$6798 4350 147 96 167 nfet_01v8 L=150000U W=140000U AS=16800000000P
+ AD=21875000000P PS=380000U PD=460000U
* device instance $6799 r0 *1 65.205,31.09 nfet_01v8
M$6799 167 2903 3468 167 nfet_01v8 L=150000U W=210000U AS=21875000000P
+ AD=40400000000P PS=460000U PD=560000U
* device instance $6800 r0 *1 65.795,31.09 nfet_01v8
M$6800 167 1512 4350 167 nfet_01v8 L=150000U W=210000U AS=21875000000P
+ AD=40400000000P PS=460000U PD=560000U
* device instance $6801 r0 *1 65.205,31.48 nfet_01v8
M$6801 2903 3468 167 167 nfet_01v8 L=150000U W=210000U AS=40400000000P
+ AD=21875000000P PS=560000U PD=460000U
* device instance $6802 r0 *1 65.795,31.48 nfet_01v8
M$6802 1512 4350 167 167 nfet_01v8 L=150000U W=210000U AS=40400000000P
+ AD=21875000000P PS=560000U PD=460000U
* device instance $6803 r0 *1 65.24,31.88 nfet_01v8
M$6803 94 147 2903 167 nfet_01v8 L=150000U W=140000U AS=21875000000P
+ AD=16800000000P PS=460000U PD=380000U
* device instance $6804 r0 *1 65.76,31.88 nfet_01v8
M$6804 95 147 1512 167 nfet_01v8 L=150000U W=140000U AS=21875000000P
+ AD=16800000000P PS=460000U PD=380000U
* device instance $6805 r0 *1 65.24,32.27 nfet_01v8
M$6805 2394 148 94 167 nfet_01v8 L=150000U W=140000U AS=16800000000P
+ AD=21875000000P PS=380000U PD=460000U
* device instance $6806 r0 *1 65.76,32.27 nfet_01v8
M$6806 972 148 95 167 nfet_01v8 L=150000U W=140000U AS=16800000000P
+ AD=21875000000P PS=380000U PD=460000U
* device instance $6807 r0 *1 65.205,32.67 nfet_01v8
M$6807 167 2808 2394 167 nfet_01v8 L=150000U W=210000U AS=21875000000P
+ AD=40400000000P PS=460000U PD=560000U
* device instance $6808 r0 *1 65.795,32.67 nfet_01v8
M$6808 167 1502 972 167 nfet_01v8 L=150000U W=210000U AS=21875000000P
+ AD=40400000000P PS=460000U PD=560000U
* device instance $6809 r0 *1 65.205,33.06 nfet_01v8
M$6809 2808 2394 167 167 nfet_01v8 L=150000U W=210000U AS=40400000000P
+ AD=21875000000P PS=560000U PD=460000U
* device instance $6810 r0 *1 65.795,33.06 nfet_01v8
M$6810 1502 972 167 167 nfet_01v8 L=150000U W=210000U AS=40400000000P
+ AD=21875000000P PS=560000U PD=460000U
* device instance $6811 r0 *1 65.24,33.46 nfet_01v8
M$6811 93 148 2808 167 nfet_01v8 L=150000U W=140000U AS=21875000000P
+ AD=16800000000P PS=460000U PD=380000U
* device instance $6812 r0 *1 65.76,33.46 nfet_01v8
M$6812 96 148 1502 167 nfet_01v8 L=150000U W=140000U AS=21875000000P
+ AD=16800000000P PS=460000U PD=380000U
* device instance $6813 r0 *1 65.24,33.85 nfet_01v8
M$6813 3420 149 93 167 nfet_01v8 L=150000U W=140000U AS=16800000000P
+ AD=21875000000P PS=380000U PD=460000U
* device instance $6814 r0 *1 65.76,33.85 nfet_01v8
M$6814 973 149 96 167 nfet_01v8 L=150000U W=140000U AS=16800000000P
+ AD=21875000000P PS=380000U PD=460000U
* device instance $6815 r0 *1 65.205,34.25 nfet_01v8
M$6815 167 2807 3420 167 nfet_01v8 L=150000U W=210000U AS=21875000000P
+ AD=40400000000P PS=460000U PD=560000U
* device instance $6816 r0 *1 65.795,34.25 nfet_01v8
M$6816 167 1503 973 167 nfet_01v8 L=150000U W=210000U AS=21875000000P
+ AD=40400000000P PS=460000U PD=560000U
* device instance $6817 r0 *1 65.205,34.64 nfet_01v8
M$6817 2807 3420 167 167 nfet_01v8 L=150000U W=210000U AS=40400000000P
+ AD=21875000000P PS=560000U PD=460000U
* device instance $6818 r0 *1 65.795,34.64 nfet_01v8
M$6818 1503 973 167 167 nfet_01v8 L=150000U W=210000U AS=40400000000P
+ AD=21875000000P PS=560000U PD=460000U
* device instance $6819 r0 *1 65.24,35.04 nfet_01v8
M$6819 94 149 2807 167 nfet_01v8 L=150000U W=140000U AS=21875000000P
+ AD=16800000000P PS=460000U PD=380000U
* device instance $6820 r0 *1 65.76,35.04 nfet_01v8
M$6820 95 149 1503 167 nfet_01v8 L=150000U W=140000U AS=21875000000P
+ AD=16800000000P PS=460000U PD=380000U
* device instance $6821 r0 *1 76.14,29.11 nfet_01v8
M$6821 3435 146 110 167 nfet_01v8 L=150000U W=140000U AS=16800000000P
+ AD=21875000000P PS=380000U PD=460000U
* device instance $6822 r0 *1 76.66,29.11 nfet_01v8
M$6822 949 146 111 167 nfet_01v8 L=150000U W=140000U AS=16800000000P
+ AD=21875000000P PS=380000U PD=460000U
* device instance $6823 r0 *1 76.105,29.51 nfet_01v8
M$6823 167 2909 3435 167 nfet_01v8 L=150000U W=210000U AS=21875000000P
+ AD=40400000000P PS=460000U PD=560000U
* device instance $6824 r0 *1 76.695,29.51 nfet_01v8
M$6824 167 1473 949 167 nfet_01v8 L=150000U W=210000U AS=21875000000P
+ AD=40400000000P PS=460000U PD=560000U
* device instance $6825 r0 *1 76.105,29.9 nfet_01v8
M$6825 2909 3435 167 167 nfet_01v8 L=150000U W=210000U AS=40400000000P
+ AD=21875000000P PS=560000U PD=460000U
* device instance $6826 r0 *1 76.695,29.9 nfet_01v8
M$6826 1473 949 167 167 nfet_01v8 L=150000U W=210000U AS=40400000000P
+ AD=21875000000P PS=560000U PD=460000U
* device instance $6827 r0 *1 76.14,30.3 nfet_01v8
M$6827 109 146 2909 167 nfet_01v8 L=150000U W=140000U AS=21875000000P
+ AD=16800000000P PS=460000U PD=380000U
* device instance $6828 r0 *1 76.66,30.3 nfet_01v8
M$6828 112 146 1473 167 nfet_01v8 L=150000U W=140000U AS=21875000000P
+ AD=16800000000P PS=460000U PD=380000U
* device instance $6829 r0 *1 76.14,30.69 nfet_01v8
M$6829 3437 147 109 167 nfet_01v8 L=150000U W=140000U AS=16800000000P
+ AD=21875000000P PS=380000U PD=460000U
* device instance $6830 r0 *1 76.66,30.69 nfet_01v8
M$6830 4310 147 112 167 nfet_01v8 L=150000U W=140000U AS=16800000000P
+ AD=21875000000P PS=380000U PD=460000U
* device instance $6831 r0 *1 76.105,31.09 nfet_01v8
M$6831 167 2052 3437 167 nfet_01v8 L=150000U W=210000U AS=21875000000P
+ AD=40400000000P PS=460000U PD=560000U
* device instance $6832 r0 *1 76.695,31.09 nfet_01v8
M$6832 167 841 4310 167 nfet_01v8 L=150000U W=210000U AS=21875000000P
+ AD=40400000000P PS=460000U PD=560000U
* device instance $6833 r0 *1 76.105,31.48 nfet_01v8
M$6833 2052 3437 167 167 nfet_01v8 L=150000U W=210000U AS=40400000000P
+ AD=21875000000P PS=560000U PD=460000U
* device instance $6834 r0 *1 76.695,31.48 nfet_01v8
M$6834 841 4310 167 167 nfet_01v8 L=150000U W=210000U AS=40400000000P
+ AD=21875000000P PS=560000U PD=460000U
* device instance $6835 r0 *1 76.14,31.88 nfet_01v8
M$6835 110 147 2052 167 nfet_01v8 L=150000U W=140000U AS=21875000000P
+ AD=16800000000P PS=460000U PD=380000U
* device instance $6836 r0 *1 76.66,31.88 nfet_01v8
M$6836 111 147 841 167 nfet_01v8 L=150000U W=140000U AS=21875000000P
+ AD=16800000000P PS=460000U PD=380000U
* device instance $6837 r0 *1 76.14,32.27 nfet_01v8
M$6837 3429 148 110 167 nfet_01v8 L=150000U W=140000U AS=16800000000P
+ AD=21875000000P PS=380000U PD=460000U
* device instance $6838 r0 *1 76.66,32.27 nfet_01v8
M$6838 663 148 111 167 nfet_01v8 L=150000U W=140000U AS=16800000000P
+ AD=21875000000P PS=380000U PD=460000U
* device instance $6839 r0 *1 76.105,32.67 nfet_01v8
M$6839 167 2155 3429 167 nfet_01v8 L=150000U W=210000U AS=21875000000P
+ AD=40400000000P PS=460000U PD=560000U
* device instance $6840 r0 *1 76.695,32.67 nfet_01v8
M$6840 167 851 663 167 nfet_01v8 L=150000U W=210000U AS=21875000000P
+ AD=40400000000P PS=460000U PD=560000U
* device instance $6841 r0 *1 76.105,33.06 nfet_01v8
M$6841 2155 3429 167 167 nfet_01v8 L=150000U W=210000U AS=40400000000P
+ AD=21875000000P PS=560000U PD=460000U
* device instance $6842 r0 *1 76.695,33.06 nfet_01v8
M$6842 851 663 167 167 nfet_01v8 L=150000U W=210000U AS=40400000000P
+ AD=21875000000P PS=560000U PD=460000U
* device instance $6843 r0 *1 76.14,33.46 nfet_01v8
M$6843 109 148 2155 167 nfet_01v8 L=150000U W=140000U AS=21875000000P
+ AD=16800000000P PS=460000U PD=380000U
* device instance $6844 r0 *1 76.66,33.46 nfet_01v8
M$6844 112 148 851 167 nfet_01v8 L=150000U W=140000U AS=21875000000P
+ AD=16800000000P PS=460000U PD=380000U
* device instance $6845 r0 *1 76.14,33.85 nfet_01v8
M$6845 3427 149 109 167 nfet_01v8 L=150000U W=140000U AS=16800000000P
+ AD=21875000000P PS=380000U PD=460000U
* device instance $6846 r0 *1 76.66,33.85 nfet_01v8
M$6846 940 149 112 167 nfet_01v8 L=150000U W=140000U AS=16800000000P
+ AD=21875000000P PS=380000U PD=460000U
* device instance $6847 r0 *1 76.105,34.25 nfet_01v8
M$6847 167 2685 3427 167 nfet_01v8 L=150000U W=210000U AS=21875000000P
+ AD=40400000000P PS=460000U PD=560000U
* device instance $6848 r0 *1 76.695,34.25 nfet_01v8
M$6848 167 1463 940 167 nfet_01v8 L=150000U W=210000U AS=21875000000P
+ AD=40400000000P PS=460000U PD=560000U
* device instance $6849 r0 *1 76.105,34.64 nfet_01v8
M$6849 2685 3427 167 167 nfet_01v8 L=150000U W=210000U AS=40400000000P
+ AD=21875000000P PS=560000U PD=460000U
* device instance $6850 r0 *1 76.695,34.64 nfet_01v8
M$6850 1463 940 167 167 nfet_01v8 L=150000U W=210000U AS=40400000000P
+ AD=21875000000P PS=560000U PD=460000U
* device instance $6851 r0 *1 76.14,35.04 nfet_01v8
M$6851 110 149 2685 167 nfet_01v8 L=150000U W=140000U AS=21875000000P
+ AD=16800000000P PS=460000U PD=380000U
* device instance $6852 r0 *1 76.66,35.04 nfet_01v8
M$6852 111 149 1463 167 nfet_01v8 L=150000U W=140000U AS=21875000000P
+ AD=16800000000P PS=460000U PD=380000U
* device instance $6853 r0 *1 87.04,29.11 nfet_01v8
M$6853 3425 146 126 167 nfet_01v8 L=150000U W=140000U AS=16800000000P
+ AD=21875000000P PS=380000U PD=460000U
* device instance $6854 r0 *1 87.56,29.11 nfet_01v8
M$6854 965 146 127 167 nfet_01v8 L=150000U W=140000U AS=16800000000P
+ AD=21875000000P PS=380000U PD=460000U
* device instance $6855 r0 *1 87.005,29.51 nfet_01v8
M$6855 167 2705 3425 167 nfet_01v8 L=150000U W=210000U AS=21875000000P
+ AD=40400000000P PS=460000U PD=560000U
* device instance $6856 r0 *1 87.595,29.51 nfet_01v8
M$6856 167 1494 965 167 nfet_01v8 L=150000U W=210000U AS=21875000000P
+ AD=40400000000P PS=460000U PD=560000U
* device instance $6857 r0 *1 87.005,29.9 nfet_01v8
M$6857 2705 3425 167 167 nfet_01v8 L=150000U W=210000U AS=40400000000P
+ AD=21875000000P PS=560000U PD=460000U
* device instance $6858 r0 *1 87.595,29.9 nfet_01v8
M$6858 1494 965 167 167 nfet_01v8 L=150000U W=210000U AS=40400000000P
+ AD=21875000000P PS=560000U PD=460000U
* device instance $6859 r0 *1 87.04,30.3 nfet_01v8
M$6859 125 146 2705 167 nfet_01v8 L=150000U W=140000U AS=21875000000P
+ AD=16800000000P PS=460000U PD=380000U
* device instance $6860 r0 *1 87.56,30.3 nfet_01v8
M$6860 128 146 1494 167 nfet_01v8 L=150000U W=140000U AS=21875000000P
+ AD=16800000000P PS=460000U PD=380000U
* device instance $6861 r0 *1 87.04,30.69 nfet_01v8
M$6861 3343 147 125 167 nfet_01v8 L=150000U W=140000U AS=16800000000P
+ AD=21875000000P PS=380000U PD=460000U
* device instance $6862 r0 *1 87.56,30.69 nfet_01v8
M$6862 4312 147 128 167 nfet_01v8 L=150000U W=140000U AS=16800000000P
+ AD=21875000000P PS=380000U PD=460000U
* device instance $6863 r0 *1 87.005,31.09 nfet_01v8
M$6863 167 2024 3343 167 nfet_01v8 L=150000U W=210000U AS=21875000000P
+ AD=40400000000P PS=460000U PD=560000U
* device instance $6864 r0 *1 87.595,31.09 nfet_01v8
M$6864 167 834 4312 167 nfet_01v8 L=150000U W=210000U AS=21875000000P
+ AD=40400000000P PS=460000U PD=560000U
* device instance $6865 r0 *1 87.005,31.48 nfet_01v8
M$6865 2024 3343 167 167 nfet_01v8 L=150000U W=210000U AS=40400000000P
+ AD=21875000000P PS=560000U PD=460000U
* device instance $6866 r0 *1 87.595,31.48 nfet_01v8
M$6866 834 4312 167 167 nfet_01v8 L=150000U W=210000U AS=40400000000P
+ AD=21875000000P PS=560000U PD=460000U
* device instance $6867 r0 *1 87.04,31.88 nfet_01v8
M$6867 126 147 2024 167 nfet_01v8 L=150000U W=140000U AS=21875000000P
+ AD=16800000000P PS=460000U PD=380000U
* device instance $6868 r0 *1 87.56,31.88 nfet_01v8
M$6868 127 147 834 167 nfet_01v8 L=150000U W=140000U AS=21875000000P
+ AD=16800000000P PS=460000U PD=380000U
* device instance $6869 r0 *1 87.04,32.27 nfet_01v8
M$6869 2538 148 126 167 nfet_01v8 L=150000U W=140000U AS=16800000000P
+ AD=21875000000P PS=380000U PD=460000U
* device instance $6870 r0 *1 87.56,32.27 nfet_01v8
M$6870 954 148 127 167 nfet_01v8 L=150000U W=140000U AS=16800000000P
+ AD=21875000000P PS=380000U PD=460000U
* device instance $6871 r0 *1 87.005,32.67 nfet_01v8
M$6871 167 3112 2538 167 nfet_01v8 L=150000U W=210000U AS=21875000000P
+ AD=40400000000P PS=460000U PD=560000U
* device instance $6872 r0 *1 87.595,32.67 nfet_01v8
M$6872 167 1480 954 167 nfet_01v8 L=150000U W=210000U AS=21875000000P
+ AD=40400000000P PS=460000U PD=560000U
* device instance $6873 r0 *1 87.005,33.06 nfet_01v8
M$6873 3112 2538 167 167 nfet_01v8 L=150000U W=210000U AS=40400000000P
+ AD=21875000000P PS=560000U PD=460000U
* device instance $6874 r0 *1 87.595,33.06 nfet_01v8
M$6874 1480 954 167 167 nfet_01v8 L=150000U W=210000U AS=40400000000P
+ AD=21875000000P PS=560000U PD=460000U
* device instance $6875 r0 *1 87.04,33.46 nfet_01v8
M$6875 125 148 3112 167 nfet_01v8 L=150000U W=140000U AS=21875000000P
+ AD=16800000000P PS=460000U PD=380000U
* device instance $6876 r0 *1 87.56,33.46 nfet_01v8
M$6876 128 148 1480 167 nfet_01v8 L=150000U W=140000U AS=21875000000P
+ AD=16800000000P PS=460000U PD=380000U
* device instance $6877 r0 *1 87.04,33.85 nfet_01v8
M$6877 2536 149 125 167 nfet_01v8 L=150000U W=140000U AS=16800000000P
+ AD=21875000000P PS=380000U PD=460000U
* device instance $6878 r0 *1 87.56,33.85 nfet_01v8
M$6878 955 149 128 167 nfet_01v8 L=150000U W=140000U AS=16800000000P
+ AD=21875000000P PS=380000U PD=460000U
* device instance $6879 r0 *1 87.005,34.25 nfet_01v8
M$6879 167 3108 2536 167 nfet_01v8 L=150000U W=210000U AS=21875000000P
+ AD=40400000000P PS=460000U PD=560000U
* device instance $6880 r0 *1 87.595,34.25 nfet_01v8
M$6880 167 1481 955 167 nfet_01v8 L=150000U W=210000U AS=21875000000P
+ AD=40400000000P PS=460000U PD=560000U
* device instance $6881 r0 *1 87.005,34.64 nfet_01v8
M$6881 3108 2536 167 167 nfet_01v8 L=150000U W=210000U AS=40400000000P
+ AD=21875000000P PS=560000U PD=460000U
* device instance $6882 r0 *1 87.595,34.64 nfet_01v8
M$6882 1481 955 167 167 nfet_01v8 L=150000U W=210000U AS=40400000000P
+ AD=21875000000P PS=560000U PD=460000U
* device instance $6883 r0 *1 87.04,35.04 nfet_01v8
M$6883 126 149 3108 167 nfet_01v8 L=150000U W=140000U AS=21875000000P
+ AD=16800000000P PS=460000U PD=380000U
* device instance $6884 r0 *1 87.56,35.04 nfet_01v8
M$6884 127 149 1481 167 nfet_01v8 L=150000U W=140000U AS=21875000000P
+ AD=16800000000P PS=460000U PD=380000U
* device instance $6885 r0 *1 21.64,60.71 nfet_01v8
M$6885 3700 162 30 167 nfet_01v8 L=150000U W=140000U AS=16800000000P
+ AD=21875000000P PS=380000U PD=460000U
* device instance $6886 r0 *1 22.16,60.71 nfet_01v8
M$6886 929 162 31 167 nfet_01v8 L=150000U W=140000U AS=16800000000P
+ AD=21875000000P PS=380000U PD=460000U
* device instance $6887 r0 *1 21.605,61.11 nfet_01v8
M$6887 167 2967 3700 167 nfet_01v8 L=150000U W=210000U AS=21875000000P
+ AD=40400000000P PS=460000U PD=560000U
* device instance $6888 r0 *1 22.195,61.11 nfet_01v8
M$6888 167 1447 929 167 nfet_01v8 L=150000U W=210000U AS=21875000000P
+ AD=40400000000P PS=460000U PD=560000U
* device instance $6889 r0 *1 21.605,61.5 nfet_01v8
M$6889 2967 3700 167 167 nfet_01v8 L=150000U W=210000U AS=40400000000P
+ AD=21875000000P PS=560000U PD=460000U
* device instance $6890 r0 *1 22.195,61.5 nfet_01v8
M$6890 1447 929 167 167 nfet_01v8 L=150000U W=210000U AS=40400000000P
+ AD=21875000000P PS=560000U PD=460000U
* device instance $6891 r0 *1 21.64,61.9 nfet_01v8
M$6891 29 162 2967 167 nfet_01v8 L=150000U W=140000U AS=21875000000P
+ AD=16800000000P PS=460000U PD=380000U
* device instance $6892 r0 *1 22.16,61.9 nfet_01v8
M$6892 32 162 1447 167 nfet_01v8 L=150000U W=140000U AS=21875000000P
+ AD=16800000000P PS=460000U PD=380000U
* device instance $6893 r0 *1 21.64,62.29 nfet_01v8
M$6893 3706 163 29 167 nfet_01v8 L=150000U W=140000U AS=16800000000P
+ AD=21875000000P PS=380000U PD=460000U
* device instance $6894 r0 *1 22.16,62.29 nfet_01v8
M$6894 4443 163 32 167 nfet_01v8 L=150000U W=140000U AS=16800000000P
+ AD=21875000000P PS=380000U PD=460000U
* device instance $6895 r0 *1 21.605,62.69 nfet_01v8
M$6895 167 3035 3706 167 nfet_01v8 L=150000U W=210000U AS=21875000000P
+ AD=40400000000P PS=460000U PD=560000U
* device instance $6896 r0 *1 22.195,62.69 nfet_01v8
M$6896 167 831 4443 167 nfet_01v8 L=150000U W=210000U AS=21875000000P
+ AD=40400000000P PS=460000U PD=560000U
* device instance $6897 r0 *1 21.605,63.08 nfet_01v8
M$6897 3035 3706 167 167 nfet_01v8 L=150000U W=210000U AS=40400000000P
+ AD=21875000000P PS=560000U PD=460000U
* device instance $6898 r0 *1 22.195,63.08 nfet_01v8
M$6898 831 4443 167 167 nfet_01v8 L=150000U W=210000U AS=40400000000P
+ AD=21875000000P PS=560000U PD=460000U
* device instance $6899 r0 *1 21.64,63.48 nfet_01v8
M$6899 30 163 3035 167 nfet_01v8 L=150000U W=140000U AS=21875000000P
+ AD=16800000000P PS=460000U PD=380000U
* device instance $6900 r0 *1 22.16,63.48 nfet_01v8
M$6900 31 163 831 167 nfet_01v8 L=150000U W=140000U AS=21875000000P
+ AD=16800000000P PS=460000U PD=380000U
* device instance $6901 r0 *1 21.64,63.87 nfet_01v8
M$6901 2509 164 30 167 nfet_01v8 L=150000U W=140000U AS=16800000000P
+ AD=21875000000P PS=380000U PD=460000U
* device instance $6902 r0 *1 22.16,63.87 nfet_01v8
M$6902 906 164 31 167 nfet_01v8 L=150000U W=140000U AS=16800000000P
+ AD=21875000000P PS=380000U PD=460000U
* device instance $6903 r0 *1 21.605,64.27 nfet_01v8
M$6903 167 3046 2509 167 nfet_01v8 L=150000U W=210000U AS=21875000000P
+ AD=40400000000P PS=460000U PD=560000U
* device instance $6904 r0 *1 22.195,64.27 nfet_01v8
M$6904 167 1423 906 167 nfet_01v8 L=150000U W=210000U AS=21875000000P
+ AD=40400000000P PS=460000U PD=560000U
* device instance $6905 r0 *1 21.605,64.66 nfet_01v8
M$6905 3046 2509 167 167 nfet_01v8 L=150000U W=210000U AS=40400000000P
+ AD=21875000000P PS=560000U PD=460000U
* device instance $6906 r0 *1 22.195,64.66 nfet_01v8
M$6906 1423 906 167 167 nfet_01v8 L=150000U W=210000U AS=40400000000P
+ AD=21875000000P PS=560000U PD=460000U
* device instance $6907 r0 *1 21.64,65.06 nfet_01v8
M$6907 29 164 3046 167 nfet_01v8 L=150000U W=140000U AS=21875000000P
+ AD=16800000000P PS=460000U PD=380000U
* device instance $6908 r0 *1 22.16,65.06 nfet_01v8
M$6908 32 164 1423 167 nfet_01v8 L=150000U W=140000U AS=21875000000P
+ AD=16800000000P PS=460000U PD=380000U
* device instance $6909 r0 *1 21.64,65.45 nfet_01v8
M$6909 2480 165 29 167 nfet_01v8 L=150000U W=140000U AS=16800000000P
+ AD=21875000000P PS=380000U PD=460000U
* device instance $6910 r0 *1 22.16,65.45 nfet_01v8
M$6910 926 165 32 167 nfet_01v8 L=150000U W=140000U AS=16800000000P
+ AD=21875000000P PS=380000U PD=460000U
* device instance $6911 r0 *1 21.605,65.85 nfet_01v8
M$6911 167 2983 2480 167 nfet_01v8 L=150000U W=210000U AS=21875000000P
+ AD=40400000000P PS=460000U PD=560000U
* device instance $6912 r0 *1 22.195,65.85 nfet_01v8
M$6912 167 1444 926 167 nfet_01v8 L=150000U W=210000U AS=21875000000P
+ AD=40400000000P PS=460000U PD=560000U
* device instance $6913 r0 *1 21.605,66.24 nfet_01v8
M$6913 2983 2480 167 167 nfet_01v8 L=150000U W=210000U AS=40400000000P
+ AD=21875000000P PS=560000U PD=460000U
* device instance $6914 r0 *1 22.195,66.24 nfet_01v8
M$6914 1444 926 167 167 nfet_01v8 L=150000U W=210000U AS=40400000000P
+ AD=21875000000P PS=560000U PD=460000U
* device instance $6915 r0 *1 21.64,66.64 nfet_01v8
M$6915 30 165 2983 167 nfet_01v8 L=150000U W=140000U AS=21875000000P
+ AD=16800000000P PS=460000U PD=380000U
* device instance $6916 r0 *1 22.16,66.64 nfet_01v8
M$6916 31 165 1444 167 nfet_01v8 L=150000U W=140000U AS=21875000000P
+ AD=16800000000P PS=460000U PD=380000U
* device instance $6917 r0 *1 10.74,21.21 nfet_01v8
M$6917 2392 142 14 167 nfet_01v8 L=150000U W=140000U AS=16800000000P
+ AD=21875000000P PS=380000U PD=460000U
* device instance $6918 r0 *1 11.26,21.21 nfet_01v8
M$6918 1360 142 15 167 nfet_01v8 L=150000U W=140000U AS=16800000000P
+ AD=21875000000P PS=380000U PD=460000U
* device instance $6919 r0 *1 10.705,21.61 nfet_01v8
M$6919 167 2805 2392 167 nfet_01v8 L=150000U W=210000U AS=21875000000P
+ AD=40400000000P PS=460000U PD=560000U
* device instance $6920 r0 *1 11.295,21.61 nfet_01v8
M$6920 167 1951 1360 167 nfet_01v8 L=150000U W=210000U AS=21875000000P
+ AD=40400000000P PS=460000U PD=560000U
* device instance $6921 r0 *1 10.705,22 nfet_01v8
M$6921 2805 2392 167 167 nfet_01v8 L=150000U W=210000U AS=40400000000P
+ AD=21875000000P PS=560000U PD=460000U
* device instance $6922 r0 *1 11.295,22 nfet_01v8
M$6922 1951 1360 167 167 nfet_01v8 L=150000U W=210000U AS=40400000000P
+ AD=21875000000P PS=560000U PD=460000U
* device instance $6923 r0 *1 10.74,22.4 nfet_01v8
M$6923 13 142 2805 167 nfet_01v8 L=150000U W=140000U AS=21875000000P
+ AD=16800000000P PS=460000U PD=380000U
* device instance $6924 r0 *1 11.26,22.4 nfet_01v8
M$6924 16 142 1951 167 nfet_01v8 L=150000U W=140000U AS=21875000000P
+ AD=16800000000P PS=460000U PD=380000U
* device instance $6925 r0 *1 10.74,22.79 nfet_01v8
M$6925 3318 143 13 167 nfet_01v8 L=150000U W=140000U AS=16800000000P
+ AD=21875000000P PS=380000U PD=460000U
* device instance $6926 r0 *1 11.26,22.79 nfet_01v8
M$6926 4539 143 16 167 nfet_01v8 L=150000U W=140000U AS=16800000000P
+ AD=21875000000P PS=380000U PD=460000U
* device instance $6927 r0 *1 10.705,23.19 nfet_01v8
M$6927 167 2848 3318 167 nfet_01v8 L=150000U W=210000U AS=21875000000P
+ AD=40400000000P PS=460000U PD=560000U
* device instance $6928 r0 *1 11.295,23.19 nfet_01v8
M$6928 167 1924 4539 167 nfet_01v8 L=150000U W=210000U AS=21875000000P
+ AD=40400000000P PS=460000U PD=560000U
* device instance $6929 r0 *1 10.705,23.58 nfet_01v8
M$6929 2848 3318 167 167 nfet_01v8 L=150000U W=210000U AS=40400000000P
+ AD=21875000000P PS=560000U PD=460000U
* device instance $6930 r0 *1 11.295,23.58 nfet_01v8
M$6930 1924 4539 167 167 nfet_01v8 L=150000U W=210000U AS=40400000000P
+ AD=21875000000P PS=560000U PD=460000U
* device instance $6931 r0 *1 10.74,23.98 nfet_01v8
M$6931 14 143 2848 167 nfet_01v8 L=150000U W=140000U AS=21875000000P
+ AD=16800000000P PS=460000U PD=380000U
* device instance $6932 r0 *1 11.26,23.98 nfet_01v8
M$6932 15 143 1924 167 nfet_01v8 L=150000U W=140000U AS=21875000000P
+ AD=16800000000P PS=460000U PD=380000U
* device instance $6933 r0 *1 10.74,24.37 nfet_01v8
M$6933 2414 144 14 167 nfet_01v8 L=150000U W=140000U AS=16800000000P
+ AD=21875000000P PS=380000U PD=460000U
* device instance $6934 r0 *1 11.26,24.37 nfet_01v8
M$6934 1377 144 15 167 nfet_01v8 L=150000U W=140000U AS=16800000000P
+ AD=21875000000P PS=380000U PD=460000U
* device instance $6935 r0 *1 10.705,24.77 nfet_01v8
M$6935 167 2838 2414 167 nfet_01v8 L=150000U W=210000U AS=21875000000P
+ AD=40400000000P PS=460000U PD=560000U
* device instance $6936 r0 *1 11.295,24.77 nfet_01v8
M$6936 167 1970 1377 167 nfet_01v8 L=150000U W=210000U AS=21875000000P
+ AD=40400000000P PS=460000U PD=560000U
* device instance $6937 r0 *1 10.705,25.16 nfet_01v8
M$6937 2838 2414 167 167 nfet_01v8 L=150000U W=210000U AS=40400000000P
+ AD=21875000000P PS=560000U PD=460000U
* device instance $6938 r0 *1 11.295,25.16 nfet_01v8
M$6938 1970 1377 167 167 nfet_01v8 L=150000U W=210000U AS=40400000000P
+ AD=21875000000P PS=560000U PD=460000U
* device instance $6939 r0 *1 10.74,25.56 nfet_01v8
M$6939 13 144 2838 167 nfet_01v8 L=150000U W=140000U AS=21875000000P
+ AD=16800000000P PS=460000U PD=380000U
* device instance $6940 r0 *1 11.26,25.56 nfet_01v8
M$6940 16 144 1970 167 nfet_01v8 L=150000U W=140000U AS=21875000000P
+ AD=16800000000P PS=460000U PD=380000U
* device instance $6941 r0 *1 10.74,25.95 nfet_01v8
M$6941 2415 145 13 167 nfet_01v8 L=150000U W=140000U AS=16800000000P
+ AD=21875000000P PS=380000U PD=460000U
* device instance $6942 r0 *1 11.26,25.95 nfet_01v8
M$6942 1375 145 16 167 nfet_01v8 L=150000U W=140000U AS=16800000000P
+ AD=21875000000P PS=380000U PD=460000U
* device instance $6943 r0 *1 10.705,26.35 nfet_01v8
M$6943 167 2839 2415 167 nfet_01v8 L=150000U W=210000U AS=21875000000P
+ AD=40400000000P PS=460000U PD=560000U
* device instance $6944 r0 *1 11.295,26.35 nfet_01v8
M$6944 167 1968 1375 167 nfet_01v8 L=150000U W=210000U AS=21875000000P
+ AD=40400000000P PS=460000U PD=560000U
* device instance $6945 r0 *1 10.705,26.74 nfet_01v8
M$6945 2839 2415 167 167 nfet_01v8 L=150000U W=210000U AS=40400000000P
+ AD=21875000000P PS=560000U PD=460000U
* device instance $6946 r0 *1 11.295,26.74 nfet_01v8
M$6946 1968 1375 167 167 nfet_01v8 L=150000U W=210000U AS=40400000000P
+ AD=21875000000P PS=560000U PD=460000U
* device instance $6947 r0 *1 10.74,27.14 nfet_01v8
M$6947 14 145 2839 167 nfet_01v8 L=150000U W=140000U AS=21875000000P
+ AD=16800000000P PS=460000U PD=380000U
* device instance $6948 r0 *1 11.26,27.14 nfet_01v8
M$6948 15 145 1968 167 nfet_01v8 L=150000U W=140000U AS=21875000000P
+ AD=16800000000P PS=460000U PD=380000U
* device instance $6949 r0 *1 21.64,21.21 nfet_01v8
M$6949 3328 142 30 167 nfet_01v8 L=150000U W=140000U AS=16800000000P
+ AD=21875000000P PS=380000U PD=460000U
* device instance $6950 r0 *1 22.16,21.21 nfet_01v8
M$6950 1291 142 31 167 nfet_01v8 L=150000U W=140000U AS=16800000000P
+ AD=21875000000P PS=380000U PD=460000U
* device instance $6951 r0 *1 21.605,21.61 nfet_01v8
M$6951 167 2877 3328 167 nfet_01v8 L=150000U W=210000U AS=21875000000P
+ AD=40400000000P PS=460000U PD=560000U
* device instance $6952 r0 *1 22.195,21.61 nfet_01v8
M$6952 167 1868 1291 167 nfet_01v8 L=150000U W=210000U AS=21875000000P
+ AD=40400000000P PS=460000U PD=560000U
* device instance $6953 r0 *1 21.605,22 nfet_01v8
M$6953 2877 3328 167 167 nfet_01v8 L=150000U W=210000U AS=40400000000P
+ AD=21875000000P PS=560000U PD=460000U
* device instance $6954 r0 *1 22.195,22 nfet_01v8
M$6954 1868 1291 167 167 nfet_01v8 L=150000U W=210000U AS=40400000000P
+ AD=21875000000P PS=560000U PD=460000U
* device instance $6955 r0 *1 21.64,22.4 nfet_01v8
M$6955 29 142 2877 167 nfet_01v8 L=150000U W=140000U AS=21875000000P
+ AD=16800000000P PS=460000U PD=380000U
* device instance $6956 r0 *1 22.16,22.4 nfet_01v8
M$6956 32 142 1868 167 nfet_01v8 L=150000U W=140000U AS=21875000000P
+ AD=16800000000P PS=460000U PD=380000U
* device instance $6957 r0 *1 21.64,22.79 nfet_01v8
M$6957 3326 143 29 167 nfet_01v8 L=150000U W=140000U AS=16800000000P
+ AD=21875000000P PS=380000U PD=460000U
* device instance $6958 r0 *1 22.16,22.79 nfet_01v8
M$6958 4488 143 32 167 nfet_01v8 L=150000U W=140000U AS=16800000000P
+ AD=21875000000P PS=380000U PD=460000U
* device instance $6959 r0 *1 21.605,23.19 nfet_01v8
M$6959 167 2200 3326 167 nfet_01v8 L=150000U W=210000U AS=21875000000P
+ AD=40400000000P PS=460000U PD=560000U
* device instance $6960 r0 *1 22.195,23.19 nfet_01v8
M$6960 167 1887 4488 167 nfet_01v8 L=150000U W=210000U AS=21875000000P
+ AD=40400000000P PS=460000U PD=560000U
* device instance $6961 r0 *1 21.605,23.58 nfet_01v8
M$6961 2200 3326 167 167 nfet_01v8 L=150000U W=210000U AS=40400000000P
+ AD=21875000000P PS=560000U PD=460000U
* device instance $6962 r0 *1 22.195,23.58 nfet_01v8
M$6962 1887 4488 167 167 nfet_01v8 L=150000U W=210000U AS=40400000000P
+ AD=21875000000P PS=560000U PD=460000U
* device instance $6963 r0 *1 21.64,23.98 nfet_01v8
M$6963 30 143 2200 167 nfet_01v8 L=150000U W=140000U AS=21875000000P
+ AD=16800000000P PS=460000U PD=380000U
* device instance $6964 r0 *1 22.16,23.98 nfet_01v8
M$6964 31 143 1887 167 nfet_01v8 L=150000U W=140000U AS=21875000000P
+ AD=16800000000P PS=460000U PD=380000U
* device instance $6965 r0 *1 21.64,24.37 nfet_01v8
M$6965 3329 144 30 167 nfet_01v8 L=150000U W=140000U AS=16800000000P
+ AD=21875000000P PS=380000U PD=460000U
* device instance $6966 r0 *1 22.16,24.37 nfet_01v8
M$6966 1317 144 31 167 nfet_01v8 L=150000U W=140000U AS=16800000000P
+ AD=21875000000P PS=380000U PD=460000U
* device instance $6967 r0 *1 21.605,24.77 nfet_01v8
M$6967 167 2201 3329 167 nfet_01v8 L=150000U W=210000U AS=21875000000P
+ AD=40400000000P PS=460000U PD=560000U
* device instance $6968 r0 *1 22.195,24.77 nfet_01v8
M$6968 167 1897 1317 167 nfet_01v8 L=150000U W=210000U AS=21875000000P
+ AD=40400000000P PS=460000U PD=560000U
* device instance $6969 r0 *1 21.605,25.16 nfet_01v8
M$6969 2201 3329 167 167 nfet_01v8 L=150000U W=210000U AS=40400000000P
+ AD=21875000000P PS=560000U PD=460000U
* device instance $6970 r0 *1 22.195,25.16 nfet_01v8
M$6970 1897 1317 167 167 nfet_01v8 L=150000U W=210000U AS=40400000000P
+ AD=21875000000P PS=560000U PD=460000U
* device instance $6971 r0 *1 21.64,25.56 nfet_01v8
M$6971 29 144 2201 167 nfet_01v8 L=150000U W=140000U AS=21875000000P
+ AD=16800000000P PS=460000U PD=380000U
* device instance $6972 r0 *1 22.16,25.56 nfet_01v8
M$6972 32 144 1897 167 nfet_01v8 L=150000U W=140000U AS=21875000000P
+ AD=16800000000P PS=460000U PD=380000U
* device instance $6973 r0 *1 21.64,25.95 nfet_01v8
M$6973 2441 145 29 167 nfet_01v8 L=150000U W=140000U AS=16800000000P
+ AD=21875000000P PS=380000U PD=460000U
* device instance $6974 r0 *1 22.16,25.95 nfet_01v8
M$6974 1311 145 32 167 nfet_01v8 L=150000U W=140000U AS=16800000000P
+ AD=21875000000P PS=380000U PD=460000U
* device instance $6975 r0 *1 21.605,26.35 nfet_01v8
M$6975 167 2905 2441 167 nfet_01v8 L=150000U W=210000U AS=21875000000P
+ AD=40400000000P PS=460000U PD=560000U
* device instance $6976 r0 *1 22.195,26.35 nfet_01v8
M$6976 167 1891 1311 167 nfet_01v8 L=150000U W=210000U AS=21875000000P
+ AD=40400000000P PS=460000U PD=560000U
* device instance $6977 r0 *1 21.605,26.74 nfet_01v8
M$6977 2905 2441 167 167 nfet_01v8 L=150000U W=210000U AS=40400000000P
+ AD=21875000000P PS=560000U PD=460000U
* device instance $6978 r0 *1 22.195,26.74 nfet_01v8
M$6978 1891 1311 167 167 nfet_01v8 L=150000U W=210000U AS=40400000000P
+ AD=21875000000P PS=560000U PD=460000U
* device instance $6979 r0 *1 21.64,27.14 nfet_01v8
M$6979 30 145 2905 167 nfet_01v8 L=150000U W=140000U AS=21875000000P
+ AD=16800000000P PS=460000U PD=380000U
* device instance $6980 r0 *1 22.16,27.14 nfet_01v8
M$6980 31 145 1891 167 nfet_01v8 L=150000U W=140000U AS=21875000000P
+ AD=16800000000P PS=460000U PD=380000U
* device instance $6981 r0 *1 32.54,21.21 nfet_01v8
M$6981 2437 142 46 167 nfet_01v8 L=150000U W=140000U AS=16800000000P
+ AD=21875000000P PS=380000U PD=460000U
* device instance $6982 r0 *1 33.06,21.21 nfet_01v8
M$6982 1213 142 47 167 nfet_01v8 L=150000U W=140000U AS=16800000000P
+ AD=21875000000P PS=380000U PD=460000U
* device instance $6983 r0 *1 32.505,21.61 nfet_01v8
M$6983 167 2894 2437 167 nfet_01v8 L=150000U W=210000U AS=21875000000P
+ AD=40400000000P PS=460000U PD=560000U
* device instance $6984 r0 *1 33.095,21.61 nfet_01v8
M$6984 167 1784 1213 167 nfet_01v8 L=150000U W=210000U AS=21875000000P
+ AD=40400000000P PS=460000U PD=560000U
* device instance $6985 r0 *1 32.505,22 nfet_01v8
M$6985 2894 2437 167 167 nfet_01v8 L=150000U W=210000U AS=40400000000P
+ AD=21875000000P PS=560000U PD=460000U
* device instance $6986 r0 *1 33.095,22 nfet_01v8
M$6986 1784 1213 167 167 nfet_01v8 L=150000U W=210000U AS=40400000000P
+ AD=21875000000P PS=560000U PD=460000U
* device instance $6987 r0 *1 32.54,22.4 nfet_01v8
M$6987 45 142 2894 167 nfet_01v8 L=150000U W=140000U AS=21875000000P
+ AD=16800000000P PS=460000U PD=380000U
* device instance $6988 r0 *1 33.06,22.4 nfet_01v8
M$6988 48 142 1784 167 nfet_01v8 L=150000U W=140000U AS=21875000000P
+ AD=16800000000P PS=460000U PD=380000U
* device instance $6989 r0 *1 32.54,22.79 nfet_01v8
M$6989 3192 143 45 167 nfet_01v8 L=150000U W=140000U AS=16800000000P
+ AD=21875000000P PS=380000U PD=460000U
* device instance $6990 r0 *1 33.06,22.79 nfet_01v8
M$6990 4519 143 48 167 nfet_01v8 L=150000U W=140000U AS=16800000000P
+ AD=21875000000P PS=380000U PD=460000U
* device instance $6991 r0 *1 32.505,23.19 nfet_01v8
M$6991 167 2230 3192 167 nfet_01v8 L=150000U W=210000U AS=21875000000P
+ AD=40400000000P PS=460000U PD=560000U
* device instance $6992 r0 *1 33.095,23.19 nfet_01v8
M$6992 167 680 4519 167 nfet_01v8 L=150000U W=210000U AS=21875000000P
+ AD=40400000000P PS=460000U PD=560000U
* device instance $6993 r0 *1 32.505,23.58 nfet_01v8
M$6993 2230 3192 167 167 nfet_01v8 L=150000U W=210000U AS=40400000000P
+ AD=21875000000P PS=560000U PD=460000U
* device instance $6994 r0 *1 33.095,23.58 nfet_01v8
M$6994 680 4519 167 167 nfet_01v8 L=150000U W=210000U AS=40400000000P
+ AD=21875000000P PS=560000U PD=460000U
* device instance $6995 r0 *1 32.54,23.98 nfet_01v8
M$6995 46 143 2230 167 nfet_01v8 L=150000U W=140000U AS=21875000000P
+ AD=16800000000P PS=460000U PD=380000U
* device instance $6996 r0 *1 33.06,23.98 nfet_01v8
M$6996 47 143 680 167 nfet_01v8 L=150000U W=140000U AS=21875000000P
+ AD=16800000000P PS=460000U PD=380000U
* device instance $6997 r0 *1 32.54,24.37 nfet_01v8
M$6997 2112 144 46 167 nfet_01v8 L=150000U W=140000U AS=16800000000P
+ AD=21875000000P PS=380000U PD=460000U
* device instance $6998 r0 *1 33.06,24.37 nfet_01v8
M$6998 1187 144 47 167 nfet_01v8 L=150000U W=140000U AS=16800000000P
+ AD=21875000000P PS=380000U PD=460000U
* device instance $6999 r0 *1 32.505,24.77 nfet_01v8
M$6999 167 2232 2112 167 nfet_01v8 L=150000U W=210000U AS=21875000000P
+ AD=40400000000P PS=460000U PD=560000U
* device instance $7000 r0 *1 33.095,24.77 nfet_01v8
M$7000 167 1752 1187 167 nfet_01v8 L=150000U W=210000U AS=21875000000P
+ AD=40400000000P PS=460000U PD=560000U
* device instance $7001 r0 *1 32.505,25.16 nfet_01v8
M$7001 2232 2112 167 167 nfet_01v8 L=150000U W=210000U AS=40400000000P
+ AD=21875000000P PS=560000U PD=460000U
* device instance $7002 r0 *1 33.095,25.16 nfet_01v8
M$7002 1752 1187 167 167 nfet_01v8 L=150000U W=210000U AS=40400000000P
+ AD=21875000000P PS=560000U PD=460000U
* device instance $7003 r0 *1 32.54,25.56 nfet_01v8
M$7003 45 144 2232 167 nfet_01v8 L=150000U W=140000U AS=21875000000P
+ AD=16800000000P PS=460000U PD=380000U
* device instance $7004 r0 *1 33.06,25.56 nfet_01v8
M$7004 48 144 1752 167 nfet_01v8 L=150000U W=140000U AS=21875000000P
+ AD=16800000000P PS=460000U PD=380000U
* device instance $7005 r0 *1 32.54,25.95 nfet_01v8
M$7005 2443 145 45 167 nfet_01v8 L=150000U W=140000U AS=16800000000P
+ AD=21875000000P PS=380000U PD=460000U
* device instance $7006 r0 *1 33.06,25.95 nfet_01v8
M$7006 1188 145 48 167 nfet_01v8 L=150000U W=140000U AS=16800000000P
+ AD=21875000000P PS=380000U PD=460000U
* device instance $7007 r0 *1 32.505,26.35 nfet_01v8
M$7007 167 2907 2443 167 nfet_01v8 L=150000U W=210000U AS=21875000000P
+ AD=40400000000P PS=460000U PD=560000U
* device instance $7008 r0 *1 33.095,26.35 nfet_01v8
M$7008 167 1754 1188 167 nfet_01v8 L=150000U W=210000U AS=21875000000P
+ AD=40400000000P PS=460000U PD=560000U
* device instance $7009 r0 *1 32.505,26.74 nfet_01v8
M$7009 2907 2443 167 167 nfet_01v8 L=150000U W=210000U AS=40400000000P
+ AD=21875000000P PS=560000U PD=460000U
* device instance $7010 r0 *1 33.095,26.74 nfet_01v8
M$7010 1754 1188 167 167 nfet_01v8 L=150000U W=210000U AS=40400000000P
+ AD=21875000000P PS=560000U PD=460000U
* device instance $7011 r0 *1 32.54,27.14 nfet_01v8
M$7011 46 145 2907 167 nfet_01v8 L=150000U W=140000U AS=21875000000P
+ AD=16800000000P PS=460000U PD=380000U
* device instance $7012 r0 *1 33.06,27.14 nfet_01v8
M$7012 47 145 1754 167 nfet_01v8 L=150000U W=140000U AS=21875000000P
+ AD=16800000000P PS=460000U PD=380000U
* device instance $7013 r0 *1 43.44,21.21 nfet_01v8
M$7013 2406 142 62 167 nfet_01v8 L=150000U W=140000U AS=16800000000P
+ AD=21875000000P PS=380000U PD=460000U
* device instance $7014 r0 *1 43.96,21.21 nfet_01v8
M$7014 1209 142 63 167 nfet_01v8 L=150000U W=140000U AS=16800000000P
+ AD=21875000000P PS=380000U PD=460000U
* device instance $7015 r0 *1 43.405,21.61 nfet_01v8
M$7015 167 2823 2406 167 nfet_01v8 L=150000U W=210000U AS=21875000000P
+ AD=40400000000P PS=460000U PD=560000U
* device instance $7016 r0 *1 43.995,21.61 nfet_01v8
M$7016 167 1779 1209 167 nfet_01v8 L=150000U W=210000U AS=21875000000P
+ AD=40400000000P PS=460000U PD=560000U
* device instance $7017 r0 *1 43.405,22 nfet_01v8
M$7017 2823 2406 167 167 nfet_01v8 L=150000U W=210000U AS=40400000000P
+ AD=21875000000P PS=560000U PD=460000U
* device instance $7018 r0 *1 43.995,22 nfet_01v8
M$7018 1779 1209 167 167 nfet_01v8 L=150000U W=210000U AS=40400000000P
+ AD=21875000000P PS=560000U PD=460000U
* device instance $7019 r0 *1 43.44,22.4 nfet_01v8
M$7019 61 142 2823 167 nfet_01v8 L=150000U W=140000U AS=21875000000P
+ AD=16800000000P PS=460000U PD=380000U
* device instance $7020 r0 *1 43.96,22.4 nfet_01v8
M$7020 64 142 1779 167 nfet_01v8 L=150000U W=140000U AS=21875000000P
+ AD=16800000000P PS=460000U PD=380000U
* device instance $7021 r0 *1 43.44,22.79 nfet_01v8
M$7021 3292 143 61 167 nfet_01v8 L=150000U W=140000U AS=16800000000P
+ AD=21875000000P PS=380000U PD=460000U
* device instance $7022 r0 *1 43.96,22.79 nfet_01v8
M$7022 4527 143 64 167 nfet_01v8 L=150000U W=140000U AS=16800000000P
+ AD=21875000000P PS=380000U PD=460000U
* device instance $7023 r0 *1 43.405,23.19 nfet_01v8
M$7023 167 1982 3292 167 nfet_01v8 L=150000U W=210000U AS=21875000000P
+ AD=40400000000P PS=460000U PD=560000U
* device instance $7024 r0 *1 43.995,23.19 nfet_01v8
M$7024 167 678 4527 167 nfet_01v8 L=150000U W=210000U AS=21875000000P
+ AD=40400000000P PS=460000U PD=560000U
* device instance $7025 r0 *1 43.405,23.58 nfet_01v8
M$7025 1982 3292 167 167 nfet_01v8 L=150000U W=210000U AS=40400000000P
+ AD=21875000000P PS=560000U PD=460000U
* device instance $7026 r0 *1 43.995,23.58 nfet_01v8
M$7026 678 4527 167 167 nfet_01v8 L=150000U W=210000U AS=40400000000P
+ AD=21875000000P PS=560000U PD=460000U
* device instance $7027 r0 *1 43.44,23.98 nfet_01v8
M$7027 62 143 1982 167 nfet_01v8 L=150000U W=140000U AS=21875000000P
+ AD=16800000000P PS=460000U PD=380000U
* device instance $7028 r0 *1 43.96,23.98 nfet_01v8
M$7028 63 143 678 167 nfet_01v8 L=150000U W=140000U AS=21875000000P
+ AD=16800000000P PS=460000U PD=380000U
* device instance $7029 r0 *1 43.44,24.37 nfet_01v8
M$7029 3275 144 62 167 nfet_01v8 L=150000U W=140000U AS=16800000000P
+ AD=21875000000P PS=380000U PD=460000U
* device instance $7030 r0 *1 43.96,24.37 nfet_01v8
M$7030 661 144 63 167 nfet_01v8 L=150000U W=140000U AS=16800000000P
+ AD=21875000000P PS=380000U PD=460000U
* device instance $7031 r0 *1 43.405,24.77 nfet_01v8
M$7031 167 2218 3275 167 nfet_01v8 L=150000U W=210000U AS=21875000000P
+ AD=40400000000P PS=460000U PD=560000U
* device instance $7032 r0 *1 43.995,24.77 nfet_01v8
M$7032 167 845 661 167 nfet_01v8 L=150000U W=210000U AS=21875000000P
+ AD=40400000000P PS=460000U PD=560000U
* device instance $7033 r0 *1 43.405,25.16 nfet_01v8
M$7033 2218 3275 167 167 nfet_01v8 L=150000U W=210000U AS=40400000000P
+ AD=21875000000P PS=560000U PD=460000U
* device instance $7034 r0 *1 43.995,25.16 nfet_01v8
M$7034 845 661 167 167 nfet_01v8 L=150000U W=210000U AS=40400000000P
+ AD=21875000000P PS=560000U PD=460000U
* device instance $7035 r0 *1 43.44,25.56 nfet_01v8
M$7035 61 144 2218 167 nfet_01v8 L=150000U W=140000U AS=21875000000P
+ AD=16800000000P PS=460000U PD=380000U
* device instance $7036 r0 *1 43.96,25.56 nfet_01v8
M$7036 64 144 845 167 nfet_01v8 L=150000U W=140000U AS=21875000000P
+ AD=16800000000P PS=460000U PD=380000U
* device instance $7037 r0 *1 43.44,25.95 nfet_01v8
M$7037 2439 145 61 167 nfet_01v8 L=150000U W=140000U AS=16800000000P
+ AD=21875000000P PS=380000U PD=460000U
* device instance $7038 r0 *1 43.96,25.95 nfet_01v8
M$7038 1227 145 64 167 nfet_01v8 L=150000U W=140000U AS=16800000000P
+ AD=21875000000P PS=380000U PD=460000U
* device instance $7039 r0 *1 43.405,26.35 nfet_01v8
M$7039 167 2901 2439 167 nfet_01v8 L=150000U W=210000U AS=21875000000P
+ AD=40400000000P PS=460000U PD=560000U
* device instance $7040 r0 *1 43.995,26.35 nfet_01v8
M$7040 167 1798 1227 167 nfet_01v8 L=150000U W=210000U AS=21875000000P
+ AD=40400000000P PS=460000U PD=560000U
* device instance $7041 r0 *1 43.405,26.74 nfet_01v8
M$7041 2901 2439 167 167 nfet_01v8 L=150000U W=210000U AS=40400000000P
+ AD=21875000000P PS=560000U PD=460000U
* device instance $7042 r0 *1 43.995,26.74 nfet_01v8
M$7042 1798 1227 167 167 nfet_01v8 L=150000U W=210000U AS=40400000000P
+ AD=21875000000P PS=560000U PD=460000U
* device instance $7043 r0 *1 43.44,27.14 nfet_01v8
M$7043 62 145 2901 167 nfet_01v8 L=150000U W=140000U AS=21875000000P
+ AD=16800000000P PS=460000U PD=380000U
* device instance $7044 r0 *1 43.96,27.14 nfet_01v8
M$7044 63 145 1798 167 nfet_01v8 L=150000U W=140000U AS=21875000000P
+ AD=16800000000P PS=460000U PD=380000U
* device instance $7045 r0 *1 54.34,21.21 nfet_01v8
M$7045 3450 142 78 167 nfet_01v8 L=150000U W=140000U AS=16800000000P
+ AD=21875000000P PS=380000U PD=460000U
* device instance $7046 r0 *1 54.86,21.21 nfet_01v8
M$7046 1129 142 79 167 nfet_01v8 L=150000U W=140000U AS=16800000000P
+ AD=21875000000P PS=380000U PD=460000U
* device instance $7047 r0 *1 54.305,21.61 nfet_01v8
M$7047 167 2730 3450 167 nfet_01v8 L=150000U W=210000U AS=21875000000P
+ AD=40400000000P PS=460000U PD=560000U
* device instance $7048 r0 *1 54.895,21.61 nfet_01v8
M$7048 167 1684 1129 167 nfet_01v8 L=150000U W=210000U AS=21875000000P
+ AD=40400000000P PS=460000U PD=560000U
* device instance $7049 r0 *1 54.305,22 nfet_01v8
M$7049 2730 3450 167 167 nfet_01v8 L=150000U W=210000U AS=40400000000P
+ AD=21875000000P PS=560000U PD=460000U
* device instance $7050 r0 *1 54.895,22 nfet_01v8
M$7050 1684 1129 167 167 nfet_01v8 L=150000U W=210000U AS=40400000000P
+ AD=21875000000P PS=560000U PD=460000U
* device instance $7051 r0 *1 54.34,22.4 nfet_01v8
M$7051 77 142 2730 167 nfet_01v8 L=150000U W=140000U AS=21875000000P
+ AD=16800000000P PS=460000U PD=380000U
* device instance $7052 r0 *1 54.86,22.4 nfet_01v8
M$7052 80 142 1684 167 nfet_01v8 L=150000U W=140000U AS=21875000000P
+ AD=16800000000P PS=460000U PD=380000U
* device instance $7053 r0 *1 54.34,22.79 nfet_01v8
M$7053 3447 143 77 167 nfet_01v8 L=150000U W=140000U AS=16800000000P
+ AD=21875000000P PS=380000U PD=460000U
* device instance $7054 r0 *1 54.86,22.79 nfet_01v8
M$7054 4380 143 80 167 nfet_01v8 L=150000U W=140000U AS=16800000000P
+ AD=21875000000P PS=380000U PD=460000U
* device instance $7055 r0 *1 54.305,23.19 nfet_01v8
M$7055 167 1984 3447 167 nfet_01v8 L=150000U W=210000U AS=21875000000P
+ AD=40400000000P PS=460000U PD=560000U
* device instance $7056 r0 *1 54.895,23.19 nfet_01v8
M$7056 167 810 4380 167 nfet_01v8 L=150000U W=210000U AS=21875000000P
+ AD=40400000000P PS=460000U PD=560000U
* device instance $7057 r0 *1 54.305,23.58 nfet_01v8
M$7057 1984 3447 167 167 nfet_01v8 L=150000U W=210000U AS=40400000000P
+ AD=21875000000P PS=560000U PD=460000U
* device instance $7058 r0 *1 54.895,23.58 nfet_01v8
M$7058 810 4380 167 167 nfet_01v8 L=150000U W=210000U AS=40400000000P
+ AD=21875000000P PS=560000U PD=460000U
* device instance $7059 r0 *1 54.34,23.98 nfet_01v8
M$7059 78 143 1984 167 nfet_01v8 L=150000U W=140000U AS=21875000000P
+ AD=16800000000P PS=460000U PD=380000U
* device instance $7060 r0 *1 54.86,23.98 nfet_01v8
M$7060 79 143 810 167 nfet_01v8 L=150000U W=140000U AS=21875000000P
+ AD=16800000000P PS=460000U PD=380000U
* device instance $7061 r0 *1 54.34,24.37 nfet_01v8
M$7061 2433 144 78 167 nfet_01v8 L=150000U W=140000U AS=16800000000P
+ AD=21875000000P PS=380000U PD=460000U
* device instance $7062 r0 *1 54.86,24.37 nfet_01v8
M$7062 1146 144 79 167 nfet_01v8 L=150000U W=140000U AS=16800000000P
+ AD=21875000000P PS=380000U PD=460000U
* device instance $7063 r0 *1 54.305,24.77 nfet_01v8
M$7063 167 2886 2433 167 nfet_01v8 L=150000U W=210000U AS=21875000000P
+ AD=40400000000P PS=460000U PD=560000U
* device instance $7064 r0 *1 54.895,24.77 nfet_01v8
M$7064 167 1703 1146 167 nfet_01v8 L=150000U W=210000U AS=21875000000P
+ AD=40400000000P PS=460000U PD=560000U
* device instance $7065 r0 *1 54.305,25.16 nfet_01v8
M$7065 2886 2433 167 167 nfet_01v8 L=150000U W=210000U AS=40400000000P
+ AD=21875000000P PS=560000U PD=460000U
* device instance $7066 r0 *1 54.895,25.16 nfet_01v8
M$7066 1703 1146 167 167 nfet_01v8 L=150000U W=210000U AS=40400000000P
+ AD=21875000000P PS=560000U PD=460000U
* device instance $7067 r0 *1 54.34,25.56 nfet_01v8
M$7067 77 144 2886 167 nfet_01v8 L=150000U W=140000U AS=21875000000P
+ AD=16800000000P PS=460000U PD=380000U
* device instance $7068 r0 *1 54.86,25.56 nfet_01v8
M$7068 80 144 1703 167 nfet_01v8 L=150000U W=140000U AS=21875000000P
+ AD=16800000000P PS=460000U PD=380000U
* device instance $7069 r0 *1 54.34,25.95 nfet_01v8
M$7069 3479 145 77 167 nfet_01v8 L=150000U W=140000U AS=16800000000P
+ AD=21875000000P PS=380000U PD=460000U
* device instance $7070 r0 *1 54.86,25.95 nfet_01v8
M$7070 1151 145 80 167 nfet_01v8 L=150000U W=140000U AS=16800000000P
+ AD=21875000000P PS=380000U PD=460000U
* device instance $7071 r0 *1 54.305,26.35 nfet_01v8
M$7071 167 2889 3479 167 nfet_01v8 L=150000U W=210000U AS=21875000000P
+ AD=40400000000P PS=460000U PD=560000U
* device instance $7072 r0 *1 54.895,26.35 nfet_01v8
M$7072 167 1709 1151 167 nfet_01v8 L=150000U W=210000U AS=21875000000P
+ AD=40400000000P PS=460000U PD=560000U
* device instance $7073 r0 *1 54.305,26.74 nfet_01v8
M$7073 2889 3479 167 167 nfet_01v8 L=150000U W=210000U AS=40400000000P
+ AD=21875000000P PS=560000U PD=460000U
* device instance $7074 r0 *1 54.895,26.74 nfet_01v8
M$7074 1709 1151 167 167 nfet_01v8 L=150000U W=210000U AS=40400000000P
+ AD=21875000000P PS=560000U PD=460000U
* device instance $7075 r0 *1 54.34,27.14 nfet_01v8
M$7075 78 145 2889 167 nfet_01v8 L=150000U W=140000U AS=21875000000P
+ AD=16800000000P PS=460000U PD=380000U
* device instance $7076 r0 *1 54.86,27.14 nfet_01v8
M$7076 79 145 1709 167 nfet_01v8 L=150000U W=140000U AS=21875000000P
+ AD=16800000000P PS=460000U PD=380000U
* device instance $7077 r0 *1 65.24,21.21 nfet_01v8
M$7077 3457 142 94 167 nfet_01v8 L=150000U W=140000U AS=16800000000P
+ AD=21875000000P PS=380000U PD=460000U
* device instance $7078 r0 *1 65.76,21.21 nfet_01v8
M$7078 1168 142 95 167 nfet_01v8 L=150000U W=140000U AS=16800000000P
+ AD=21875000000P PS=380000U PD=460000U
* device instance $7079 r0 *1 65.205,21.61 nfet_01v8
M$7079 167 2696 3457 167 nfet_01v8 L=150000U W=210000U AS=21875000000P
+ AD=40400000000P PS=460000U PD=560000U
* device instance $7080 r0 *1 65.795,21.61 nfet_01v8
M$7080 167 1730 1168 167 nfet_01v8 L=150000U W=210000U AS=21875000000P
+ AD=40400000000P PS=460000U PD=560000U
* device instance $7081 r0 *1 65.205,22 nfet_01v8
M$7081 2696 3457 167 167 nfet_01v8 L=150000U W=210000U AS=40400000000P
+ AD=21875000000P PS=560000U PD=460000U
* device instance $7082 r0 *1 65.795,22 nfet_01v8
M$7082 1730 1168 167 167 nfet_01v8 L=150000U W=210000U AS=40400000000P
+ AD=21875000000P PS=560000U PD=460000U
* device instance $7083 r0 *1 65.24,22.4 nfet_01v8
M$7083 93 142 2696 167 nfet_01v8 L=150000U W=140000U AS=21875000000P
+ AD=16800000000P PS=460000U PD=380000U
* device instance $7084 r0 *1 65.76,22.4 nfet_01v8
M$7084 96 142 1730 167 nfet_01v8 L=150000U W=140000U AS=21875000000P
+ AD=16800000000P PS=460000U PD=380000U
* device instance $7085 r0 *1 65.24,22.79 nfet_01v8
M$7085 3458 143 93 167 nfet_01v8 L=150000U W=140000U AS=16800000000P
+ AD=21875000000P PS=380000U PD=460000U
* device instance $7086 r0 *1 65.76,22.79 nfet_01v8
M$7086 4383 143 96 167 nfet_01v8 L=150000U W=140000U AS=16800000000P
+ AD=21875000000P PS=380000U PD=460000U
* device instance $7087 r0 *1 65.205,23.19 nfet_01v8
M$7087 167 2717 3458 167 nfet_01v8 L=150000U W=210000U AS=21875000000P
+ AD=40400000000P PS=460000U PD=560000U
* device instance $7088 r0 *1 65.795,23.19 nfet_01v8
M$7088 167 1692 4383 167 nfet_01v8 L=150000U W=210000U AS=21875000000P
+ AD=40400000000P PS=460000U PD=560000U
* device instance $7089 r0 *1 65.205,23.58 nfet_01v8
M$7089 2717 3458 167 167 nfet_01v8 L=150000U W=210000U AS=40400000000P
+ AD=21875000000P PS=560000U PD=460000U
* device instance $7090 r0 *1 65.795,23.58 nfet_01v8
M$7090 1692 4383 167 167 nfet_01v8 L=150000U W=210000U AS=40400000000P
+ AD=21875000000P PS=560000U PD=460000U
* device instance $7091 r0 *1 65.24,23.98 nfet_01v8
M$7091 94 143 2717 167 nfet_01v8 L=150000U W=140000U AS=21875000000P
+ AD=16800000000P PS=460000U PD=380000U
* device instance $7092 r0 *1 65.76,23.98 nfet_01v8
M$7092 95 143 1692 167 nfet_01v8 L=150000U W=140000U AS=21875000000P
+ AD=16800000000P PS=460000U PD=380000U
* device instance $7093 r0 *1 65.24,24.37 nfet_01v8
M$7093 3451 144 94 167 nfet_01v8 L=150000U W=140000U AS=16800000000P
+ AD=21875000000P PS=380000U PD=460000U
* device instance $7094 r0 *1 65.76,24.37 nfet_01v8
M$7094 634 144 95 167 nfet_01v8 L=150000U W=140000U AS=16800000000P
+ AD=21875000000P PS=380000U PD=460000U
* device instance $7095 r0 *1 65.205,24.77 nfet_01v8
M$7095 167 2744 3451 167 nfet_01v8 L=150000U W=210000U AS=21875000000P
+ AD=40400000000P PS=460000U PD=560000U
* device instance $7096 r0 *1 65.795,24.77 nfet_01v8
M$7096 167 785 634 167 nfet_01v8 L=150000U W=210000U AS=21875000000P
+ AD=40400000000P PS=460000U PD=560000U
* device instance $7097 r0 *1 65.205,25.16 nfet_01v8
M$7097 2744 3451 167 167 nfet_01v8 L=150000U W=210000U AS=40400000000P
+ AD=21875000000P PS=560000U PD=460000U
* device instance $7098 r0 *1 65.795,25.16 nfet_01v8
M$7098 785 634 167 167 nfet_01v8 L=150000U W=210000U AS=40400000000P
+ AD=21875000000P PS=560000U PD=460000U
* device instance $7099 r0 *1 65.24,25.56 nfet_01v8
M$7099 93 144 2744 167 nfet_01v8 L=150000U W=140000U AS=21875000000P
+ AD=16800000000P PS=460000U PD=380000U
* device instance $7100 r0 *1 65.76,25.56 nfet_01v8
M$7100 96 144 785 167 nfet_01v8 L=150000U W=140000U AS=21875000000P
+ AD=16800000000P PS=460000U PD=380000U
* device instance $7101 r0 *1 65.24,25.95 nfet_01v8
M$7101 3452 145 93 167 nfet_01v8 L=150000U W=140000U AS=16800000000P
+ AD=21875000000P PS=380000U PD=460000U
* device instance $7102 r0 *1 65.76,25.95 nfet_01v8
M$7102 1134 145 96 167 nfet_01v8 L=150000U W=140000U AS=16800000000P
+ AD=21875000000P PS=380000U PD=460000U
* device instance $7103 r0 *1 65.205,26.35 nfet_01v8
M$7103 167 2745 3452 167 nfet_01v8 L=150000U W=210000U AS=21875000000P
+ AD=40400000000P PS=460000U PD=560000U
* device instance $7104 r0 *1 65.795,26.35 nfet_01v8
M$7104 167 1690 1134 167 nfet_01v8 L=150000U W=210000U AS=21875000000P
+ AD=40400000000P PS=460000U PD=560000U
* device instance $7105 r0 *1 65.205,26.74 nfet_01v8
M$7105 2745 3452 167 167 nfet_01v8 L=150000U W=210000U AS=40400000000P
+ AD=21875000000P PS=560000U PD=460000U
* device instance $7106 r0 *1 65.795,26.74 nfet_01v8
M$7106 1690 1134 167 167 nfet_01v8 L=150000U W=210000U AS=40400000000P
+ AD=21875000000P PS=560000U PD=460000U
* device instance $7107 r0 *1 65.24,27.14 nfet_01v8
M$7107 94 145 2745 167 nfet_01v8 L=150000U W=140000U AS=21875000000P
+ AD=16800000000P PS=460000U PD=380000U
* device instance $7108 r0 *1 65.76,27.14 nfet_01v8
M$7108 95 145 1690 167 nfet_01v8 L=150000U W=140000U AS=21875000000P
+ AD=16800000000P PS=460000U PD=380000U
* device instance $7109 r0 *1 76.14,21.21 nfet_01v8
M$7109 2426 142 110 167 nfet_01v8 L=150000U W=140000U AS=16800000000P
+ AD=21875000000P PS=380000U PD=460000U
* device instance $7110 r0 *1 76.66,21.21 nfet_01v8
M$7110 986 142 111 167 nfet_01v8 L=150000U W=140000U AS=16800000000P
+ AD=21875000000P PS=380000U PD=460000U
* device instance $7111 r0 *1 76.105,21.61 nfet_01v8
M$7111 167 2861 2426 167 nfet_01v8 L=150000U W=210000U AS=21875000000P
+ AD=40400000000P PS=460000U PD=560000U
* device instance $7112 r0 *1 76.695,21.61 nfet_01v8
M$7112 167 1519 986 167 nfet_01v8 L=150000U W=210000U AS=21875000000P
+ AD=40400000000P PS=460000U PD=560000U
* device instance $7113 r0 *1 76.105,22 nfet_01v8
M$7113 2861 2426 167 167 nfet_01v8 L=150000U W=210000U AS=40400000000P
+ AD=21875000000P PS=560000U PD=460000U
* device instance $7114 r0 *1 76.695,22 nfet_01v8
M$7114 1519 986 167 167 nfet_01v8 L=150000U W=210000U AS=40400000000P
+ AD=21875000000P PS=560000U PD=460000U
* device instance $7115 r0 *1 76.14,22.4 nfet_01v8
M$7115 109 142 2861 167 nfet_01v8 L=150000U W=140000U AS=21875000000P
+ AD=16800000000P PS=460000U PD=380000U
* device instance $7116 r0 *1 76.66,22.4 nfet_01v8
M$7116 112 142 1519 167 nfet_01v8 L=150000U W=140000U AS=21875000000P
+ AD=16800000000P PS=460000U PD=380000U
* device instance $7117 r0 *1 76.14,22.79 nfet_01v8
M$7117 3407 143 109 167 nfet_01v8 L=150000U W=140000U AS=16800000000P
+ AD=21875000000P PS=380000U PD=460000U
* device instance $7118 r0 *1 76.66,22.79 nfet_01v8
M$7118 4283 143 112 167 nfet_01v8 L=150000U W=140000U AS=16800000000P
+ AD=21875000000P PS=380000U PD=460000U
* device instance $7119 r0 *1 76.105,23.19 nfet_01v8
M$7119 167 2916 3407 167 nfet_01v8 L=150000U W=210000U AS=21875000000P
+ AD=40400000000P PS=460000U PD=560000U
* device instance $7120 r0 *1 76.695,23.19 nfet_01v8
M$7120 167 1475 4283 167 nfet_01v8 L=150000U W=210000U AS=21875000000P
+ AD=40400000000P PS=460000U PD=560000U
* device instance $7121 r0 *1 76.105,23.58 nfet_01v8
M$7121 2916 3407 167 167 nfet_01v8 L=150000U W=210000U AS=40400000000P
+ AD=21875000000P PS=560000U PD=460000U
* device instance $7122 r0 *1 76.695,23.58 nfet_01v8
M$7122 1475 4283 167 167 nfet_01v8 L=150000U W=210000U AS=40400000000P
+ AD=21875000000P PS=560000U PD=460000U
* device instance $7123 r0 *1 76.14,23.98 nfet_01v8
M$7123 110 143 2916 167 nfet_01v8 L=150000U W=140000U AS=21875000000P
+ AD=16800000000P PS=460000U PD=380000U
* device instance $7124 r0 *1 76.66,23.98 nfet_01v8
M$7124 111 143 1475 167 nfet_01v8 L=150000U W=140000U AS=21875000000P
+ AD=16800000000P PS=460000U PD=380000U
* device instance $7125 r0 *1 76.14,24.37 nfet_01v8
M$7125 2450 144 110 167 nfet_01v8 L=150000U W=140000U AS=16800000000P
+ AD=21875000000P PS=380000U PD=460000U
* device instance $7126 r0 *1 76.66,24.37 nfet_01v8
M$7126 950 144 111 167 nfet_01v8 L=150000U W=140000U AS=16800000000P
+ AD=21875000000P PS=380000U PD=460000U
* device instance $7127 r0 *1 76.105,24.77 nfet_01v8
M$7127 167 2919 2450 167 nfet_01v8 L=150000U W=210000U AS=21875000000P
+ AD=40400000000P PS=460000U PD=560000U
* device instance $7128 r0 *1 76.695,24.77 nfet_01v8
M$7128 167 1476 950 167 nfet_01v8 L=150000U W=210000U AS=21875000000P
+ AD=40400000000P PS=460000U PD=560000U
* device instance $7129 r0 *1 76.105,25.16 nfet_01v8
M$7129 2919 2450 167 167 nfet_01v8 L=150000U W=210000U AS=40400000000P
+ AD=21875000000P PS=560000U PD=460000U
* device instance $7130 r0 *1 76.695,25.16 nfet_01v8
M$7130 1476 950 167 167 nfet_01v8 L=150000U W=210000U AS=40400000000P
+ AD=21875000000P PS=560000U PD=460000U
* device instance $7131 r0 *1 76.14,25.56 nfet_01v8
M$7131 109 144 2919 167 nfet_01v8 L=150000U W=140000U AS=21875000000P
+ AD=16800000000P PS=460000U PD=380000U
* device instance $7132 r0 *1 76.66,25.56 nfet_01v8
M$7132 112 144 1476 167 nfet_01v8 L=150000U W=140000U AS=21875000000P
+ AD=16800000000P PS=460000U PD=380000U
* device instance $7133 r0 *1 76.14,25.95 nfet_01v8
M$7133 2447 145 109 167 nfet_01v8 L=150000U W=140000U AS=16800000000P
+ AD=21875000000P PS=380000U PD=460000U
* device instance $7134 r0 *1 76.66,25.95 nfet_01v8
M$7134 974 145 112 167 nfet_01v8 L=150000U W=140000U AS=16800000000P
+ AD=21875000000P PS=380000U PD=460000U
* device instance $7135 r0 *1 76.105,26.35 nfet_01v8
M$7135 167 2913 2447 167 nfet_01v8 L=150000U W=210000U AS=21875000000P
+ AD=40400000000P PS=460000U PD=560000U
* device instance $7136 r0 *1 76.695,26.35 nfet_01v8
M$7136 167 1504 974 167 nfet_01v8 L=150000U W=210000U AS=21875000000P
+ AD=40400000000P PS=460000U PD=560000U
* device instance $7137 r0 *1 76.105,26.74 nfet_01v8
M$7137 2913 2447 167 167 nfet_01v8 L=150000U W=210000U AS=40400000000P
+ AD=21875000000P PS=560000U PD=460000U
* device instance $7138 r0 *1 76.695,26.74 nfet_01v8
M$7138 1504 974 167 167 nfet_01v8 L=150000U W=210000U AS=40400000000P
+ AD=21875000000P PS=560000U PD=460000U
* device instance $7139 r0 *1 76.14,27.14 nfet_01v8
M$7139 110 145 2913 167 nfet_01v8 L=150000U W=140000U AS=21875000000P
+ AD=16800000000P PS=460000U PD=380000U
* device instance $7140 r0 *1 76.66,27.14 nfet_01v8
M$7140 111 145 1504 167 nfet_01v8 L=150000U W=140000U AS=21875000000P
+ AD=16800000000P PS=460000U PD=380000U
* device instance $7141 r0 *1 10.74,13.31 nfet_01v8
M$7141 3210 138 14 167 nfet_01v8 L=150000U W=140000U AS=16800000000P
+ AD=21875000000P PS=380000U PD=460000U
* device instance $7142 r0 *1 11.26,13.31 nfet_01v8
M$7142 1018 138 15 167 nfet_01v8 L=150000U W=140000U AS=16800000000P
+ AD=21875000000P PS=380000U PD=460000U
* device instance $7143 r0 *1 10.705,13.71 nfet_01v8
M$7143 167 3049 3210 167 nfet_01v8 L=150000U W=210000U AS=21875000000P
+ AD=40400000000P PS=460000U PD=560000U
* device instance $7144 r0 *1 11.295,13.71 nfet_01v8
M$7144 167 1553 1018 167 nfet_01v8 L=150000U W=210000U AS=21875000000P
+ AD=40400000000P PS=460000U PD=560000U
* device instance $7145 r0 *1 10.705,14.1 nfet_01v8
M$7145 3049 3210 167 167 nfet_01v8 L=150000U W=210000U AS=40400000000P
+ AD=21875000000P PS=560000U PD=460000U
* device instance $7146 r0 *1 11.295,14.1 nfet_01v8
M$7146 1553 1018 167 167 nfet_01v8 L=150000U W=210000U AS=40400000000P
+ AD=21875000000P PS=560000U PD=460000U
* device instance $7147 r0 *1 10.74,14.5 nfet_01v8
M$7147 13 138 3049 167 nfet_01v8 L=150000U W=140000U AS=21875000000P
+ AD=16800000000P PS=460000U PD=380000U
* device instance $7148 r0 *1 11.26,14.5 nfet_01v8
M$7148 16 138 1553 167 nfet_01v8 L=150000U W=140000U AS=21875000000P
+ AD=16800000000P PS=460000U PD=380000U
* device instance $7149 r0 *1 10.74,14.89 nfet_01v8
M$7149 3306 139 13 167 nfet_01v8 L=150000U W=140000U AS=16800000000P
+ AD=21875000000P PS=380000U PD=460000U
* device instance $7150 r0 *1 11.26,14.89 nfet_01v8
M$7150 4476 139 16 167 nfet_01v8 L=150000U W=140000U AS=16800000000P
+ AD=21875000000P PS=380000U PD=460000U
* device instance $7151 r0 *1 10.705,15.29 nfet_01v8
M$7151 167 2242 3306 167 nfet_01v8 L=150000U W=210000U AS=21875000000P
+ AD=40400000000P PS=460000U PD=560000U
* device instance $7152 r0 *1 11.295,15.29 nfet_01v8
M$7152 167 812 4476 167 nfet_01v8 L=150000U W=210000U AS=21875000000P
+ AD=40400000000P PS=460000U PD=560000U
* device instance $7153 r0 *1 10.705,15.68 nfet_01v8
M$7153 2242 3306 167 167 nfet_01v8 L=150000U W=210000U AS=40400000000P
+ AD=21875000000P PS=560000U PD=460000U
* device instance $7154 r0 *1 11.295,15.68 nfet_01v8
M$7154 812 4476 167 167 nfet_01v8 L=150000U W=210000U AS=40400000000P
+ AD=21875000000P PS=560000U PD=460000U
* device instance $7155 r0 *1 10.74,16.08 nfet_01v8
M$7155 14 139 2242 167 nfet_01v8 L=150000U W=140000U AS=21875000000P
+ AD=16800000000P PS=460000U PD=380000U
* device instance $7156 r0 *1 11.26,16.08 nfet_01v8
M$7156 15 139 812 167 nfet_01v8 L=150000U W=140000U AS=21875000000P
+ AD=16800000000P PS=460000U PD=380000U
* device instance $7157 r0 *1 10.74,16.47 nfet_01v8
M$7157 2117 140 14 167 nfet_01v8 L=150000U W=140000U AS=16800000000P
+ AD=21875000000P PS=380000U PD=460000U
* device instance $7158 r0 *1 11.26,16.47 nfet_01v8
M$7158 1326 140 15 167 nfet_01v8 L=150000U W=140000U AS=16800000000P
+ AD=21875000000P PS=380000U PD=460000U
* device instance $7159 r0 *1 10.705,16.87 nfet_01v8
M$7159 167 2241 2117 167 nfet_01v8 L=150000U W=210000U AS=21875000000P
+ AD=40400000000P PS=460000U PD=560000U
* device instance $7160 r0 *1 11.295,16.87 nfet_01v8
M$7160 167 1907 1326 167 nfet_01v8 L=150000U W=210000U AS=21875000000P
+ AD=40400000000P PS=460000U PD=560000U
* device instance $7161 r0 *1 10.705,17.26 nfet_01v8
M$7161 2241 2117 167 167 nfet_01v8 L=150000U W=210000U AS=40400000000P
+ AD=21875000000P PS=560000U PD=460000U
* device instance $7162 r0 *1 11.295,17.26 nfet_01v8
M$7162 1907 1326 167 167 nfet_01v8 L=150000U W=210000U AS=40400000000P
+ AD=21875000000P PS=560000U PD=460000U
* device instance $7163 r0 *1 10.74,17.66 nfet_01v8
M$7163 13 140 2241 167 nfet_01v8 L=150000U W=140000U AS=21875000000P
+ AD=16800000000P PS=460000U PD=380000U
* device instance $7164 r0 *1 11.26,17.66 nfet_01v8
M$7164 16 140 1907 167 nfet_01v8 L=150000U W=140000U AS=21875000000P
+ AD=16800000000P PS=460000U PD=380000U
* device instance $7165 r0 *1 10.74,18.05 nfet_01v8
M$7165 2368 141 13 167 nfet_01v8 L=150000U W=140000U AS=16800000000P
+ AD=21875000000P PS=380000U PD=460000U
* device instance $7166 r0 *1 11.26,18.05 nfet_01v8
M$7166 1328 141 16 167 nfet_01v8 L=150000U W=140000U AS=16800000000P
+ AD=21875000000P PS=380000U PD=460000U
* device instance $7167 r0 *1 10.705,18.45 nfet_01v8
M$7167 167 2762 2368 167 nfet_01v8 L=150000U W=210000U AS=21875000000P
+ AD=40400000000P PS=460000U PD=560000U
* device instance $7168 r0 *1 11.295,18.45 nfet_01v8
M$7168 167 1909 1328 167 nfet_01v8 L=150000U W=210000U AS=21875000000P
+ AD=40400000000P PS=460000U PD=560000U
* device instance $7169 r0 *1 10.705,18.84 nfet_01v8
M$7169 2762 2368 167 167 nfet_01v8 L=150000U W=210000U AS=40400000000P
+ AD=21875000000P PS=560000U PD=460000U
* device instance $7170 r0 *1 11.295,18.84 nfet_01v8
M$7170 1909 1328 167 167 nfet_01v8 L=150000U W=210000U AS=40400000000P
+ AD=21875000000P PS=560000U PD=460000U
* device instance $7171 r0 *1 10.74,19.24 nfet_01v8
M$7171 14 141 2762 167 nfet_01v8 L=150000U W=140000U AS=21875000000P
+ AD=16800000000P PS=460000U PD=380000U
* device instance $7172 r0 *1 11.26,19.24 nfet_01v8
M$7172 15 141 1909 167 nfet_01v8 L=150000U W=140000U AS=21875000000P
+ AD=16800000000P PS=460000U PD=380000U
* device instance $7173 r0 *1 87.04,21.21 nfet_01v8
M$7173 2402 142 126 167 nfet_01v8 L=150000U W=140000U AS=16800000000P
+ AD=21875000000P PS=380000U PD=460000U
* device instance $7174 r0 *1 87.56,21.21 nfet_01v8
M$7174 967 142 127 167 nfet_01v8 L=150000U W=140000U AS=16800000000P
+ AD=21875000000P PS=380000U PD=460000U
* device instance $7175 r0 *1 87.005,21.61 nfet_01v8
M$7175 167 2817 2402 167 nfet_01v8 L=150000U W=210000U AS=21875000000P
+ AD=40400000000P PS=460000U PD=560000U
* device instance $7176 r0 *1 87.595,21.61 nfet_01v8
M$7176 167 1497 967 167 nfet_01v8 L=150000U W=210000U AS=21875000000P
+ AD=40400000000P PS=460000U PD=560000U
* device instance $7177 r0 *1 87.005,22 nfet_01v8
M$7177 2817 2402 167 167 nfet_01v8 L=150000U W=210000U AS=40400000000P
+ AD=21875000000P PS=560000U PD=460000U
* device instance $7178 r0 *1 87.595,22 nfet_01v8
M$7178 1497 967 167 167 nfet_01v8 L=150000U W=210000U AS=40400000000P
+ AD=21875000000P PS=560000U PD=460000U
* device instance $7179 r0 *1 87.04,22.4 nfet_01v8
M$7179 125 142 2817 167 nfet_01v8 L=150000U W=140000U AS=21875000000P
+ AD=16800000000P PS=460000U PD=380000U
* device instance $7180 r0 *1 87.56,22.4 nfet_01v8
M$7180 128 142 1497 167 nfet_01v8 L=150000U W=140000U AS=21875000000P
+ AD=16800000000P PS=460000U PD=380000U
* device instance $7181 r0 *1 87.04,22.79 nfet_01v8
M$7181 3418 143 125 167 nfet_01v8 L=150000U W=140000U AS=16800000000P
+ AD=21875000000P PS=380000U PD=460000U
* device instance $7182 r0 *1 87.56,22.79 nfet_01v8
M$7182 4365 143 128 167 nfet_01v8 L=150000U W=140000U AS=16800000000P
+ AD=21875000000P PS=380000U PD=460000U
* device instance $7183 r0 *1 87.005,23.19 nfet_01v8
M$7183 167 2181 3418 167 nfet_01v8 L=150000U W=210000U AS=21875000000P
+ AD=40400000000P PS=460000U PD=560000U
* device instance $7184 r0 *1 87.595,23.19 nfet_01v8
M$7184 167 789 4365 167 nfet_01v8 L=150000U W=210000U AS=21875000000P
+ AD=40400000000P PS=460000U PD=560000U
* device instance $7185 r0 *1 87.005,23.58 nfet_01v8
M$7185 2181 3418 167 167 nfet_01v8 L=150000U W=210000U AS=40400000000P
+ AD=21875000000P PS=560000U PD=460000U
* device instance $7186 r0 *1 87.595,23.58 nfet_01v8
M$7186 789 4365 167 167 nfet_01v8 L=150000U W=210000U AS=40400000000P
+ AD=21875000000P PS=560000U PD=460000U
* device instance $7187 r0 *1 87.04,23.98 nfet_01v8
M$7187 126 143 2181 167 nfet_01v8 L=150000U W=140000U AS=21875000000P
+ AD=16800000000P PS=460000U PD=380000U
* device instance $7188 r0 *1 87.56,23.98 nfet_01v8
M$7188 127 143 789 167 nfet_01v8 L=150000U W=140000U AS=21875000000P
+ AD=16800000000P PS=460000U PD=380000U
* device instance $7189 r0 *1 87.04,24.37 nfet_01v8
M$7189 3409 144 126 167 nfet_01v8 L=150000U W=140000U AS=16800000000P
+ AD=21875000000P PS=380000U PD=460000U
* device instance $7190 r0 *1 87.56,24.37 nfet_01v8
M$7190 989 144 127 167 nfet_01v8 L=150000U W=140000U AS=16800000000P
+ AD=21875000000P PS=380000U PD=460000U
* device instance $7191 r0 *1 87.005,24.77 nfet_01v8
M$7191 167 2176 3409 167 nfet_01v8 L=150000U W=210000U AS=21875000000P
+ AD=40400000000P PS=460000U PD=560000U
* device instance $7192 r0 *1 87.595,24.77 nfet_01v8
M$7192 167 1524 989 167 nfet_01v8 L=150000U W=210000U AS=21875000000P
+ AD=40400000000P PS=460000U PD=560000U
* device instance $7193 r0 *1 87.005,25.16 nfet_01v8
M$7193 2176 3409 167 167 nfet_01v8 L=150000U W=210000U AS=40400000000P
+ AD=21875000000P PS=560000U PD=460000U
* device instance $7194 r0 *1 87.595,25.16 nfet_01v8
M$7194 1524 989 167 167 nfet_01v8 L=150000U W=210000U AS=40400000000P
+ AD=21875000000P PS=560000U PD=460000U
* device instance $7195 r0 *1 87.04,25.56 nfet_01v8
M$7195 125 144 2176 167 nfet_01v8 L=150000U W=140000U AS=21875000000P
+ AD=16800000000P PS=460000U PD=380000U
* device instance $7196 r0 *1 87.56,25.56 nfet_01v8
M$7196 128 144 1524 167 nfet_01v8 L=150000U W=140000U AS=21875000000P
+ AD=16800000000P PS=460000U PD=380000U
* device instance $7197 r0 *1 87.04,25.95 nfet_01v8
M$7197 3410 145 125 167 nfet_01v8 L=150000U W=140000U AS=16800000000P
+ AD=21875000000P PS=380000U PD=460000U
* device instance $7198 r0 *1 87.56,25.95 nfet_01v8
M$7198 990 145 128 167 nfet_01v8 L=150000U W=140000U AS=16800000000P
+ AD=21875000000P PS=380000U PD=460000U
* device instance $7199 r0 *1 87.005,26.35 nfet_01v8
M$7199 167 2842 3410 167 nfet_01v8 L=150000U W=210000U AS=21875000000P
+ AD=40400000000P PS=460000U PD=560000U
* device instance $7200 r0 *1 87.595,26.35 nfet_01v8
M$7200 167 1525 990 167 nfet_01v8 L=150000U W=210000U AS=21875000000P
+ AD=40400000000P PS=460000U PD=560000U
* device instance $7201 r0 *1 87.005,26.74 nfet_01v8
M$7201 2842 3410 167 167 nfet_01v8 L=150000U W=210000U AS=40400000000P
+ AD=21875000000P PS=560000U PD=460000U
* device instance $7202 r0 *1 87.595,26.74 nfet_01v8
M$7202 1525 990 167 167 nfet_01v8 L=150000U W=210000U AS=40400000000P
+ AD=21875000000P PS=560000U PD=460000U
* device instance $7203 r0 *1 87.04,27.14 nfet_01v8
M$7203 126 145 2842 167 nfet_01v8 L=150000U W=140000U AS=21875000000P
+ AD=16800000000P PS=460000U PD=380000U
* device instance $7204 r0 *1 87.56,27.14 nfet_01v8
M$7204 127 145 1525 167 nfet_01v8 L=150000U W=140000U AS=21875000000P
+ AD=16800000000P PS=460000U PD=380000U
* device instance $7205 r0 *1 34.94,60.71 nfet_01v8
M$7205 266 162 50 167 nfet_01v8 L=150000U W=140000U AS=16800000000P
+ AD=21875000000P PS=380000U PD=460000U
* device instance $7206 r0 *1 34.905,61.11 nfet_01v8
M$7206 167 398 266 167 nfet_01v8 L=150000U W=210000U AS=21875000000P
+ AD=51200000000P PS=460000U PD=775000U
* device instance $7207 r0 *1 34.905,61.5 nfet_01v8
M$7207 398 266 167 167 nfet_01v8 L=150000U W=210000U AS=51200000000P
+ AD=21875000000P PS=775000U PD=460000U
* device instance $7208 r0 *1 34.94,61.9 nfet_01v8
M$7208 49 162 398 167 nfet_01v8 L=150000U W=140000U AS=21875000000P
+ AD=16800000000P PS=460000U PD=380000U
* device instance $7209 r0 *1 34.94,62.29 nfet_01v8
M$7209 3545 163 49 167 nfet_01v8 L=150000U W=140000U AS=16800000000P
+ AD=21875000000P PS=380000U PD=460000U
* device instance $7210 r0 *1 34.905,62.69 nfet_01v8
M$7210 167 513 3545 167 nfet_01v8 L=150000U W=210000U AS=21875000000P
+ AD=51200000000P PS=460000U PD=775000U
* device instance $7211 r0 *1 34.905,63.08 nfet_01v8
M$7211 513 3545 167 167 nfet_01v8 L=150000U W=210000U AS=51200000000P
+ AD=21875000000P PS=775000U PD=460000U
* device instance $7212 r0 *1 34.94,63.48 nfet_01v8
M$7212 50 163 513 167 nfet_01v8 L=150000U W=140000U AS=21875000000P
+ AD=16800000000P PS=460000U PD=380000U
* device instance $7213 r0 *1 34.94,63.87 nfet_01v8
M$7213 238 164 50 167 nfet_01v8 L=150000U W=140000U AS=16800000000P
+ AD=21875000000P PS=380000U PD=460000U
* device instance $7214 r0 *1 34.905,64.27 nfet_01v8
M$7214 167 199 238 167 nfet_01v8 L=150000U W=210000U AS=21875000000P
+ AD=51200000000P PS=460000U PD=775000U
* device instance $7215 r0 *1 34.905,64.66 nfet_01v8
M$7215 199 238 167 167 nfet_01v8 L=150000U W=210000U AS=51200000000P
+ AD=21875000000P PS=775000U PD=460000U
* device instance $7216 r0 *1 34.94,65.06 nfet_01v8
M$7216 49 164 199 167 nfet_01v8 L=150000U W=140000U AS=21875000000P
+ AD=16800000000P PS=460000U PD=380000U
* device instance $7217 r0 *1 34.94,65.45 nfet_01v8
M$7217 287 165 49 167 nfet_01v8 L=150000U W=140000U AS=16800000000P
+ AD=21875000000P PS=380000U PD=460000U
* device instance $7218 r0 *1 34.905,65.85 nfet_01v8
M$7218 167 440 287 167 nfet_01v8 L=150000U W=210000U AS=21875000000P
+ AD=51200000000P PS=460000U PD=775000U
* device instance $7219 r0 *1 34.905,66.24 nfet_01v8
M$7219 440 287 167 167 nfet_01v8 L=150000U W=210000U AS=51200000000P
+ AD=21875000000P PS=775000U PD=460000U
* device instance $7220 r0 *1 34.94,66.64 nfet_01v8
M$7220 50 165 440 167 nfet_01v8 L=150000U W=140000U AS=21875000000P
+ AD=16800000000P PS=460000U PD=380000U
* device instance $7221 r0 *1 89.44,37.01 nfet_01v8
M$7221 337 150 130 167 nfet_01v8 L=150000U W=140000U AS=16800000000P
+ AD=21875000000P PS=380000U PD=460000U
* device instance $7222 r0 *1 89.405,37.41 nfet_01v8
M$7222 167 543 337 167 nfet_01v8 L=150000U W=210000U AS=21875000000P
+ AD=51200000000P PS=460000U PD=775000U
* device instance $7223 r0 *1 89.405,37.8 nfet_01v8
M$7223 543 337 167 167 nfet_01v8 L=150000U W=210000U AS=51200000000P
+ AD=21875000000P PS=775000U PD=460000U
* device instance $7224 r0 *1 89.44,38.2 nfet_01v8
M$7224 129 150 543 167 nfet_01v8 L=150000U W=140000U AS=21875000000P
+ AD=16800000000P PS=460000U PD=380000U
* device instance $7225 r0 *1 89.44,38.59 nfet_01v8
M$7225 3515 151 129 167 nfet_01v8 L=150000U W=140000U AS=16800000000P
+ AD=21875000000P PS=380000U PD=460000U
* device instance $7226 r0 *1 89.405,38.99 nfet_01v8
M$7226 167 224 3515 167 nfet_01v8 L=150000U W=210000U AS=21875000000P
+ AD=51200000000P PS=460000U PD=775000U
* device instance $7227 r0 *1 89.405,39.38 nfet_01v8
M$7227 224 3515 167 167 nfet_01v8 L=150000U W=210000U AS=51200000000P
+ AD=21875000000P PS=775000U PD=460000U
* device instance $7228 r0 *1 89.44,39.78 nfet_01v8
M$7228 130 151 224 167 nfet_01v8 L=150000U W=140000U AS=21875000000P
+ AD=16800000000P PS=460000U PD=380000U
* device instance $7229 r0 *1 89.44,40.17 nfet_01v8
M$7229 324 152 130 167 nfet_01v8 L=150000U W=140000U AS=16800000000P
+ AD=21875000000P PS=380000U PD=460000U
* device instance $7230 r0 *1 89.405,40.57 nfet_01v8
M$7230 167 518 324 167 nfet_01v8 L=150000U W=210000U AS=21875000000P
+ AD=51200000000P PS=460000U PD=775000U
* device instance $7231 r0 *1 89.405,40.96 nfet_01v8
M$7231 518 324 167 167 nfet_01v8 L=150000U W=210000U AS=51200000000P
+ AD=21875000000P PS=775000U PD=460000U
* device instance $7232 r0 *1 89.44,41.36 nfet_01v8
M$7232 129 152 518 167 nfet_01v8 L=150000U W=140000U AS=21875000000P
+ AD=16800000000P PS=460000U PD=380000U
* device instance $7233 r0 *1 89.44,41.75 nfet_01v8
M$7233 333 153 129 167 nfet_01v8 L=150000U W=140000U AS=16800000000P
+ AD=21875000000P PS=380000U PD=460000U
* device instance $7234 r0 *1 89.405,42.15 nfet_01v8
M$7234 167 535 333 167 nfet_01v8 L=150000U W=210000U AS=21875000000P
+ AD=51200000000P PS=460000U PD=775000U
* device instance $7235 r0 *1 89.405,42.54 nfet_01v8
M$7235 535 333 167 167 nfet_01v8 L=150000U W=210000U AS=51200000000P
+ AD=21875000000P PS=775000U PD=460000U
* device instance $7236 r0 *1 89.44,42.94 nfet_01v8
M$7236 130 153 535 167 nfet_01v8 L=150000U W=140000U AS=21875000000P
+ AD=16800000000P PS=460000U PD=380000U
* device instance $7237 r0 *1 78.54,37.01 nfet_01v8
M$7237 319 150 114 167 nfet_01v8 L=150000U W=140000U AS=16800000000P
+ AD=21875000000P PS=380000U PD=460000U
* device instance $7238 r0 *1 78.505,37.41 nfet_01v8
M$7238 167 505 319 167 nfet_01v8 L=150000U W=210000U AS=21875000000P
+ AD=51200000000P PS=460000U PD=775000U
* device instance $7239 r0 *1 78.505,37.8 nfet_01v8
M$7239 505 319 167 167 nfet_01v8 L=150000U W=210000U AS=51200000000P
+ AD=21875000000P PS=775000U PD=460000U
* device instance $7240 r0 *1 78.54,38.2 nfet_01v8
M$7240 113 150 505 167 nfet_01v8 L=150000U W=140000U AS=21875000000P
+ AD=16800000000P PS=460000U PD=380000U
* device instance $7241 r0 *1 78.54,38.59 nfet_01v8
M$7241 3509 151 113 167 nfet_01v8 L=150000U W=140000U AS=16800000000P
+ AD=21875000000P PS=380000U PD=460000U
* device instance $7242 r0 *1 78.505,38.99 nfet_01v8
M$7242 167 531 3509 167 nfet_01v8 L=150000U W=210000U AS=21875000000P
+ AD=51200000000P PS=460000U PD=775000U
* device instance $7243 r0 *1 78.505,39.38 nfet_01v8
M$7243 531 3509 167 167 nfet_01v8 L=150000U W=210000U AS=51200000000P
+ AD=21875000000P PS=775000U PD=460000U
* device instance $7244 r0 *1 78.54,39.78 nfet_01v8
M$7244 114 151 531 167 nfet_01v8 L=150000U W=140000U AS=21875000000P
+ AD=16800000000P PS=460000U PD=380000U
* device instance $7245 r0 *1 78.54,40.17 nfet_01v8
M$7245 269 152 114 167 nfet_01v8 L=150000U W=140000U AS=16800000000P
+ AD=21875000000P PS=380000U PD=460000U
* device instance $7246 r0 *1 78.505,40.57 nfet_01v8
M$7246 167 405 269 167 nfet_01v8 L=150000U W=210000U AS=21875000000P
+ AD=51200000000P PS=460000U PD=775000U
* device instance $7247 r0 *1 78.505,40.96 nfet_01v8
M$7247 405 269 167 167 nfet_01v8 L=150000U W=210000U AS=51200000000P
+ AD=21875000000P PS=775000U PD=460000U
* device instance $7248 r0 *1 78.54,41.36 nfet_01v8
M$7248 113 152 405 167 nfet_01v8 L=150000U W=140000U AS=21875000000P
+ AD=16800000000P PS=460000U PD=380000U
* device instance $7249 r0 *1 78.54,41.75 nfet_01v8
M$7249 3501 153 113 167 nfet_01v8 L=150000U W=140000U AS=16800000000P
+ AD=21875000000P PS=380000U PD=460000U
* device instance $7250 r0 *1 78.505,42.15 nfet_01v8
M$7250 167 390 3501 167 nfet_01v8 L=150000U W=210000U AS=21875000000P
+ AD=51200000000P PS=460000U PD=775000U
* device instance $7251 r0 *1 78.505,42.54 nfet_01v8
M$7251 390 3501 167 167 nfet_01v8 L=150000U W=210000U AS=51200000000P
+ AD=21875000000P PS=775000U PD=460000U
* device instance $7252 r0 *1 78.54,42.94 nfet_01v8
M$7252 114 153 390 167 nfet_01v8 L=150000U W=140000U AS=21875000000P
+ AD=16800000000P PS=460000U PD=380000U
* device instance $7253 r0 *1 67.64,37.01 nfet_01v8
M$7253 299 150 98 167 nfet_01v8 L=150000U W=140000U AS=16800000000P
+ AD=21875000000P PS=380000U PD=460000U
* device instance $7254 r0 *1 67.605,37.41 nfet_01v8
M$7254 167 463 299 167 nfet_01v8 L=150000U W=210000U AS=21875000000P
+ AD=51200000000P PS=460000U PD=775000U
* device instance $7255 r0 *1 67.605,37.8 nfet_01v8
M$7255 463 299 167 167 nfet_01v8 L=150000U W=210000U AS=51200000000P
+ AD=21875000000P PS=775000U PD=460000U
* device instance $7256 r0 *1 67.64,38.2 nfet_01v8
M$7256 97 150 463 167 nfet_01v8 L=150000U W=140000U AS=21875000000P
+ AD=16800000000P PS=460000U PD=380000U
* device instance $7257 r0 *1 67.64,38.59 nfet_01v8
M$7257 3618 151 97 167 nfet_01v8 L=150000U W=140000U AS=16800000000P
+ AD=21875000000P PS=380000U PD=460000U
* device instance $7258 r0 *1 67.605,38.99 nfet_01v8
M$7258 167 222 3618 167 nfet_01v8 L=150000U W=210000U AS=21875000000P
+ AD=51200000000P PS=460000U PD=775000U
* device instance $7259 r0 *1 67.605,39.38 nfet_01v8
M$7259 222 3618 167 167 nfet_01v8 L=150000U W=210000U AS=51200000000P
+ AD=21875000000P PS=775000U PD=460000U
* device instance $7260 r0 *1 67.64,39.78 nfet_01v8
M$7260 98 151 222 167 nfet_01v8 L=150000U W=140000U AS=21875000000P
+ AD=16800000000P PS=460000U PD=380000U
* device instance $7261 r0 *1 67.64,40.17 nfet_01v8
M$7261 3612 152 98 167 nfet_01v8 L=150000U W=140000U AS=16800000000P
+ AD=21875000000P PS=380000U PD=460000U
* device instance $7262 r0 *1 67.605,40.57 nfet_01v8
M$7262 167 210 3612 167 nfet_01v8 L=150000U W=210000U AS=21875000000P
+ AD=51200000000P PS=460000U PD=775000U
* device instance $7263 r0 *1 67.605,40.96 nfet_01v8
M$7263 210 3612 167 167 nfet_01v8 L=150000U W=210000U AS=51200000000P
+ AD=21875000000P PS=775000U PD=460000U
* device instance $7264 r0 *1 67.64,41.36 nfet_01v8
M$7264 97 152 210 167 nfet_01v8 L=150000U W=140000U AS=21875000000P
+ AD=16800000000P PS=460000U PD=380000U
* device instance $7265 r0 *1 67.64,41.75 nfet_01v8
M$7265 3614 153 97 167 nfet_01v8 L=150000U W=140000U AS=16800000000P
+ AD=21875000000P PS=380000U PD=460000U
* device instance $7266 r0 *1 67.605,42.15 nfet_01v8
M$7266 167 437 3614 167 nfet_01v8 L=150000U W=210000U AS=21875000000P
+ AD=51200000000P PS=460000U PD=775000U
* device instance $7267 r0 *1 67.605,42.54 nfet_01v8
M$7267 437 3614 167 167 nfet_01v8 L=150000U W=210000U AS=51200000000P
+ AD=21875000000P PS=775000U PD=460000U
* device instance $7268 r0 *1 67.64,42.94 nfet_01v8
M$7268 98 153 437 167 nfet_01v8 L=150000U W=140000U AS=21875000000P
+ AD=16800000000P PS=460000U PD=380000U
* device instance $7269 r0 *1 56.74,37.01 nfet_01v8
M$7269 3619 150 82 167 nfet_01v8 L=150000U W=140000U AS=16800000000P
+ AD=21875000000P PS=380000U PD=460000U
* device instance $7270 r0 *1 56.705,37.41 nfet_01v8
M$7270 167 388 3619 167 nfet_01v8 L=150000U W=210000U AS=21875000000P
+ AD=51200000000P PS=460000U PD=775000U
* device instance $7271 r0 *1 56.705,37.8 nfet_01v8
M$7271 388 3619 167 167 nfet_01v8 L=150000U W=210000U AS=51200000000P
+ AD=21875000000P PS=775000U PD=460000U
* device instance $7272 r0 *1 56.74,38.2 nfet_01v8
M$7272 81 150 388 167 nfet_01v8 L=150000U W=140000U AS=21875000000P
+ AD=16800000000P PS=460000U PD=380000U
* device instance $7273 r0 *1 56.74,38.59 nfet_01v8
M$7273 3609 151 81 167 nfet_01v8 L=150000U W=140000U AS=16800000000P
+ AD=21875000000P PS=380000U PD=460000U
* device instance $7274 r0 *1 56.705,38.99 nfet_01v8
M$7274 167 469 3609 167 nfet_01v8 L=150000U W=210000U AS=21875000000P
+ AD=51200000000P PS=460000U PD=775000U
* device instance $7275 r0 *1 56.705,39.38 nfet_01v8
M$7275 469 3609 167 167 nfet_01v8 L=150000U W=210000U AS=51200000000P
+ AD=21875000000P PS=775000U PD=460000U
* device instance $7276 r0 *1 56.74,39.78 nfet_01v8
M$7276 82 151 469 167 nfet_01v8 L=150000U W=140000U AS=21875000000P
+ AD=16800000000P PS=460000U PD=380000U
* device instance $7277 r0 *1 56.74,40.17 nfet_01v8
M$7277 244 152 82 167 nfet_01v8 L=150000U W=140000U AS=16800000000P
+ AD=21875000000P PS=380000U PD=460000U
* device instance $7278 r0 *1 56.705,40.57 nfet_01v8
M$7278 167 221 244 167 nfet_01v8 L=150000U W=210000U AS=21875000000P
+ AD=51200000000P PS=460000U PD=775000U
* device instance $7279 r0 *1 56.705,40.96 nfet_01v8
M$7279 221 244 167 167 nfet_01v8 L=150000U W=210000U AS=51200000000P
+ AD=21875000000P PS=775000U PD=460000U
* device instance $7280 r0 *1 56.74,41.36 nfet_01v8
M$7280 81 152 221 167 nfet_01v8 L=150000U W=140000U AS=21875000000P
+ AD=16800000000P PS=460000U PD=380000U
* device instance $7281 r0 *1 56.74,41.75 nfet_01v8
M$7281 3604 153 81 167 nfet_01v8 L=150000U W=140000U AS=16800000000P
+ AD=21875000000P PS=380000U PD=460000U
* device instance $7282 r0 *1 56.705,42.15 nfet_01v8
M$7282 167 385 3604 167 nfet_01v8 L=150000U W=210000U AS=21875000000P
+ AD=51200000000P PS=460000U PD=775000U
* device instance $7283 r0 *1 56.705,42.54 nfet_01v8
M$7283 385 3604 167 167 nfet_01v8 L=150000U W=210000U AS=51200000000P
+ AD=21875000000P PS=775000U PD=460000U
* device instance $7284 r0 *1 56.74,42.94 nfet_01v8
M$7284 82 153 385 167 nfet_01v8 L=150000U W=140000U AS=21875000000P
+ AD=16800000000P PS=460000U PD=380000U
* device instance $7285 r0 *1 78.54,60.71 nfet_01v8
M$7285 253 162 114 167 nfet_01v8 L=150000U W=140000U AS=16800000000P
+ AD=21875000000P PS=380000U PD=460000U
* device instance $7286 r0 *1 78.505,61.11 nfet_01v8
M$7286 167 371 253 167 nfet_01v8 L=150000U W=210000U AS=21875000000P
+ AD=51200000000P PS=460000U PD=775000U
* device instance $7287 r0 *1 78.505,61.5 nfet_01v8
M$7287 371 253 167 167 nfet_01v8 L=150000U W=210000U AS=51200000000P
+ AD=21875000000P PS=775000U PD=460000U
* device instance $7288 r0 *1 78.54,61.9 nfet_01v8
M$7288 113 162 371 167 nfet_01v8 L=150000U W=140000U AS=21875000000P
+ AD=16800000000P PS=460000U PD=380000U
* device instance $7289 r0 *1 78.54,62.29 nfet_01v8
M$7289 3159 163 113 167 nfet_01v8 L=150000U W=140000U AS=16800000000P
+ AD=21875000000P PS=380000U PD=460000U
* device instance $7290 r0 *1 78.505,62.69 nfet_01v8
M$7290 167 1975 3159 167 nfet_01v8 L=150000U W=210000U AS=21875000000P
+ AD=51200000000P PS=460000U PD=775000U
* device instance $7291 r0 *1 78.505,63.08 nfet_01v8
M$7291 1975 3159 167 167 nfet_01v8 L=150000U W=210000U AS=51200000000P
+ AD=21875000000P PS=775000U PD=460000U
* device instance $7292 r0 *1 78.54,63.48 nfet_01v8
M$7292 114 163 1975 167 nfet_01v8 L=150000U W=140000U AS=21875000000P
+ AD=16800000000P PS=460000U PD=380000U
* device instance $7293 r0 *1 78.54,63.87 nfet_01v8
M$7293 236 164 114 167 nfet_01v8 L=150000U W=140000U AS=16800000000P
+ AD=21875000000P PS=380000U PD=460000U
* device instance $7294 r0 *1 78.505,64.27 nfet_01v8
M$7294 167 191 236 167 nfet_01v8 L=150000U W=210000U AS=21875000000P
+ AD=51200000000P PS=460000U PD=775000U
* device instance $7295 r0 *1 78.505,64.66 nfet_01v8
M$7295 191 236 167 167 nfet_01v8 L=150000U W=210000U AS=51200000000P
+ AD=21875000000P PS=775000U PD=460000U
* device instance $7296 r0 *1 78.54,65.06 nfet_01v8
M$7296 113 164 191 167 nfet_01v8 L=150000U W=140000U AS=21875000000P
+ AD=16800000000P PS=460000U PD=380000U
* device instance $7297 r0 *1 78.54,65.45 nfet_01v8
M$7297 3166 165 113 167 nfet_01v8 L=150000U W=140000U AS=16800000000P
+ AD=21875000000P PS=380000U PD=460000U
* device instance $7298 r0 *1 78.505,65.85 nfet_01v8
M$7298 167 446 3166 167 nfet_01v8 L=150000U W=210000U AS=21875000000P
+ AD=51200000000P PS=460000U PD=775000U
* device instance $7299 r0 *1 78.505,66.24 nfet_01v8
M$7299 446 3166 167 167 nfet_01v8 L=150000U W=210000U AS=51200000000P
+ AD=21875000000P PS=775000U PD=460000U
* device instance $7300 r0 *1 78.54,66.64 nfet_01v8
M$7300 114 165 446 167 nfet_01v8 L=150000U W=140000U AS=21875000000P
+ AD=16800000000P PS=460000U PD=380000U
* device instance $7301 r0 *1 45.84,37.01 nfet_01v8
M$7301 3677 150 66 167 nfet_01v8 L=150000U W=140000U AS=16800000000P
+ AD=21875000000P PS=380000U PD=460000U
* device instance $7302 r0 *1 45.805,37.41 nfet_01v8
M$7302 167 578 3677 167 nfet_01v8 L=150000U W=210000U AS=21875000000P
+ AD=51200000000P PS=460000U PD=775000U
* device instance $7303 r0 *1 45.805,37.8 nfet_01v8
M$7303 578 3677 167 167 nfet_01v8 L=150000U W=210000U AS=51200000000P
+ AD=21875000000P PS=775000U PD=460000U
* device instance $7304 r0 *1 45.84,38.2 nfet_01v8
M$7304 65 150 578 167 nfet_01v8 L=150000U W=140000U AS=21875000000P
+ AD=16800000000P PS=460000U PD=380000U
* device instance $7305 r0 *1 45.84,38.59 nfet_01v8
M$7305 3676 151 65 167 nfet_01v8 L=150000U W=140000U AS=16800000000P
+ AD=21875000000P PS=380000U PD=460000U
* device instance $7306 r0 *1 45.805,38.99 nfet_01v8
M$7306 167 476 3676 167 nfet_01v8 L=150000U W=210000U AS=21875000000P
+ AD=51200000000P PS=460000U PD=775000U
* device instance $7307 r0 *1 45.805,39.38 nfet_01v8
M$7307 476 3676 167 167 nfet_01v8 L=150000U W=210000U AS=51200000000P
+ AD=21875000000P PS=775000U PD=460000U
* device instance $7308 r0 *1 45.84,39.78 nfet_01v8
M$7308 66 151 476 167 nfet_01v8 L=150000U W=140000U AS=21875000000P
+ AD=16800000000P PS=460000U PD=380000U
* device instance $7309 r0 *1 45.84,40.17 nfet_01v8
M$7309 227 152 66 167 nfet_01v8 L=150000U W=140000U AS=16800000000P
+ AD=21875000000P PS=380000U PD=460000U
* device instance $7310 r0 *1 45.805,40.57 nfet_01v8
M$7310 167 170 227 167 nfet_01v8 L=150000U W=210000U AS=21875000000P
+ AD=51200000000P PS=460000U PD=775000U
* device instance $7311 r0 *1 45.805,40.96 nfet_01v8
M$7311 170 227 167 167 nfet_01v8 L=150000U W=210000U AS=51200000000P
+ AD=21875000000P PS=775000U PD=460000U
* device instance $7312 r0 *1 45.84,41.36 nfet_01v8
M$7312 65 152 170 167 nfet_01v8 L=150000U W=140000U AS=21875000000P
+ AD=16800000000P PS=460000U PD=380000U
* device instance $7313 r0 *1 45.84,41.75 nfet_01v8
M$7313 315 153 65 167 nfet_01v8 L=150000U W=140000U AS=16800000000P
+ AD=21875000000P PS=380000U PD=460000U
* device instance $7314 r0 *1 45.805,42.15 nfet_01v8
M$7314 167 497 315 167 nfet_01v8 L=150000U W=210000U AS=21875000000P
+ AD=51200000000P PS=460000U PD=775000U
* device instance $7315 r0 *1 45.805,42.54 nfet_01v8
M$7315 497 315 167 167 nfet_01v8 L=150000U W=210000U AS=51200000000P
+ AD=21875000000P PS=775000U PD=460000U
* device instance $7316 r0 *1 45.84,42.94 nfet_01v8
M$7316 66 153 497 167 nfet_01v8 L=150000U W=140000U AS=21875000000P
+ AD=16800000000P PS=460000U PD=380000U
* device instance $7317 r0 *1 34.94,37.01 nfet_01v8
M$7317 3632 150 50 167 nfet_01v8 L=150000U W=140000U AS=16800000000P
+ AD=21875000000P PS=380000U PD=460000U
* device instance $7318 r0 *1 34.905,37.41 nfet_01v8
M$7318 167 517 3632 167 nfet_01v8 L=150000U W=210000U AS=21875000000P
+ AD=51200000000P PS=460000U PD=775000U
* device instance $7319 r0 *1 34.905,37.8 nfet_01v8
M$7319 517 3632 167 167 nfet_01v8 L=150000U W=210000U AS=51200000000P
+ AD=21875000000P PS=775000U PD=460000U
* device instance $7320 r0 *1 34.94,38.2 nfet_01v8
M$7320 49 150 517 167 nfet_01v8 L=150000U W=140000U AS=21875000000P
+ AD=16800000000P PS=460000U PD=380000U
* device instance $7321 r0 *1 34.94,38.59 nfet_01v8
M$7321 3631 151 49 167 nfet_01v8 L=150000U W=140000U AS=16800000000P
+ AD=21875000000P PS=380000U PD=460000U
* device instance $7322 r0 *1 34.905,38.99 nfet_01v8
M$7322 167 2055 3631 167 nfet_01v8 L=150000U W=210000U AS=21875000000P
+ AD=51200000000P PS=460000U PD=775000U
* device instance $7323 r0 *1 34.905,39.38 nfet_01v8
M$7323 2055 3631 167 167 nfet_01v8 L=150000U W=210000U AS=51200000000P
+ AD=21875000000P PS=775000U PD=460000U
* device instance $7324 r0 *1 34.94,39.78 nfet_01v8
M$7324 50 151 2055 167 nfet_01v8 L=150000U W=140000U AS=21875000000P
+ AD=16800000000P PS=460000U PD=380000U
* device instance $7325 r0 *1 34.94,40.17 nfet_01v8
M$7325 3628 152 50 167 nfet_01v8 L=150000U W=140000U AS=16800000000P
+ AD=21875000000P PS=380000U PD=460000U
* device instance $7326 r0 *1 34.905,40.57 nfet_01v8
M$7326 167 185 3628 167 nfet_01v8 L=150000U W=210000U AS=21875000000P
+ AD=51200000000P PS=460000U PD=775000U
* device instance $7327 r0 *1 34.905,40.96 nfet_01v8
M$7327 185 3628 167 167 nfet_01v8 L=150000U W=210000U AS=51200000000P
+ AD=21875000000P PS=775000U PD=460000U
* device instance $7328 r0 *1 34.94,41.36 nfet_01v8
M$7328 49 152 185 167 nfet_01v8 L=150000U W=140000U AS=21875000000P
+ AD=16800000000P PS=460000U PD=380000U
* device instance $7329 r0 *1 34.94,41.75 nfet_01v8
M$7329 313 153 49 167 nfet_01v8 L=150000U W=140000U AS=16800000000P
+ AD=21875000000P PS=380000U PD=460000U
* device instance $7330 r0 *1 34.905,42.15 nfet_01v8
M$7330 167 492 313 167 nfet_01v8 L=150000U W=210000U AS=21875000000P
+ AD=51200000000P PS=460000U PD=775000U
* device instance $7331 r0 *1 34.905,42.54 nfet_01v8
M$7331 492 313 167 167 nfet_01v8 L=150000U W=210000U AS=51200000000P
+ AD=21875000000P PS=775000U PD=460000U
* device instance $7332 r0 *1 34.94,42.94 nfet_01v8
M$7332 50 153 492 167 nfet_01v8 L=150000U W=140000U AS=21875000000P
+ AD=16800000000P PS=460000U PD=380000U
* device instance $7333 r0 *1 24.04,37.01 nfet_01v8
M$7333 322 150 34 167 nfet_01v8 L=150000U W=140000U AS=16800000000P
+ AD=21875000000P PS=380000U PD=460000U
* device instance $7334 r0 *1 24.005,37.41 nfet_01v8
M$7334 167 511 322 167 nfet_01v8 L=150000U W=210000U AS=21875000000P
+ AD=51200000000P PS=460000U PD=775000U
* device instance $7335 r0 *1 24.005,37.8 nfet_01v8
M$7335 511 322 167 167 nfet_01v8 L=150000U W=210000U AS=51200000000P
+ AD=21875000000P PS=775000U PD=460000U
* device instance $7336 r0 *1 24.04,38.2 nfet_01v8
M$7336 33 150 511 167 nfet_01v8 L=150000U W=140000U AS=21875000000P
+ AD=16800000000P PS=460000U PD=380000U
* device instance $7337 r0 *1 24.04,38.59 nfet_01v8
M$7337 3639 151 33 167 nfet_01v8 L=150000U W=140000U AS=16800000000P
+ AD=21875000000P PS=380000U PD=460000U
* device instance $7338 r0 *1 24.005,38.99 nfet_01v8
M$7338 167 509 3639 167 nfet_01v8 L=150000U W=210000U AS=21875000000P
+ AD=51200000000P PS=460000U PD=775000U
* device instance $7339 r0 *1 24.005,39.38 nfet_01v8
M$7339 509 3639 167 167 nfet_01v8 L=150000U W=210000U AS=51200000000P
+ AD=21875000000P PS=775000U PD=460000U
* device instance $7340 r0 *1 24.04,39.78 nfet_01v8
M$7340 34 151 509 167 nfet_01v8 L=150000U W=140000U AS=21875000000P
+ AD=16800000000P PS=460000U PD=380000U
* device instance $7341 r0 *1 24.04,40.17 nfet_01v8
M$7341 320 152 34 167 nfet_01v8 L=150000U W=140000U AS=16800000000P
+ AD=21875000000P PS=380000U PD=460000U
* device instance $7342 r0 *1 24.005,40.57 nfet_01v8
M$7342 167 506 320 167 nfet_01v8 L=150000U W=210000U AS=21875000000P
+ AD=51200000000P PS=460000U PD=775000U
* device instance $7343 r0 *1 24.005,40.96 nfet_01v8
M$7343 506 320 167 167 nfet_01v8 L=150000U W=210000U AS=51200000000P
+ AD=21875000000P PS=775000U PD=460000U
* device instance $7344 r0 *1 24.04,41.36 nfet_01v8
M$7344 33 152 506 167 nfet_01v8 L=150000U W=140000U AS=21875000000P
+ AD=16800000000P PS=460000U PD=380000U
* device instance $7345 r0 *1 24.04,41.75 nfet_01v8
M$7345 3635 153 33 167 nfet_01v8 L=150000U W=140000U AS=16800000000P
+ AD=21875000000P PS=380000U PD=460000U
* device instance $7346 r0 *1 24.005,42.15 nfet_01v8
M$7346 167 504 3635 167 nfet_01v8 L=150000U W=210000U AS=21875000000P
+ AD=51200000000P PS=460000U PD=775000U
* device instance $7347 r0 *1 24.005,42.54 nfet_01v8
M$7347 504 3635 167 167 nfet_01v8 L=150000U W=210000U AS=51200000000P
+ AD=21875000000P PS=775000U PD=460000U
* device instance $7348 r0 *1 24.04,42.94 nfet_01v8
M$7348 34 153 504 167 nfet_01v8 L=150000U W=140000U AS=21875000000P
+ AD=16800000000P PS=460000U PD=380000U
* device instance $7349 r0 *1 13.14,37.01 nfet_01v8
M$7349 350 150 18 167 nfet_01v8 L=150000U W=140000U AS=16800000000P
+ AD=21875000000P PS=380000U PD=460000U
* device instance $7350 r0 *1 13.105,37.41 nfet_01v8
M$7350 167 563 350 167 nfet_01v8 L=150000U W=210000U AS=21875000000P
+ AD=51200000000P PS=460000U PD=775000U
* device instance $7351 r0 *1 13.105,37.8 nfet_01v8
M$7351 563 350 167 167 nfet_01v8 L=150000U W=210000U AS=51200000000P
+ AD=21875000000P PS=775000U PD=460000U
* device instance $7352 r0 *1 13.14,38.2 nfet_01v8
M$7352 17 150 563 167 nfet_01v8 L=150000U W=140000U AS=21875000000P
+ AD=16800000000P PS=460000U PD=380000U
* device instance $7353 r0 *1 13.14,38.59 nfet_01v8
M$7353 3734 151 17 167 nfet_01v8 L=150000U W=140000U AS=16800000000P
+ AD=21875000000P PS=380000U PD=460000U
* device instance $7354 r0 *1 13.105,38.99 nfet_01v8
M$7354 167 2030 3734 167 nfet_01v8 L=150000U W=210000U AS=21875000000P
+ AD=51200000000P PS=460000U PD=775000U
* device instance $7355 r0 *1 13.105,39.38 nfet_01v8
M$7355 2030 3734 167 167 nfet_01v8 L=150000U W=210000U AS=51200000000P
+ AD=21875000000P PS=775000U PD=460000U
* device instance $7356 r0 *1 13.14,39.78 nfet_01v8
M$7356 18 151 2030 167 nfet_01v8 L=150000U W=140000U AS=21875000000P
+ AD=16800000000P PS=460000U PD=380000U
* device instance $7357 r0 *1 13.14,40.17 nfet_01v8
M$7357 232 152 18 167 nfet_01v8 L=150000U W=140000U AS=16800000000P
+ AD=21875000000P PS=380000U PD=460000U
* device instance $7358 r0 *1 13.105,40.57 nfet_01v8
M$7358 167 180 232 167 nfet_01v8 L=150000U W=210000U AS=21875000000P
+ AD=51200000000P PS=460000U PD=775000U
* device instance $7359 r0 *1 13.105,40.96 nfet_01v8
M$7359 180 232 167 167 nfet_01v8 L=150000U W=210000U AS=51200000000P
+ AD=21875000000P PS=775000U PD=460000U
* device instance $7360 r0 *1 13.14,41.36 nfet_01v8
M$7360 17 152 180 167 nfet_01v8 L=150000U W=140000U AS=21875000000P
+ AD=16800000000P PS=460000U PD=380000U
* device instance $7361 r0 *1 13.14,41.75 nfet_01v8
M$7361 3737 153 17 167 nfet_01v8 L=150000U W=140000U AS=16800000000P
+ AD=21875000000P PS=380000U PD=460000U
* device instance $7362 r0 *1 13.105,42.15 nfet_01v8
M$7362 167 551 3737 167 nfet_01v8 L=150000U W=210000U AS=21875000000P
+ AD=51200000000P PS=460000U PD=775000U
* device instance $7363 r0 *1 13.105,42.54 nfet_01v8
M$7363 551 3737 167 167 nfet_01v8 L=150000U W=210000U AS=51200000000P
+ AD=21875000000P PS=775000U PD=460000U
* device instance $7364 r0 *1 13.14,42.94 nfet_01v8
M$7364 18 153 551 167 nfet_01v8 L=150000U W=140000U AS=21875000000P
+ AD=16800000000P PS=460000U PD=380000U
* device instance $7365 r0 *1 45.84,60.71 nfet_01v8
M$7365 342 162 66 167 nfet_01v8 L=150000U W=140000U AS=16800000000P
+ AD=21875000000P PS=380000U PD=460000U
* device instance $7366 r0 *1 45.805,61.11 nfet_01v8
M$7366 167 549 342 167 nfet_01v8 L=150000U W=210000U AS=21875000000P
+ AD=51200000000P PS=460000U PD=775000U
* device instance $7367 r0 *1 45.805,61.5 nfet_01v8
M$7367 549 342 167 167 nfet_01v8 L=150000U W=210000U AS=51200000000P
+ AD=21875000000P PS=775000U PD=460000U
* device instance $7368 r0 *1 45.84,61.9 nfet_01v8
M$7368 65 162 549 167 nfet_01v8 L=150000U W=140000U AS=21875000000P
+ AD=16800000000P PS=460000U PD=380000U
* device instance $7369 r0 *1 45.84,62.29 nfet_01v8
M$7369 3522 163 65 167 nfet_01v8 L=150000U W=140000U AS=16800000000P
+ AD=21875000000P PS=380000U PD=460000U
* device instance $7370 r0 *1 45.805,62.69 nfet_01v8
M$7370 167 176 3522 167 nfet_01v8 L=150000U W=210000U AS=21875000000P
+ AD=51200000000P PS=460000U PD=775000U
* device instance $7371 r0 *1 45.805,63.08 nfet_01v8
M$7371 176 3522 167 167 nfet_01v8 L=150000U W=210000U AS=51200000000P
+ AD=21875000000P PS=775000U PD=460000U
* device instance $7372 r0 *1 45.84,63.48 nfet_01v8
M$7372 66 163 176 167 nfet_01v8 L=150000U W=140000U AS=21875000000P
+ AD=16800000000P PS=460000U PD=380000U
* device instance $7373 r0 *1 45.84,63.87 nfet_01v8
M$7373 3534 164 66 167 nfet_01v8 L=150000U W=140000U AS=16800000000P
+ AD=21875000000P PS=380000U PD=460000U
* device instance $7374 r0 *1 45.805,64.27 nfet_01v8
M$7374 167 402 3534 167 nfet_01v8 L=150000U W=210000U AS=21875000000P
+ AD=51200000000P PS=460000U PD=775000U
* device instance $7375 r0 *1 45.805,64.66 nfet_01v8
M$7375 402 3534 167 167 nfet_01v8 L=150000U W=210000U AS=51200000000P
+ AD=21875000000P PS=775000U PD=460000U
* device instance $7376 r0 *1 45.84,65.06 nfet_01v8
M$7376 65 164 402 167 nfet_01v8 L=150000U W=140000U AS=21875000000P
+ AD=16800000000P PS=460000U PD=380000U
* device instance $7377 r0 *1 45.84,65.45 nfet_01v8
M$7377 3537 165 65 167 nfet_01v8 L=150000U W=140000U AS=16800000000P
+ AD=21875000000P PS=380000U PD=460000U
* device instance $7378 r0 *1 45.805,65.85 nfet_01v8
M$7378 167 386 3537 167 nfet_01v8 L=150000U W=210000U AS=21875000000P
+ AD=51200000000P PS=460000U PD=775000U
* device instance $7379 r0 *1 45.805,66.24 nfet_01v8
M$7379 386 3537 167 167 nfet_01v8 L=150000U W=210000U AS=51200000000P
+ AD=21875000000P PS=775000U PD=460000U
* device instance $7380 r0 *1 45.84,66.64 nfet_01v8
M$7380 66 165 386 167 nfet_01v8 L=150000U W=140000U AS=21875000000P
+ AD=16800000000P PS=460000U PD=380000U
* device instance $7381 r0 *1 89.44,44.91 nfet_01v8
M$7381 284 154 130 167 nfet_01v8 L=150000U W=140000U AS=16800000000P
+ AD=21875000000P PS=380000U PD=460000U
* device instance $7382 r0 *1 89.405,45.31 nfet_01v8
M$7382 167 432 284 167 nfet_01v8 L=150000U W=210000U AS=21875000000P
+ AD=51200000000P PS=460000U PD=775000U
* device instance $7383 r0 *1 89.405,45.7 nfet_01v8
M$7383 432 284 167 167 nfet_01v8 L=150000U W=210000U AS=51200000000P
+ AD=21875000000P PS=775000U PD=460000U
* device instance $7384 r0 *1 89.44,46.1 nfet_01v8
M$7384 129 154 432 167 nfet_01v8 L=150000U W=140000U AS=21875000000P
+ AD=16800000000P PS=460000U PD=380000U
* device instance $7385 r0 *1 89.44,46.49 nfet_01v8
M$7385 3592 155 129 167 nfet_01v8 L=150000U W=140000U AS=16800000000P
+ AD=21875000000P PS=380000U PD=460000U
* device instance $7386 r0 *1 89.405,46.89 nfet_01v8
M$7386 167 434 3592 167 nfet_01v8 L=150000U W=210000U AS=21875000000P
+ AD=51200000000P PS=460000U PD=775000U
* device instance $7387 r0 *1 89.405,47.28 nfet_01v8
M$7387 434 3592 167 167 nfet_01v8 L=150000U W=210000U AS=51200000000P
+ AD=21875000000P PS=775000U PD=460000U
* device instance $7388 r0 *1 89.44,47.68 nfet_01v8
M$7388 130 155 434 167 nfet_01v8 L=150000U W=140000U AS=21875000000P
+ AD=16800000000P PS=460000U PD=380000U
* device instance $7389 r0 *1 89.44,48.07 nfet_01v8
M$7389 229 156 130 167 nfet_01v8 L=150000U W=140000U AS=16800000000P
+ AD=21875000000P PS=380000U PD=460000U
* device instance $7390 r0 *1 89.405,48.47 nfet_01v8
M$7390 167 174 229 167 nfet_01v8 L=150000U W=210000U AS=21875000000P
+ AD=51200000000P PS=460000U PD=775000U
* device instance $7391 r0 *1 89.405,48.86 nfet_01v8
M$7391 174 229 167 167 nfet_01v8 L=150000U W=210000U AS=51200000000P
+ AD=21875000000P PS=775000U PD=460000U
* device instance $7392 r0 *1 89.44,49.26 nfet_01v8
M$7392 129 156 174 167 nfet_01v8 L=150000U W=140000U AS=21875000000P
+ AD=16800000000P PS=460000U PD=380000U
* device instance $7393 r0 *1 89.44,49.65 nfet_01v8
M$7393 3586 157 129 167 nfet_01v8 L=150000U W=140000U AS=16800000000P
+ AD=21875000000P PS=380000U PD=460000U
* device instance $7394 r0 *1 89.405,50.05 nfet_01v8
M$7394 167 451 3586 167 nfet_01v8 L=150000U W=210000U AS=21875000000P
+ AD=51200000000P PS=460000U PD=775000U
* device instance $7395 r0 *1 89.405,50.44 nfet_01v8
M$7395 451 3586 167 167 nfet_01v8 L=150000U W=210000U AS=51200000000P
+ AD=21875000000P PS=775000U PD=460000U
* device instance $7396 r0 *1 89.44,50.84 nfet_01v8
M$7396 130 157 451 167 nfet_01v8 L=150000U W=140000U AS=21875000000P
+ AD=16800000000P PS=460000U PD=380000U
* device instance $7397 r0 *1 78.54,44.91 nfet_01v8
M$7397 3600 154 114 167 nfet_01v8 L=150000U W=140000U AS=16800000000P
+ AD=21875000000P PS=380000U PD=460000U
* device instance $7398 r0 *1 78.505,45.31 nfet_01v8
M$7398 167 365 3600 167 nfet_01v8 L=150000U W=210000U AS=21875000000P
+ AD=51200000000P PS=460000U PD=775000U
* device instance $7399 r0 *1 78.505,45.7 nfet_01v8
M$7399 365 3600 167 167 nfet_01v8 L=150000U W=210000U AS=51200000000P
+ AD=21875000000P PS=775000U PD=460000U
* device instance $7400 r0 *1 78.54,46.1 nfet_01v8
M$7400 113 154 365 167 nfet_01v8 L=150000U W=140000U AS=21875000000P
+ AD=16800000000P PS=460000U PD=380000U
* device instance $7401 r0 *1 78.54,46.49 nfet_01v8
M$7401 3557 155 113 167 nfet_01v8 L=150000U W=140000U AS=16800000000P
+ AD=21875000000P PS=380000U PD=460000U
* device instance $7402 r0 *1 78.505,46.89 nfet_01v8
M$7402 167 181 3557 167 nfet_01v8 L=150000U W=210000U AS=21875000000P
+ AD=51200000000P PS=460000U PD=775000U
* device instance $7403 r0 *1 78.505,47.28 nfet_01v8
M$7403 181 3557 167 167 nfet_01v8 L=150000U W=210000U AS=51200000000P
+ AD=21875000000P PS=775000U PD=460000U
* device instance $7404 r0 *1 78.54,47.68 nfet_01v8
M$7404 114 155 181 167 nfet_01v8 L=150000U W=140000U AS=21875000000P
+ AD=16800000000P PS=460000U PD=380000U
* device instance $7405 r0 *1 78.54,48.07 nfet_01v8
M$7405 249 156 114 167 nfet_01v8 L=150000U W=140000U AS=16800000000P
+ AD=21875000000P PS=380000U PD=460000U
* device instance $7406 r0 *1 78.505,48.47 nfet_01v8
M$7406 167 364 249 167 nfet_01v8 L=150000U W=210000U AS=21875000000P
+ AD=51200000000P PS=460000U PD=775000U
* device instance $7407 r0 *1 78.505,48.86 nfet_01v8
M$7407 364 249 167 167 nfet_01v8 L=150000U W=210000U AS=51200000000P
+ AD=21875000000P PS=775000U PD=460000U
* device instance $7408 r0 *1 78.54,49.26 nfet_01v8
M$7408 113 156 364 167 nfet_01v8 L=150000U W=140000U AS=21875000000P
+ AD=16800000000P PS=460000U PD=380000U
* device instance $7409 r0 *1 78.54,49.65 nfet_01v8
M$7409 297 157 113 167 nfet_01v8 L=150000U W=140000U AS=16800000000P
+ AD=21875000000P PS=380000U PD=460000U
* device instance $7410 r0 *1 78.505,50.05 nfet_01v8
M$7410 167 460 297 167 nfet_01v8 L=150000U W=210000U AS=21875000000P
+ AD=51200000000P PS=460000U PD=775000U
* device instance $7411 r0 *1 78.505,50.44 nfet_01v8
M$7411 460 297 167 167 nfet_01v8 L=150000U W=210000U AS=51200000000P
+ AD=21875000000P PS=775000U PD=460000U
* device instance $7412 r0 *1 78.54,50.84 nfet_01v8
M$7412 114 157 460 167 nfet_01v8 L=150000U W=140000U AS=21875000000P
+ AD=16800000000P PS=460000U PD=380000U
* device instance $7413 r0 *1 24.04,52.81 nfet_01v8
M$7413 323 158 34 167 nfet_01v8 L=150000U W=140000U AS=16800000000P
+ AD=21875000000P PS=380000U PD=460000U
* device instance $7414 r0 *1 24.005,53.21 nfet_01v8
M$7414 167 512 323 167 nfet_01v8 L=150000U W=210000U AS=21875000000P
+ AD=51200000000P PS=460000U PD=775000U
* device instance $7415 r0 *1 24.005,53.6 nfet_01v8
M$7415 512 323 167 167 nfet_01v8 L=150000U W=210000U AS=51200000000P
+ AD=21875000000P PS=775000U PD=460000U
* device instance $7416 r0 *1 24.04,54 nfet_01v8
M$7416 33 158 512 167 nfet_01v8 L=150000U W=140000U AS=21875000000P
+ AD=16800000000P PS=460000U PD=380000U
* device instance $7417 r0 *1 24.04,54.39 nfet_01v8
M$7417 3695 159 33 167 nfet_01v8 L=150000U W=140000U AS=16800000000P
+ AD=21875000000P PS=380000U PD=460000U
* device instance $7418 r0 *1 24.005,54.79 nfet_01v8
M$7418 167 485 3695 167 nfet_01v8 L=150000U W=210000U AS=21875000000P
+ AD=51200000000P PS=460000U PD=775000U
* device instance $7419 r0 *1 24.005,55.18 nfet_01v8
M$7419 485 3695 167 167 nfet_01v8 L=150000U W=210000U AS=51200000000P
+ AD=21875000000P PS=775000U PD=460000U
* device instance $7420 r0 *1 24.04,55.58 nfet_01v8
M$7420 34 159 485 167 nfet_01v8 L=150000U W=140000U AS=21875000000P
+ AD=16800000000P PS=460000U PD=380000U
* device instance $7421 r0 *1 24.04,55.97 nfet_01v8
M$7421 3702 160 34 167 nfet_01v8 L=150000U W=140000U AS=16800000000P
+ AD=21875000000P PS=380000U PD=460000U
* device instance $7422 r0 *1 24.005,56.37 nfet_01v8
M$7422 167 200 3702 167 nfet_01v8 L=150000U W=210000U AS=21875000000P
+ AD=51200000000P PS=460000U PD=775000U
* device instance $7423 r0 *1 24.005,56.76 nfet_01v8
M$7423 200 3702 167 167 nfet_01v8 L=150000U W=210000U AS=51200000000P
+ AD=21875000000P PS=775000U PD=460000U
* device instance $7424 r0 *1 24.04,57.16 nfet_01v8
M$7424 33 160 200 167 nfet_01v8 L=150000U W=140000U AS=21875000000P
+ AD=16800000000P PS=460000U PD=380000U
* device instance $7425 r0 *1 24.04,57.55 nfet_01v8
M$7425 3698 161 33 167 nfet_01v8 L=150000U W=140000U AS=16800000000P
+ AD=21875000000P PS=380000U PD=460000U
* device instance $7426 r0 *1 24.005,57.95 nfet_01v8
M$7426 167 496 3698 167 nfet_01v8 L=150000U W=210000U AS=21875000000P
+ AD=51200000000P PS=460000U PD=775000U
* device instance $7427 r0 *1 24.005,58.34 nfet_01v8
M$7427 496 3698 167 167 nfet_01v8 L=150000U W=210000U AS=51200000000P
+ AD=21875000000P PS=775000U PD=460000U
* device instance $7428 r0 *1 24.04,58.74 nfet_01v8
M$7428 34 161 496 167 nfet_01v8 L=150000U W=140000U AS=21875000000P
+ AD=16800000000P PS=460000U PD=380000U
* device instance $7429 r0 *1 34.94,52.81 nfet_01v8
M$7429 349 158 50 167 nfet_01v8 L=150000U W=140000U AS=16800000000P
+ AD=21875000000P PS=380000U PD=460000U
* device instance $7430 r0 *1 34.905,53.21 nfet_01v8
M$7430 167 562 349 167 nfet_01v8 L=150000U W=210000U AS=21875000000P
+ AD=51200000000P PS=460000U PD=775000U
* device instance $7431 r0 *1 34.905,53.6 nfet_01v8
M$7431 562 349 167 167 nfet_01v8 L=150000U W=210000U AS=51200000000P
+ AD=21875000000P PS=775000U PD=460000U
* device instance $7432 r0 *1 34.94,54 nfet_01v8
M$7432 49 158 562 167 nfet_01v8 L=150000U W=140000U AS=21875000000P
+ AD=16800000000P PS=460000U PD=380000U
* device instance $7433 r0 *1 34.94,54.39 nfet_01v8
M$7433 3518 159 49 167 nfet_01v8 L=150000U W=140000U AS=16800000000P
+ AD=21875000000P PS=380000U PD=460000U
* device instance $7434 r0 *1 34.905,54.79 nfet_01v8
M$7434 167 435 3518 167 nfet_01v8 L=150000U W=210000U AS=21875000000P
+ AD=51200000000P PS=460000U PD=775000U
* device instance $7435 r0 *1 34.905,55.18 nfet_01v8
M$7435 435 3518 167 167 nfet_01v8 L=150000U W=210000U AS=51200000000P
+ AD=21875000000P PS=775000U PD=460000U
* device instance $7436 r0 *1 34.94,55.58 nfet_01v8
M$7436 50 159 435 167 nfet_01v8 L=150000U W=140000U AS=21875000000P
+ AD=16800000000P PS=460000U PD=380000U
* device instance $7437 r0 *1 34.94,55.97 nfet_01v8
M$7437 237 160 50 167 nfet_01v8 L=150000U W=140000U AS=16800000000P
+ AD=21875000000P PS=380000U PD=460000U
* device instance $7438 r0 *1 34.905,56.37 nfet_01v8
M$7438 167 193 237 167 nfet_01v8 L=150000U W=210000U AS=21875000000P
+ AD=51200000000P PS=460000U PD=775000U
* device instance $7439 r0 *1 34.905,56.76 nfet_01v8
M$7439 193 237 167 167 nfet_01v8 L=150000U W=210000U AS=51200000000P
+ AD=21875000000P PS=775000U PD=460000U
* device instance $7440 r0 *1 34.94,57.16 nfet_01v8
M$7440 49 160 193 167 nfet_01v8 L=150000U W=140000U AS=21875000000P
+ AD=16800000000P PS=460000U PD=380000U
* device instance $7441 r0 *1 34.94,57.55 nfet_01v8
M$7441 3550 161 49 167 nfet_01v8 L=150000U W=140000U AS=16800000000P
+ AD=21875000000P PS=380000U PD=460000U
* device instance $7442 r0 *1 34.905,57.95 nfet_01v8
M$7442 167 404 3550 167 nfet_01v8 L=150000U W=210000U AS=21875000000P
+ AD=51200000000P PS=460000U PD=775000U
* device instance $7443 r0 *1 34.905,58.34 nfet_01v8
M$7443 404 3550 167 167 nfet_01v8 L=150000U W=210000U AS=51200000000P
+ AD=21875000000P PS=775000U PD=460000U
* device instance $7444 r0 *1 34.94,58.74 nfet_01v8
M$7444 50 161 404 167 nfet_01v8 L=150000U W=140000U AS=21875000000P
+ AD=16800000000P PS=460000U PD=380000U
* device instance $7445 r0 *1 45.84,52.81 nfet_01v8
M$7445 339 158 66 167 nfet_01v8 L=150000U W=140000U AS=16800000000P
+ AD=21875000000P PS=380000U PD=460000U
* device instance $7446 r0 *1 45.805,53.21 nfet_01v8
M$7446 167 546 339 167 nfet_01v8 L=150000U W=210000U AS=21875000000P
+ AD=51200000000P PS=460000U PD=775000U
* device instance $7447 r0 *1 45.805,53.6 nfet_01v8
M$7447 546 339 167 167 nfet_01v8 L=150000U W=210000U AS=51200000000P
+ AD=21875000000P PS=775000U PD=460000U
* device instance $7448 r0 *1 45.84,54 nfet_01v8
M$7448 65 158 546 167 nfet_01v8 L=150000U W=140000U AS=21875000000P
+ AD=16800000000P PS=460000U PD=380000U
* device instance $7449 r0 *1 45.84,54.39 nfet_01v8
M$7449 3525 159 65 167 nfet_01v8 L=150000U W=140000U AS=16800000000P
+ AD=21875000000P PS=380000U PD=460000U
* device instance $7450 r0 *1 45.805,54.79 nfet_01v8
M$7450 167 515 3525 167 nfet_01v8 L=150000U W=210000U AS=21875000000P
+ AD=51200000000P PS=460000U PD=775000U
* device instance $7451 r0 *1 45.805,55.18 nfet_01v8
M$7451 515 3525 167 167 nfet_01v8 L=150000U W=210000U AS=51200000000P
+ AD=21875000000P PS=775000U PD=460000U
* device instance $7452 r0 *1 45.84,55.58 nfet_01v8
M$7452 66 159 515 167 nfet_01v8 L=150000U W=140000U AS=21875000000P
+ AD=16800000000P PS=460000U PD=380000U
* device instance $7453 r0 *1 45.84,55.97 nfet_01v8
M$7453 3526 160 66 167 nfet_01v8 L=150000U W=140000U AS=16800000000P
+ AD=21875000000P PS=380000U PD=460000U
* device instance $7454 r0 *1 45.805,56.37 nfet_01v8
M$7454 167 514 3526 167 nfet_01v8 L=150000U W=210000U AS=21875000000P
+ AD=51200000000P PS=460000U PD=775000U
* device instance $7455 r0 *1 45.805,56.76 nfet_01v8
M$7455 514 3526 167 167 nfet_01v8 L=150000U W=210000U AS=51200000000P
+ AD=21875000000P PS=775000U PD=460000U
* device instance $7456 r0 *1 45.84,57.16 nfet_01v8
M$7456 65 160 514 167 nfet_01v8 L=150000U W=140000U AS=21875000000P
+ AD=16800000000P PS=460000U PD=380000U
* device instance $7457 r0 *1 45.84,57.55 nfet_01v8
M$7457 262 161 65 167 nfet_01v8 L=150000U W=140000U AS=16800000000P
+ AD=21875000000P PS=380000U PD=460000U
* device instance $7458 r0 *1 45.805,57.95 nfet_01v8
M$7458 167 382 262 167 nfet_01v8 L=150000U W=210000U AS=21875000000P
+ AD=51200000000P PS=460000U PD=775000U
* device instance $7459 r0 *1 45.805,58.34 nfet_01v8
M$7459 382 262 167 167 nfet_01v8 L=150000U W=210000U AS=51200000000P
+ AD=21875000000P PS=775000U PD=460000U
* device instance $7460 r0 *1 45.84,58.74 nfet_01v8
M$7460 66 161 382 167 nfet_01v8 L=150000U W=140000U AS=21875000000P
+ AD=16800000000P PS=460000U PD=380000U
* device instance $7461 r0 *1 56.74,52.81 nfet_01v8
M$7461 334 158 82 167 nfet_01v8 L=150000U W=140000U AS=16800000000P
+ AD=21875000000P PS=380000U PD=460000U
* device instance $7462 r0 *1 56.705,53.21 nfet_01v8
M$7462 167 536 334 167 nfet_01v8 L=150000U W=210000U AS=21875000000P
+ AD=51200000000P PS=460000U PD=775000U
* device instance $7463 r0 *1 56.705,53.6 nfet_01v8
M$7463 536 334 167 167 nfet_01v8 L=150000U W=210000U AS=51200000000P
+ AD=21875000000P PS=775000U PD=460000U
* device instance $7464 r0 *1 56.74,54 nfet_01v8
M$7464 81 158 536 167 nfet_01v8 L=150000U W=140000U AS=21875000000P
+ AD=16800000000P PS=460000U PD=380000U
* device instance $7465 r0 *1 56.74,54.39 nfet_01v8
M$7465 3572 159 81 167 nfet_01v8 L=150000U W=140000U AS=16800000000P
+ AD=21875000000P PS=380000U PD=460000U
* device instance $7466 r0 *1 56.705,54.79 nfet_01v8
M$7466 167 2060 3572 167 nfet_01v8 L=150000U W=210000U AS=21875000000P
+ AD=51200000000P PS=460000U PD=775000U
* device instance $7467 r0 *1 56.705,55.18 nfet_01v8
M$7467 2060 3572 167 167 nfet_01v8 L=150000U W=210000U AS=51200000000P
+ AD=21875000000P PS=775000U PD=460000U
* device instance $7468 r0 *1 56.74,55.58 nfet_01v8
M$7468 82 159 2060 167 nfet_01v8 L=150000U W=140000U AS=21875000000P
+ AD=16800000000P PS=460000U PD=380000U
* device instance $7469 r0 *1 56.74,55.97 nfet_01v8
M$7469 3573 160 82 167 nfet_01v8 L=150000U W=140000U AS=16800000000P
+ AD=21875000000P PS=380000U PD=460000U
* device instance $7470 r0 *1 56.705,56.37 nfet_01v8
M$7470 167 192 3573 167 nfet_01v8 L=150000U W=210000U AS=21875000000P
+ AD=51200000000P PS=460000U PD=775000U
* device instance $7471 r0 *1 56.705,56.76 nfet_01v8
M$7471 192 3573 167 167 nfet_01v8 L=150000U W=210000U AS=51200000000P
+ AD=21875000000P PS=775000U PD=460000U
* device instance $7472 r0 *1 56.74,57.16 nfet_01v8
M$7472 81 160 192 167 nfet_01v8 L=150000U W=140000U AS=21875000000P
+ AD=16800000000P PS=460000U PD=380000U
* device instance $7473 r0 *1 56.74,57.55 nfet_01v8
M$7473 268 161 81 167 nfet_01v8 L=150000U W=140000U AS=16800000000P
+ AD=21875000000P PS=380000U PD=460000U
* device instance $7474 r0 *1 56.705,57.95 nfet_01v8
M$7474 167 403 268 167 nfet_01v8 L=150000U W=210000U AS=21875000000P
+ AD=51200000000P PS=460000U PD=775000U
* device instance $7475 r0 *1 56.705,58.34 nfet_01v8
M$7475 403 268 167 167 nfet_01v8 L=150000U W=210000U AS=51200000000P
+ AD=21875000000P PS=775000U PD=460000U
* device instance $7476 r0 *1 56.74,58.74 nfet_01v8
M$7476 82 161 403 167 nfet_01v8 L=150000U W=140000U AS=21875000000P
+ AD=16800000000P PS=460000U PD=380000U
* device instance $7477 r0 *1 67.64,52.81 nfet_01v8
M$7477 3142 158 98 167 nfet_01v8 L=150000U W=140000U AS=16800000000P
+ AD=21875000000P PS=380000U PD=460000U
* device instance $7478 r0 *1 67.605,53.21 nfet_01v8
M$7478 167 568 3142 167 nfet_01v8 L=150000U W=210000U AS=21875000000P
+ AD=51200000000P PS=460000U PD=775000U
* device instance $7479 r0 *1 67.605,53.6 nfet_01v8
M$7479 568 3142 167 167 nfet_01v8 L=150000U W=210000U AS=51200000000P
+ AD=21875000000P PS=775000U PD=460000U
* device instance $7480 r0 *1 67.64,54 nfet_01v8
M$7480 97 158 568 167 nfet_01v8 L=150000U W=140000U AS=21875000000P
+ AD=16800000000P PS=460000U PD=380000U
* device instance $7481 r0 *1 67.64,54.39 nfet_01v8
M$7481 3582 159 97 167 nfet_01v8 L=150000U W=140000U AS=16800000000P
+ AD=21875000000P PS=380000U PD=460000U
* device instance $7482 r0 *1 67.605,54.79 nfet_01v8
M$7482 167 2003 3582 167 nfet_01v8 L=150000U W=210000U AS=21875000000P
+ AD=51200000000P PS=460000U PD=775000U
* device instance $7483 r0 *1 67.605,55.18 nfet_01v8
M$7483 2003 3582 167 167 nfet_01v8 L=150000U W=210000U AS=51200000000P
+ AD=21875000000P PS=775000U PD=460000U
* device instance $7484 r0 *1 67.64,55.58 nfet_01v8
M$7484 98 159 2003 167 nfet_01v8 L=150000U W=140000U AS=21875000000P
+ AD=16800000000P PS=460000U PD=380000U
* device instance $7485 r0 *1 67.64,55.97 nfet_01v8
M$7485 240 160 98 167 nfet_01v8 L=150000U W=140000U AS=16800000000P
+ AD=21875000000P PS=380000U PD=460000U
* device instance $7486 r0 *1 67.605,56.37 nfet_01v8
M$7486 167 206 240 167 nfet_01v8 L=150000U W=210000U AS=21875000000P
+ AD=51200000000P PS=460000U PD=775000U
* device instance $7487 r0 *1 67.605,56.76 nfet_01v8
M$7487 206 240 167 167 nfet_01v8 L=150000U W=210000U AS=51200000000P
+ AD=21875000000P PS=775000U PD=460000U
* device instance $7488 r0 *1 67.64,57.16 nfet_01v8
M$7488 97 160 206 167 nfet_01v8 L=150000U W=140000U AS=21875000000P
+ AD=16800000000P PS=460000U PD=380000U
* device instance $7489 r0 *1 67.64,57.55 nfet_01v8
M$7489 3574 161 97 167 nfet_01v8 L=150000U W=140000U AS=16800000000P
+ AD=21875000000P PS=380000U PD=460000U
* device instance $7490 r0 *1 67.605,57.95 nfet_01v8
M$7490 167 537 3574 167 nfet_01v8 L=150000U W=210000U AS=21875000000P
+ AD=51200000000P PS=460000U PD=775000U
* device instance $7491 r0 *1 67.605,58.34 nfet_01v8
M$7491 537 3574 167 167 nfet_01v8 L=150000U W=210000U AS=51200000000P
+ AD=21875000000P PS=775000U PD=460000U
* device instance $7492 r0 *1 67.64,58.74 nfet_01v8
M$7492 98 161 537 167 nfet_01v8 L=150000U W=140000U AS=21875000000P
+ AD=16800000000P PS=460000U PD=380000U
* device instance $7493 r0 *1 13.14,52.81 nfet_01v8
M$7493 3488 158 18 167 nfet_01v8 L=150000U W=140000U AS=16800000000P
+ AD=21875000000P PS=380000U PD=460000U
* device instance $7494 r0 *1 13.105,53.21 nfet_01v8
M$7494 167 475 3488 167 nfet_01v8 L=150000U W=210000U AS=21875000000P
+ AD=51200000000P PS=460000U PD=775000U
* device instance $7495 r0 *1 13.105,53.6 nfet_01v8
M$7495 475 3488 167 167 nfet_01v8 L=150000U W=210000U AS=51200000000P
+ AD=21875000000P PS=775000U PD=460000U
* device instance $7496 r0 *1 13.14,54 nfet_01v8
M$7496 17 158 475 167 nfet_01v8 L=150000U W=140000U AS=21875000000P
+ AD=16800000000P PS=460000U PD=380000U
* device instance $7497 r0 *1 13.14,54.39 nfet_01v8
M$7497 3693 159 17 167 nfet_01v8 L=150000U W=140000U AS=16800000000P
+ AD=21875000000P PS=380000U PD=460000U
* device instance $7498 r0 *1 13.105,54.79 nfet_01v8
M$7498 167 212 3693 167 nfet_01v8 L=150000U W=210000U AS=21875000000P
+ AD=51200000000P PS=460000U PD=775000U
* device instance $7499 r0 *1 13.105,55.18 nfet_01v8
M$7499 212 3693 167 167 nfet_01v8 L=150000U W=210000U AS=51200000000P
+ AD=21875000000P PS=775000U PD=460000U
* device instance $7500 r0 *1 13.14,55.58 nfet_01v8
M$7500 18 159 212 167 nfet_01v8 L=150000U W=140000U AS=21875000000P
+ AD=16800000000P PS=460000U PD=380000U
* device instance $7501 r0 *1 13.14,55.97 nfet_01v8
M$7501 243 160 18 167 nfet_01v8 L=150000U W=140000U AS=16800000000P
+ AD=21875000000P PS=380000U PD=460000U
* device instance $7502 r0 *1 13.105,56.37 nfet_01v8
M$7502 167 211 243 167 nfet_01v8 L=150000U W=210000U AS=21875000000P
+ AD=51200000000P PS=460000U PD=775000U
* device instance $7503 r0 *1 13.105,56.76 nfet_01v8
M$7503 211 243 167 167 nfet_01v8 L=150000U W=210000U AS=51200000000P
+ AD=21875000000P PS=775000U PD=460000U
* device instance $7504 r0 *1 13.14,57.16 nfet_01v8
M$7504 17 160 211 167 nfet_01v8 L=150000U W=140000U AS=21875000000P
+ AD=16800000000P PS=460000U PD=380000U
* device instance $7505 r0 *1 13.14,57.55 nfet_01v8
M$7505 3688 161 17 167 nfet_01v8 L=150000U W=140000U AS=16800000000P
+ AD=21875000000P PS=380000U PD=460000U
* device instance $7506 r0 *1 13.105,57.95 nfet_01v8
M$7506 167 572 3688 167 nfet_01v8 L=150000U W=210000U AS=21875000000P
+ AD=51200000000P PS=460000U PD=775000U
* device instance $7507 r0 *1 13.105,58.34 nfet_01v8
M$7507 572 3688 167 167 nfet_01v8 L=150000U W=210000U AS=51200000000P
+ AD=21875000000P PS=775000U PD=460000U
* device instance $7508 r0 *1 13.14,58.74 nfet_01v8
M$7508 18 161 572 167 nfet_01v8 L=150000U W=140000U AS=21875000000P
+ AD=16800000000P PS=460000U PD=380000U
* device instance $7509 r0 *1 78.54,52.81 nfet_01v8
M$7509 332 158 114 167 nfet_01v8 L=150000U W=140000U AS=16800000000P
+ AD=21875000000P PS=380000U PD=460000U
* device instance $7510 r0 *1 78.505,53.21 nfet_01v8
M$7510 167 532 332 167 nfet_01v8 L=150000U W=210000U AS=21875000000P
+ AD=51200000000P PS=460000U PD=775000U
* device instance $7511 r0 *1 78.505,53.6 nfet_01v8
M$7511 532 332 167 167 nfet_01v8 L=150000U W=210000U AS=51200000000P
+ AD=21875000000P PS=775000U PD=460000U
* device instance $7512 r0 *1 78.54,54 nfet_01v8
M$7512 113 158 532 167 nfet_01v8 L=150000U W=140000U AS=21875000000P
+ AD=16800000000P PS=460000U PD=380000U
* device instance $7513 r0 *1 78.54,54.39 nfet_01v8
M$7513 3147 159 113 167 nfet_01v8 L=150000U W=140000U AS=16800000000P
+ AD=21875000000P PS=380000U PD=460000U
* device instance $7514 r0 *1 78.505,54.79 nfet_01v8
M$7514 167 526 3147 167 nfet_01v8 L=150000U W=210000U AS=21875000000P
+ AD=51200000000P PS=460000U PD=775000U
* device instance $7515 r0 *1 78.505,55.18 nfet_01v8
M$7515 526 3147 167 167 nfet_01v8 L=150000U W=210000U AS=51200000000P
+ AD=21875000000P PS=775000U PD=460000U
* device instance $7516 r0 *1 78.54,55.58 nfet_01v8
M$7516 114 159 526 167 nfet_01v8 L=150000U W=140000U AS=21875000000P
+ AD=16800000000P PS=460000U PD=380000U
* device instance $7517 r0 *1 78.54,55.97 nfet_01v8
M$7517 3139 160 114 167 nfet_01v8 L=150000U W=140000U AS=16800000000P
+ AD=21875000000P PS=380000U PD=460000U
* device instance $7518 r0 *1 78.505,56.37 nfet_01v8
M$7518 167 177 3139 167 nfet_01v8 L=150000U W=210000U AS=21875000000P
+ AD=51200000000P PS=460000U PD=775000U
* device instance $7519 r0 *1 78.505,56.76 nfet_01v8
M$7519 177 3139 167 167 nfet_01v8 L=150000U W=210000U AS=51200000000P
+ AD=21875000000P PS=775000U PD=460000U
* device instance $7520 r0 *1 78.54,57.16 nfet_01v8
M$7520 113 160 177 167 nfet_01v8 L=150000U W=140000U AS=21875000000P
+ AD=16800000000P PS=460000U PD=380000U
* device instance $7521 r0 *1 78.54,57.55 nfet_01v8
M$7521 3134 161 113 167 nfet_01v8 L=150000U W=140000U AS=16800000000P
+ AD=21875000000P PS=380000U PD=460000U
* device instance $7522 r0 *1 78.505,57.95 nfet_01v8
M$7522 167 392 3134 167 nfet_01v8 L=150000U W=210000U AS=21875000000P
+ AD=51200000000P PS=460000U PD=775000U
* device instance $7523 r0 *1 78.505,58.34 nfet_01v8
M$7523 392 3134 167 167 nfet_01v8 L=150000U W=210000U AS=51200000000P
+ AD=21875000000P PS=775000U PD=460000U
* device instance $7524 r0 *1 78.54,58.74 nfet_01v8
M$7524 114 161 392 167 nfet_01v8 L=150000U W=140000U AS=21875000000P
+ AD=16800000000P PS=460000U PD=380000U
* device instance $7525 r0 *1 67.64,44.91 nfet_01v8
M$7525 309 154 98 167 nfet_01v8 L=150000U W=140000U AS=16800000000P
+ AD=21875000000P PS=380000U PD=460000U
* device instance $7526 r0 *1 67.605,45.31 nfet_01v8
M$7526 167 488 309 167 nfet_01v8 L=150000U W=210000U AS=21875000000P
+ AD=51200000000P PS=460000U PD=775000U
* device instance $7527 r0 *1 67.605,45.7 nfet_01v8
M$7527 488 309 167 167 nfet_01v8 L=150000U W=210000U AS=51200000000P
+ AD=21875000000P PS=775000U PD=460000U
* device instance $7528 r0 *1 67.64,46.1 nfet_01v8
M$7528 97 154 488 167 nfet_01v8 L=150000U W=140000U AS=21875000000P
+ AD=16800000000P PS=460000U PD=380000U
* device instance $7529 r0 *1 67.64,46.49 nfet_01v8
M$7529 3555 155 97 167 nfet_01v8 L=150000U W=140000U AS=16800000000P
+ AD=21875000000P PS=380000U PD=460000U
* device instance $7530 r0 *1 67.605,46.89 nfet_01v8
M$7530 167 527 3555 167 nfet_01v8 L=150000U W=210000U AS=21875000000P
+ AD=51200000000P PS=460000U PD=775000U
* device instance $7531 r0 *1 67.605,47.28 nfet_01v8
M$7531 527 3555 167 167 nfet_01v8 L=150000U W=210000U AS=51200000000P
+ AD=21875000000P PS=775000U PD=460000U
* device instance $7532 r0 *1 67.64,47.68 nfet_01v8
M$7532 98 155 527 167 nfet_01v8 L=150000U W=140000U AS=21875000000P
+ AD=16800000000P PS=460000U PD=380000U
* device instance $7533 r0 *1 67.64,48.07 nfet_01v8
M$7533 327 156 98 167 nfet_01v8 L=150000U W=140000U AS=16800000000P
+ AD=21875000000P PS=380000U PD=460000U
* device instance $7534 r0 *1 67.605,48.47 nfet_01v8
M$7534 167 523 327 167 nfet_01v8 L=150000U W=210000U AS=21875000000P
+ AD=51200000000P PS=460000U PD=775000U
* device instance $7535 r0 *1 67.605,48.86 nfet_01v8
M$7535 523 327 167 167 nfet_01v8 L=150000U W=210000U AS=51200000000P
+ AD=21875000000P PS=775000U PD=460000U
* device instance $7536 r0 *1 67.64,49.26 nfet_01v8
M$7536 97 156 523 167 nfet_01v8 L=150000U W=140000U AS=21875000000P
+ AD=16800000000P PS=460000U PD=380000U
* device instance $7537 r0 *1 67.64,49.65 nfet_01v8
M$7537 3584 157 97 167 nfet_01v8 L=150000U W=140000U AS=16800000000P
+ AD=21875000000P PS=380000U PD=460000U
* device instance $7538 r0 *1 67.605,50.05 nfet_01v8
M$7538 167 479 3584 167 nfet_01v8 L=150000U W=210000U AS=21875000000P
+ AD=51200000000P PS=460000U PD=775000U
* device instance $7539 r0 *1 67.605,50.44 nfet_01v8
M$7539 479 3584 167 167 nfet_01v8 L=150000U W=210000U AS=51200000000P
+ AD=21875000000P PS=775000U PD=460000U
* device instance $7540 r0 *1 67.64,50.84 nfet_01v8
M$7540 98 157 479 167 nfet_01v8 L=150000U W=140000U AS=21875000000P
+ AD=16800000000P PS=460000U PD=380000U
* device instance $7541 r0 *1 13.14,29.11 nfet_01v8
M$7541 3270 146 18 167 nfet_01v8 L=150000U W=140000U AS=16800000000P
+ AD=21875000000P PS=380000U PD=460000U
* device instance $7542 r0 *1 13.105,29.51 nfet_01v8
M$7542 167 542 3270 167 nfet_01v8 L=150000U W=210000U AS=21875000000P
+ AD=51200000000P PS=460000U PD=775000U
* device instance $7543 r0 *1 13.105,29.9 nfet_01v8
M$7543 542 3270 167 167 nfet_01v8 L=150000U W=210000U AS=51200000000P
+ AD=21875000000P PS=775000U PD=460000U
* device instance $7544 r0 *1 13.14,30.3 nfet_01v8
M$7544 17 146 542 167 nfet_01v8 L=150000U W=140000U AS=21875000000P
+ AD=16800000000P PS=460000U PD=380000U
* device instance $7545 r0 *1 13.14,30.69 nfet_01v8
M$7545 3271 147 17 167 nfet_01v8 L=150000U W=140000U AS=16800000000P
+ AD=21875000000P PS=380000U PD=460000U
* device instance $7546 r0 *1 13.105,31.09 nfet_01v8
M$7546 167 190 3271 167 nfet_01v8 L=150000U W=210000U AS=21875000000P
+ AD=51200000000P PS=460000U PD=775000U
* device instance $7547 r0 *1 13.105,31.48 nfet_01v8
M$7547 190 3271 167 167 nfet_01v8 L=150000U W=210000U AS=51200000000P
+ AD=21875000000P PS=775000U PD=460000U
* device instance $7548 r0 *1 13.14,31.88 nfet_01v8
M$7548 18 147 190 167 nfet_01v8 L=150000U W=140000U AS=21875000000P
+ AD=16800000000P PS=460000U PD=380000U
* device instance $7549 r0 *1 13.14,32.27 nfet_01v8
M$7549 344 148 18 167 nfet_01v8 L=150000U W=140000U AS=16800000000P
+ AD=21875000000P PS=380000U PD=460000U
* device instance $7550 r0 *1 13.105,32.67 nfet_01v8
M$7550 167 553 344 167 nfet_01v8 L=150000U W=210000U AS=21875000000P
+ AD=51200000000P PS=460000U PD=775000U
* device instance $7551 r0 *1 13.105,33.06 nfet_01v8
M$7551 553 344 167 167 nfet_01v8 L=150000U W=210000U AS=51200000000P
+ AD=21875000000P PS=775000U PD=460000U
* device instance $7552 r0 *1 13.14,33.46 nfet_01v8
M$7552 17 148 553 167 nfet_01v8 L=150000U W=140000U AS=21875000000P
+ AD=16800000000P PS=460000U PD=380000U
* device instance $7553 r0 *1 13.14,33.85 nfet_01v8
M$7553 343 149 17 167 nfet_01v8 L=150000U W=140000U AS=16800000000P
+ AD=21875000000P PS=380000U PD=460000U
* device instance $7554 r0 *1 13.105,34.25 nfet_01v8
M$7554 167 550 343 167 nfet_01v8 L=150000U W=210000U AS=21875000000P
+ AD=51200000000P PS=460000U PD=775000U
* device instance $7555 r0 *1 13.105,34.64 nfet_01v8
M$7555 550 343 167 167 nfet_01v8 L=150000U W=210000U AS=51200000000P
+ AD=21875000000P PS=775000U PD=460000U
* device instance $7556 r0 *1 13.14,35.04 nfet_01v8
M$7556 18 149 550 167 nfet_01v8 L=150000U W=140000U AS=21875000000P
+ AD=16800000000P PS=460000U PD=380000U
* device instance $7557 r0 *1 56.74,60.71 nfet_01v8
M$7557 252 162 82 167 nfet_01v8 L=150000U W=140000U AS=16800000000P
+ AD=21875000000P PS=380000U PD=460000U
* device instance $7558 r0 *1 56.705,61.11 nfet_01v8
M$7558 167 369 252 167 nfet_01v8 L=150000U W=210000U AS=21875000000P
+ AD=51200000000P PS=460000U PD=775000U
* device instance $7559 r0 *1 56.705,61.5 nfet_01v8
M$7559 369 252 167 167 nfet_01v8 L=150000U W=210000U AS=51200000000P
+ AD=21875000000P PS=775000U PD=460000U
* device instance $7560 r0 *1 56.74,61.9 nfet_01v8
M$7560 81 162 369 167 nfet_01v8 L=150000U W=140000U AS=21875000000P
+ AD=16800000000P PS=460000U PD=380000U
* device instance $7561 r0 *1 56.74,62.29 nfet_01v8
M$7561 3151 163 81 167 nfet_01v8 L=150000U W=140000U AS=16800000000P
+ AD=21875000000P PS=380000U PD=460000U
* device instance $7562 r0 *1 56.705,62.69 nfet_01v8
M$7562 167 1999 3151 167 nfet_01v8 L=150000U W=210000U AS=21875000000P
+ AD=51200000000P PS=460000U PD=775000U
* device instance $7563 r0 *1 56.705,63.08 nfet_01v8
M$7563 1999 3151 167 167 nfet_01v8 L=150000U W=210000U AS=51200000000P
+ AD=21875000000P PS=775000U PD=460000U
* device instance $7564 r0 *1 56.74,63.48 nfet_01v8
M$7564 82 163 1999 167 nfet_01v8 L=150000U W=140000U AS=21875000000P
+ AD=16800000000P PS=460000U PD=380000U
* device instance $7565 r0 *1 56.74,63.87 nfet_01v8
M$7565 3180 164 82 167 nfet_01v8 L=150000U W=140000U AS=16800000000P
+ AD=21875000000P PS=380000U PD=460000U
* device instance $7566 r0 *1 56.705,64.27 nfet_01v8
M$7566 167 220 3180 167 nfet_01v8 L=150000U W=210000U AS=21875000000P
+ AD=51200000000P PS=460000U PD=775000U
* device instance $7567 r0 *1 56.705,64.66 nfet_01v8
M$7567 220 3180 167 167 nfet_01v8 L=150000U W=210000U AS=51200000000P
+ AD=21875000000P PS=775000U PD=460000U
* device instance $7568 r0 *1 56.74,65.06 nfet_01v8
M$7568 81 164 220 167 nfet_01v8 L=150000U W=140000U AS=21875000000P
+ AD=16800000000P PS=460000U PD=380000U
* device instance $7569 r0 *1 56.74,65.45 nfet_01v8
M$7569 311 165 81 167 nfet_01v8 L=150000U W=140000U AS=16800000000P
+ AD=21875000000P PS=380000U PD=460000U
* device instance $7570 r0 *1 56.705,65.85 nfet_01v8
M$7570 167 490 311 167 nfet_01v8 L=150000U W=210000U AS=21875000000P
+ AD=51200000000P PS=460000U PD=775000U
* device instance $7571 r0 *1 56.705,66.24 nfet_01v8
M$7571 490 311 167 167 nfet_01v8 L=150000U W=210000U AS=51200000000P
+ AD=21875000000P PS=775000U PD=460000U
* device instance $7572 r0 *1 56.74,66.64 nfet_01v8
M$7572 82 165 490 167 nfet_01v8 L=150000U W=140000U AS=21875000000P
+ AD=16800000000P PS=460000U PD=380000U
* device instance $7573 r0 *1 13.14,44.91 nfet_01v8
M$7573 335 154 18 167 nfet_01v8 L=150000U W=140000U AS=16800000000P
+ AD=21875000000P PS=380000U PD=460000U
* device instance $7574 r0 *1 13.105,45.31 nfet_01v8
M$7574 167 538 335 167 nfet_01v8 L=150000U W=210000U AS=21875000000P
+ AD=51200000000P PS=460000U PD=775000U
* device instance $7575 r0 *1 13.105,45.7 nfet_01v8
M$7575 538 335 167 167 nfet_01v8 L=150000U W=210000U AS=51200000000P
+ AD=21875000000P PS=775000U PD=460000U
* device instance $7576 r0 *1 13.14,46.1 nfet_01v8
M$7576 17 154 538 167 nfet_01v8 L=150000U W=140000U AS=21875000000P
+ AD=16800000000P PS=460000U PD=380000U
* device instance $7577 r0 *1 13.14,46.49 nfet_01v8
M$7577 3720 155 17 167 nfet_01v8 L=150000U W=140000U AS=16800000000P
+ AD=21875000000P PS=380000U PD=460000U
* device instance $7578 r0 *1 13.105,46.89 nfet_01v8
M$7578 167 567 3720 167 nfet_01v8 L=150000U W=210000U AS=21875000000P
+ AD=51200000000P PS=460000U PD=775000U
* device instance $7579 r0 *1 13.105,47.28 nfet_01v8
M$7579 567 3720 167 167 nfet_01v8 L=150000U W=210000U AS=51200000000P
+ AD=21875000000P PS=775000U PD=460000U
* device instance $7580 r0 *1 13.14,47.68 nfet_01v8
M$7580 18 155 567 167 nfet_01v8 L=150000U W=140000U AS=21875000000P
+ AD=16800000000P PS=460000U PD=380000U
* device instance $7581 r0 *1 13.14,48.07 nfet_01v8
M$7581 306 156 18 167 nfet_01v8 L=150000U W=140000U AS=16800000000P
+ AD=21875000000P PS=380000U PD=460000U
* device instance $7582 r0 *1 13.105,48.47 nfet_01v8
M$7582 167 480 306 167 nfet_01v8 L=150000U W=210000U AS=21875000000P
+ AD=51200000000P PS=460000U PD=775000U
* device instance $7583 r0 *1 13.105,48.86 nfet_01v8
M$7583 480 306 167 167 nfet_01v8 L=150000U W=210000U AS=51200000000P
+ AD=21875000000P PS=775000U PD=460000U
* device instance $7584 r0 *1 13.14,49.26 nfet_01v8
M$7584 17 156 480 167 nfet_01v8 L=150000U W=140000U AS=21875000000P
+ AD=16800000000P PS=460000U PD=380000U
* device instance $7585 r0 *1 13.14,49.65 nfet_01v8
M$7585 3755 157 17 167 nfet_01v8 L=150000U W=140000U AS=16800000000P
+ AD=21875000000P PS=380000U PD=460000U
* device instance $7586 r0 *1 13.105,50.05 nfet_01v8
M$7586 167 482 3755 167 nfet_01v8 L=150000U W=210000U AS=21875000000P
+ AD=51200000000P PS=460000U PD=775000U
* device instance $7587 r0 *1 13.105,50.44 nfet_01v8
M$7587 482 3755 167 167 nfet_01v8 L=150000U W=210000U AS=51200000000P
+ AD=21875000000P PS=775000U PD=460000U
* device instance $7588 r0 *1 13.14,50.84 nfet_01v8
M$7588 18 157 482 167 nfet_01v8 L=150000U W=140000U AS=21875000000P
+ AD=16800000000P PS=460000U PD=380000U
* device instance $7589 r0 *1 24.04,44.91 nfet_01v8
M$7589 3750 154 34 167 nfet_01v8 L=150000U W=140000U AS=16800000000P
+ AD=21875000000P PS=380000U PD=460000U
* device instance $7590 r0 *1 24.005,45.31 nfet_01v8
M$7590 167 579 3750 167 nfet_01v8 L=150000U W=210000U AS=21875000000P
+ AD=51200000000P PS=460000U PD=775000U
* device instance $7591 r0 *1 24.005,45.7 nfet_01v8
M$7591 579 3750 167 167 nfet_01v8 L=150000U W=210000U AS=51200000000P
+ AD=21875000000P PS=775000U PD=460000U
* device instance $7592 r0 *1 24.04,46.1 nfet_01v8
M$7592 33 154 579 167 nfet_01v8 L=150000U W=140000U AS=21875000000P
+ AD=16800000000P PS=460000U PD=380000U
* device instance $7593 r0 *1 24.04,46.49 nfet_01v8
M$7593 3751 155 33 167 nfet_01v8 L=150000U W=140000U AS=16800000000P
+ AD=21875000000P PS=380000U PD=460000U
* device instance $7594 r0 *1 24.005,46.89 nfet_01v8
M$7594 167 533 3751 167 nfet_01v8 L=150000U W=210000U AS=21875000000P
+ AD=51200000000P PS=460000U PD=775000U
* device instance $7595 r0 *1 24.005,47.28 nfet_01v8
M$7595 533 3751 167 167 nfet_01v8 L=150000U W=210000U AS=51200000000P
+ AD=21875000000P PS=775000U PD=460000U
* device instance $7596 r0 *1 24.04,47.68 nfet_01v8
M$7596 34 155 533 167 nfet_01v8 L=150000U W=140000U AS=21875000000P
+ AD=16800000000P PS=460000U PD=380000U
* device instance $7597 r0 *1 24.04,48.07 nfet_01v8
M$7597 3752 156 34 167 nfet_01v8 L=150000U W=140000U AS=16800000000P
+ AD=21875000000P PS=380000U PD=460000U
* device instance $7598 r0 *1 24.005,48.47 nfet_01v8
M$7598 167 486 3752 167 nfet_01v8 L=150000U W=210000U AS=21875000000P
+ AD=51200000000P PS=460000U PD=775000U
* device instance $7599 r0 *1 24.005,48.86 nfet_01v8
M$7599 486 3752 167 167 nfet_01v8 L=150000U W=210000U AS=51200000000P
+ AD=21875000000P PS=775000U PD=460000U
* device instance $7600 r0 *1 24.04,49.26 nfet_01v8
M$7600 33 156 486 167 nfet_01v8 L=150000U W=140000U AS=21875000000P
+ AD=16800000000P PS=460000U PD=380000U
* device instance $7601 r0 *1 24.04,49.65 nfet_01v8
M$7601 305 157 33 167 nfet_01v8 L=150000U W=140000U AS=16800000000P
+ AD=21875000000P PS=380000U PD=460000U
* device instance $7602 r0 *1 24.005,50.05 nfet_01v8
M$7602 167 477 305 167 nfet_01v8 L=150000U W=210000U AS=21875000000P
+ AD=51200000000P PS=460000U PD=775000U
* device instance $7603 r0 *1 24.005,50.44 nfet_01v8
M$7603 477 305 167 167 nfet_01v8 L=150000U W=210000U AS=51200000000P
+ AD=21875000000P PS=775000U PD=460000U
* device instance $7604 r0 *1 24.04,50.84 nfet_01v8
M$7604 34 157 477 167 nfet_01v8 L=150000U W=140000U AS=21875000000P
+ AD=16800000000P PS=460000U PD=380000U
* device instance $7605 r0 *1 34.94,44.91 nfet_01v8
M$7605 264 154 50 167 nfet_01v8 L=150000U W=140000U AS=16800000000P
+ AD=21875000000P PS=380000U PD=460000U
* device instance $7606 r0 *1 34.905,45.31 nfet_01v8
M$7606 167 391 264 167 nfet_01v8 L=150000U W=210000U AS=21875000000P
+ AD=51200000000P PS=460000U PD=775000U
* device instance $7607 r0 *1 34.905,45.7 nfet_01v8
M$7607 391 264 167 167 nfet_01v8 L=150000U W=210000U AS=51200000000P
+ AD=21875000000P PS=775000U PD=460000U
* device instance $7608 r0 *1 34.94,46.1 nfet_01v8
M$7608 49 154 391 167 nfet_01v8 L=150000U W=140000U AS=21875000000P
+ AD=16800000000P PS=460000U PD=380000U
* device instance $7609 r0 *1 34.94,46.49 nfet_01v8
M$7609 3624 155 49 167 nfet_01v8 L=150000U W=140000U AS=16800000000P
+ AD=21875000000P PS=380000U PD=460000U
* device instance $7610 r0 *1 34.905,46.89 nfet_01v8
M$7610 167 2065 3624 167 nfet_01v8 L=150000U W=210000U AS=21875000000P
+ AD=51200000000P PS=460000U PD=775000U
* device instance $7611 r0 *1 34.905,47.28 nfet_01v8
M$7611 2065 3624 167 167 nfet_01v8 L=150000U W=210000U AS=51200000000P
+ AD=21875000000P PS=775000U PD=460000U
* device instance $7612 r0 *1 34.94,47.68 nfet_01v8
M$7612 50 155 2065 167 nfet_01v8 L=150000U W=140000U AS=21875000000P
+ AD=16800000000P PS=460000U PD=380000U
* device instance $7613 r0 *1 34.94,48.07 nfet_01v8
M$7613 257 156 50 167 nfet_01v8 L=150000U W=140000U AS=16800000000P
+ AD=21875000000P PS=380000U PD=460000U
* device instance $7614 r0 *1 34.905,48.47 nfet_01v8
M$7614 167 377 257 167 nfet_01v8 L=150000U W=210000U AS=21875000000P
+ AD=51200000000P PS=460000U PD=775000U
* device instance $7615 r0 *1 34.905,48.86 nfet_01v8
M$7615 377 257 167 167 nfet_01v8 L=150000U W=210000U AS=51200000000P
+ AD=21875000000P PS=775000U PD=460000U
* device instance $7616 r0 *1 34.94,49.26 nfet_01v8
M$7616 49 156 377 167 nfet_01v8 L=150000U W=140000U AS=21875000000P
+ AD=16800000000P PS=460000U PD=380000U
* device instance $7617 r0 *1 34.94,49.65 nfet_01v8
M$7617 289 157 49 167 nfet_01v8 L=150000U W=140000U AS=16800000000P
+ AD=21875000000P PS=380000U PD=460000U
* device instance $7618 r0 *1 34.905,50.05 nfet_01v8
M$7618 167 443 289 167 nfet_01v8 L=150000U W=210000U AS=21875000000P
+ AD=51200000000P PS=460000U PD=775000U
* device instance $7619 r0 *1 34.905,50.44 nfet_01v8
M$7619 443 289 167 167 nfet_01v8 L=150000U W=210000U AS=51200000000P
+ AD=21875000000P PS=775000U PD=460000U
* device instance $7620 r0 *1 34.94,50.84 nfet_01v8
M$7620 50 157 443 167 nfet_01v8 L=150000U W=140000U AS=21875000000P
+ AD=16800000000P PS=460000U PD=380000U
* device instance $7621 r0 *1 45.84,44.91 nfet_01v8
M$7621 3646 154 66 167 nfet_01v8 L=150000U W=140000U AS=16800000000P
+ AD=21875000000P PS=380000U PD=460000U
* device instance $7622 r0 *1 45.805,45.31 nfet_01v8
M$7622 167 458 3646 167 nfet_01v8 L=150000U W=210000U AS=21875000000P
+ AD=51200000000P PS=460000U PD=775000U
* device instance $7623 r0 *1 45.805,45.7 nfet_01v8
M$7623 458 3646 167 167 nfet_01v8 L=150000U W=210000U AS=51200000000P
+ AD=21875000000P PS=775000U PD=460000U
* device instance $7624 r0 *1 45.84,46.1 nfet_01v8
M$7624 65 154 458 167 nfet_01v8 L=150000U W=140000U AS=21875000000P
+ AD=16800000000P PS=460000U PD=380000U
* device instance $7625 r0 *1 45.84,46.49 nfet_01v8
M$7625 3647 155 65 167 nfet_01v8 L=150000U W=140000U AS=16800000000P
+ AD=21875000000P PS=380000U PD=460000U
* device instance $7626 r0 *1 45.805,46.89 nfet_01v8
M$7626 167 195 3647 167 nfet_01v8 L=150000U W=210000U AS=21875000000P
+ AD=51200000000P PS=460000U PD=775000U
* device instance $7627 r0 *1 45.805,47.28 nfet_01v8
M$7627 195 3647 167 167 nfet_01v8 L=150000U W=210000U AS=51200000000P
+ AD=21875000000P PS=775000U PD=460000U
* device instance $7628 r0 *1 45.84,47.68 nfet_01v8
M$7628 66 155 195 167 nfet_01v8 L=150000U W=140000U AS=21875000000P
+ AD=16800000000P PS=460000U PD=380000U
* device instance $7629 r0 *1 45.84,48.07 nfet_01v8
M$7629 231 156 66 167 nfet_01v8 L=150000U W=140000U AS=16800000000P
+ AD=21875000000P PS=380000U PD=460000U
* device instance $7630 r0 *1 45.805,48.47 nfet_01v8
M$7630 167 179 231 167 nfet_01v8 L=150000U W=210000U AS=21875000000P
+ AD=51200000000P PS=460000U PD=775000U
* device instance $7631 r0 *1 45.805,48.86 nfet_01v8
M$7631 179 231 167 167 nfet_01v8 L=150000U W=210000U AS=51200000000P
+ AD=21875000000P PS=775000U PD=460000U
* device instance $7632 r0 *1 45.84,49.26 nfet_01v8
M$7632 65 156 179 167 nfet_01v8 L=150000U W=140000U AS=21875000000P
+ AD=16800000000P PS=460000U PD=380000U
* device instance $7633 r0 *1 45.84,49.65 nfet_01v8
M$7633 275 157 65 167 nfet_01v8 L=150000U W=140000U AS=16800000000P
+ AD=21875000000P PS=380000U PD=460000U
* device instance $7634 r0 *1 45.805,50.05 nfet_01v8
M$7634 167 416 275 167 nfet_01v8 L=150000U W=210000U AS=21875000000P
+ AD=51200000000P PS=460000U PD=775000U
* device instance $7635 r0 *1 45.805,50.44 nfet_01v8
M$7635 416 275 167 167 nfet_01v8 L=150000U W=210000U AS=51200000000P
+ AD=21875000000P PS=775000U PD=460000U
* device instance $7636 r0 *1 45.84,50.84 nfet_01v8
M$7636 66 157 416 167 nfet_01v8 L=150000U W=140000U AS=21875000000P
+ AD=16800000000P PS=460000U PD=380000U
* device instance $7637 r0 *1 56.74,44.91 nfet_01v8
M$7637 288 154 82 167 nfet_01v8 L=150000U W=140000U AS=16800000000P
+ AD=21875000000P PS=380000U PD=460000U
* device instance $7638 r0 *1 56.705,45.31 nfet_01v8
M$7638 167 442 288 167 nfet_01v8 L=150000U W=210000U AS=21875000000P
+ AD=51200000000P PS=460000U PD=775000U
* device instance $7639 r0 *1 56.705,45.7 nfet_01v8
M$7639 442 288 167 167 nfet_01v8 L=150000U W=210000U AS=51200000000P
+ AD=21875000000P PS=775000U PD=460000U
* device instance $7640 r0 *1 56.74,46.1 nfet_01v8
M$7640 81 154 442 167 nfet_01v8 L=150000U W=140000U AS=21875000000P
+ AD=16800000000P PS=460000U PD=380000U
* device instance $7641 r0 *1 56.74,46.49 nfet_01v8
M$7641 3562 155 81 167 nfet_01v8 L=150000U W=140000U AS=16800000000P
+ AD=21875000000P PS=380000U PD=460000U
* device instance $7642 r0 *1 56.705,46.89 nfet_01v8
M$7642 167 2043 3562 167 nfet_01v8 L=150000U W=210000U AS=21875000000P
+ AD=51200000000P PS=460000U PD=775000U
* device instance $7643 r0 *1 56.705,47.28 nfet_01v8
M$7643 2043 3562 167 167 nfet_01v8 L=150000U W=210000U AS=51200000000P
+ AD=21875000000P PS=775000U PD=460000U
* device instance $7644 r0 *1 56.74,47.68 nfet_01v8
M$7644 82 155 2043 167 nfet_01v8 L=150000U W=140000U AS=21875000000P
+ AD=16800000000P PS=460000U PD=380000U
* device instance $7645 r0 *1 56.74,48.07 nfet_01v8
M$7645 286 156 82 167 nfet_01v8 L=150000U W=140000U AS=16800000000P
+ AD=21875000000P PS=380000U PD=460000U
* device instance $7646 r0 *1 56.705,48.47 nfet_01v8
M$7646 167 439 286 167 nfet_01v8 L=150000U W=210000U AS=21875000000P
+ AD=51200000000P PS=460000U PD=775000U
* device instance $7647 r0 *1 56.705,48.86 nfet_01v8
M$7647 439 286 167 167 nfet_01v8 L=150000U W=210000U AS=51200000000P
+ AD=21875000000P PS=775000U PD=460000U
* device instance $7648 r0 *1 56.74,49.26 nfet_01v8
M$7648 81 156 439 167 nfet_01v8 L=150000U W=140000U AS=21875000000P
+ AD=16800000000P PS=460000U PD=380000U
* device instance $7649 r0 *1 56.74,49.65 nfet_01v8
M$7649 255 157 81 167 nfet_01v8 L=150000U W=140000U AS=16800000000P
+ AD=21875000000P PS=380000U PD=460000U
* device instance $7650 r0 *1 56.705,50.05 nfet_01v8
M$7650 167 373 255 167 nfet_01v8 L=150000U W=210000U AS=21875000000P
+ AD=51200000000P PS=460000U PD=775000U
* device instance $7651 r0 *1 56.705,50.44 nfet_01v8
M$7651 373 255 167 167 nfet_01v8 L=150000U W=210000U AS=51200000000P
+ AD=21875000000P PS=775000U PD=460000U
* device instance $7652 r0 *1 56.74,50.84 nfet_01v8
M$7652 82 157 373 167 nfet_01v8 L=150000U W=140000U AS=21875000000P
+ AD=16800000000P PS=460000U PD=380000U
* device instance $7653 r0 *1 67.64,60.71 nfet_01v8
M$7653 331 162 98 167 nfet_01v8 L=150000U W=140000U AS=16800000000P
+ AD=21875000000P PS=380000U PD=460000U
* device instance $7654 r0 *1 67.605,61.11 nfet_01v8
M$7654 167 530 331 167 nfet_01v8 L=150000U W=210000U AS=21875000000P
+ AD=51200000000P PS=460000U PD=775000U
* device instance $7655 r0 *1 67.605,61.5 nfet_01v8
M$7655 530 331 167 167 nfet_01v8 L=150000U W=210000U AS=51200000000P
+ AD=21875000000P PS=775000U PD=460000U
* device instance $7656 r0 *1 67.64,61.9 nfet_01v8
M$7656 97 162 530 167 nfet_01v8 L=150000U W=140000U AS=21875000000P
+ AD=16800000000P PS=460000U PD=380000U
* device instance $7657 r0 *1 67.64,62.29 nfet_01v8
M$7657 3148 163 97 167 nfet_01v8 L=150000U W=140000U AS=16800000000P
+ AD=21875000000P PS=380000U PD=460000U
* device instance $7658 r0 *1 67.605,62.69 nfet_01v8
M$7658 167 2014 3148 167 nfet_01v8 L=150000U W=210000U AS=21875000000P
+ AD=51200000000P PS=460000U PD=775000U
* device instance $7659 r0 *1 67.605,63.08 nfet_01v8
M$7659 2014 3148 167 167 nfet_01v8 L=150000U W=210000U AS=51200000000P
+ AD=21875000000P PS=775000U PD=460000U
* device instance $7660 r0 *1 67.64,63.48 nfet_01v8
M$7660 98 163 2014 167 nfet_01v8 L=150000U W=140000U AS=21875000000P
+ AD=16800000000P PS=460000U PD=380000U
* device instance $7661 r0 *1 67.64,63.87 nfet_01v8
M$7661 295 164 98 167 nfet_01v8 L=150000U W=140000U AS=16800000000P
+ AD=21875000000P PS=380000U PD=460000U
* device instance $7662 r0 *1 67.605,64.27 nfet_01v8
M$7662 167 457 295 167 nfet_01v8 L=150000U W=210000U AS=21875000000P
+ AD=51200000000P PS=460000U PD=775000U
* device instance $7663 r0 *1 67.605,64.66 nfet_01v8
M$7663 457 295 167 167 nfet_01v8 L=150000U W=210000U AS=51200000000P
+ AD=21875000000P PS=775000U PD=460000U
* device instance $7664 r0 *1 67.64,65.06 nfet_01v8
M$7664 97 164 457 167 nfet_01v8 L=150000U W=140000U AS=21875000000P
+ AD=16800000000P PS=460000U PD=380000U
* device instance $7665 r0 *1 67.64,65.45 nfet_01v8
M$7665 296 165 97 167 nfet_01v8 L=150000U W=140000U AS=16800000000P
+ AD=21875000000P PS=380000U PD=460000U
* device instance $7666 r0 *1 67.605,65.85 nfet_01v8
M$7666 167 459 296 167 nfet_01v8 L=150000U W=210000U AS=21875000000P
+ AD=51200000000P PS=460000U PD=775000U
* device instance $7667 r0 *1 67.605,66.24 nfet_01v8
M$7667 459 296 167 167 nfet_01v8 L=150000U W=210000U AS=51200000000P
+ AD=21875000000P PS=775000U PD=460000U
* device instance $7668 r0 *1 67.64,66.64 nfet_01v8
M$7668 98 165 459 167 nfet_01v8 L=150000U W=140000U AS=21875000000P
+ AD=16800000000P PS=460000U PD=380000U
* device instance $7669 r0 *1 89.44,52.81 nfet_01v8
M$7669 3127 158 130 167 nfet_01v8 L=150000U W=140000U AS=16800000000P
+ AD=21875000000P PS=380000U PD=460000U
* device instance $7670 r0 *1 89.405,53.21 nfet_01v8
M$7670 167 516 3127 167 nfet_01v8 L=150000U W=210000U AS=21875000000P
+ AD=51200000000P PS=460000U PD=775000U
* device instance $7671 r0 *1 89.405,53.6 nfet_01v8
M$7671 516 3127 167 167 nfet_01v8 L=150000U W=210000U AS=51200000000P
+ AD=21875000000P PS=775000U PD=460000U
* device instance $7672 r0 *1 89.44,54 nfet_01v8
M$7672 129 158 516 167 nfet_01v8 L=150000U W=140000U AS=21875000000P
+ AD=16800000000P PS=460000U PD=380000U
* device instance $7673 r0 *1 89.44,54.39 nfet_01v8
M$7673 3176 159 129 167 nfet_01v8 L=150000U W=140000U AS=16800000000P
+ AD=21875000000P PS=380000U PD=460000U
* device instance $7674 r0 *1 89.405,54.79 nfet_01v8
M$7674 167 219 3176 167 nfet_01v8 L=150000U W=210000U AS=21875000000P
+ AD=51200000000P PS=460000U PD=775000U
* device instance $7675 r0 *1 89.405,55.18 nfet_01v8
M$7675 219 3176 167 167 nfet_01v8 L=150000U W=210000U AS=51200000000P
+ AD=21875000000P PS=775000U PD=460000U
* device instance $7676 r0 *1 89.44,55.58 nfet_01v8
M$7676 130 159 219 167 nfet_01v8 L=150000U W=140000U AS=21875000000P
+ AD=16800000000P PS=460000U PD=380000U
* device instance $7677 r0 *1 89.44,55.97 nfet_01v8
M$7677 250 160 130 167 nfet_01v8 L=150000U W=140000U AS=16800000000P
+ AD=21875000000P PS=380000U PD=460000U
* device instance $7678 r0 *1 89.405,56.37 nfet_01v8
M$7678 167 367 250 167 nfet_01v8 L=150000U W=210000U AS=21875000000P
+ AD=51200000000P PS=460000U PD=775000U
* device instance $7679 r0 *1 89.405,56.76 nfet_01v8
M$7679 367 250 167 167 nfet_01v8 L=150000U W=210000U AS=51200000000P
+ AD=21875000000P PS=775000U PD=460000U
* device instance $7680 r0 *1 89.44,57.16 nfet_01v8
M$7680 129 160 367 167 nfet_01v8 L=150000U W=140000U AS=21875000000P
+ AD=16800000000P PS=460000U PD=380000U
* device instance $7681 r0 *1 89.44,57.55 nfet_01v8
M$7681 307 161 129 167 nfet_01v8 L=150000U W=140000U AS=16800000000P
+ AD=21875000000P PS=380000U PD=460000U
* device instance $7682 r0 *1 89.405,57.95 nfet_01v8
M$7682 167 481 307 167 nfet_01v8 L=150000U W=210000U AS=21875000000P
+ AD=51200000000P PS=460000U PD=775000U
* device instance $7683 r0 *1 89.405,58.34 nfet_01v8
M$7683 481 307 167 167 nfet_01v8 L=150000U W=210000U AS=51200000000P
+ AD=21875000000P PS=775000U PD=460000U
* device instance $7684 r0 *1 89.44,58.74 nfet_01v8
M$7684 130 161 481 167 nfet_01v8 L=150000U W=140000U AS=21875000000P
+ AD=16800000000P PS=460000U PD=380000U
* device instance $7685 r0 *1 89.44,60.71 nfet_01v8
M$7685 314 162 130 167 nfet_01v8 L=150000U W=140000U AS=16800000000P
+ AD=21875000000P PS=380000U PD=460000U
* device instance $7686 r0 *1 89.405,61.11 nfet_01v8
M$7686 167 495 314 167 nfet_01v8 L=150000U W=210000U AS=21875000000P
+ AD=51200000000P PS=460000U PD=775000U
* device instance $7687 r0 *1 89.405,61.5 nfet_01v8
M$7687 495 314 167 167 nfet_01v8 L=150000U W=210000U AS=51200000000P
+ AD=21875000000P PS=775000U PD=460000U
* device instance $7688 r0 *1 89.44,61.9 nfet_01v8
M$7688 129 162 495 167 nfet_01v8 L=150000U W=140000U AS=21875000000P
+ AD=16800000000P PS=460000U PD=380000U
* device instance $7689 r0 *1 89.44,62.29 nfet_01v8
M$7689 3178 163 129 167 nfet_01v8 L=150000U W=140000U AS=16800000000P
+ AD=21875000000P PS=380000U PD=460000U
* device instance $7690 r0 *1 89.405,62.69 nfet_01v8
M$7690 167 213 3178 167 nfet_01v8 L=150000U W=210000U AS=21875000000P
+ AD=51200000000P PS=460000U PD=775000U
* device instance $7691 r0 *1 89.405,63.08 nfet_01v8
M$7691 213 3178 167 167 nfet_01v8 L=150000U W=210000U AS=51200000000P
+ AD=21875000000P PS=775000U PD=460000U
* device instance $7692 r0 *1 89.44,63.48 nfet_01v8
M$7692 130 163 213 167 nfet_01v8 L=150000U W=140000U AS=21875000000P
+ AD=16800000000P PS=460000U PD=380000U
* device instance $7693 r0 *1 89.44,63.87 nfet_01v8
M$7693 3182 164 130 167 nfet_01v8 L=150000U W=140000U AS=16800000000P
+ AD=21875000000P PS=380000U PD=460000U
* device instance $7694 r0 *1 89.405,64.27 nfet_01v8
M$7694 167 203 3182 167 nfet_01v8 L=150000U W=210000U AS=21875000000P
+ AD=51200000000P PS=460000U PD=775000U
* device instance $7695 r0 *1 89.405,64.66 nfet_01v8
M$7695 203 3182 167 167 nfet_01v8 L=150000U W=210000U AS=51200000000P
+ AD=21875000000P PS=775000U PD=460000U
* device instance $7696 r0 *1 89.44,65.06 nfet_01v8
M$7696 129 164 203 167 nfet_01v8 L=150000U W=140000U AS=21875000000P
+ AD=16800000000P PS=460000U PD=380000U
* device instance $7697 r0 *1 89.44,65.45 nfet_01v8
M$7697 270 165 129 167 nfet_01v8 L=150000U W=140000U AS=16800000000P
+ AD=21875000000P PS=380000U PD=460000U
* device instance $7698 r0 *1 89.405,65.85 nfet_01v8
M$7698 167 406 270 167 nfet_01v8 L=150000U W=210000U AS=21875000000P
+ AD=51200000000P PS=460000U PD=775000U
* device instance $7699 r0 *1 89.405,66.24 nfet_01v8
M$7699 406 270 167 167 nfet_01v8 L=150000U W=210000U AS=51200000000P
+ AD=21875000000P PS=775000U PD=460000U
* device instance $7700 r0 *1 89.44,66.64 nfet_01v8
M$7700 130 165 406 167 nfet_01v8 L=150000U W=140000U AS=21875000000P
+ AD=16800000000P PS=460000U PD=380000U
* device instance $7701 r0 *1 24.04,13.31 nfet_01v8
M$7701 3304 138 34 167 nfet_01v8 L=150000U W=140000U AS=16800000000P
+ AD=21875000000P PS=380000U PD=460000U
* device instance $7702 r0 *1 24.005,13.71 nfet_01v8
M$7702 167 541 3304 167 nfet_01v8 L=150000U W=210000U AS=21875000000P
+ AD=51200000000P PS=460000U PD=775000U
* device instance $7703 r0 *1 24.005,14.1 nfet_01v8
M$7703 541 3304 167 167 nfet_01v8 L=150000U W=210000U AS=51200000000P
+ AD=21875000000P PS=775000U PD=460000U
* device instance $7704 r0 *1 24.04,14.5 nfet_01v8
M$7704 33 138 541 167 nfet_01v8 L=150000U W=140000U AS=21875000000P
+ AD=16800000000P PS=460000U PD=380000U
* device instance $7705 r0 *1 24.04,14.89 nfet_01v8
M$7705 3297 139 33 167 nfet_01v8 L=150000U W=140000U AS=16800000000P
+ AD=21875000000P PS=380000U PD=460000U
* device instance $7706 r0 *1 24.005,15.29 nfet_01v8
M$7706 167 1980 3297 167 nfet_01v8 L=150000U W=210000U AS=21875000000P
+ AD=51200000000P PS=460000U PD=775000U
* device instance $7707 r0 *1 24.005,15.68 nfet_01v8
M$7707 1980 3297 167 167 nfet_01v8 L=150000U W=210000U AS=51200000000P
+ AD=21875000000P PS=775000U PD=460000U
* device instance $7708 r0 *1 24.04,16.08 nfet_01v8
M$7708 34 139 1980 167 nfet_01v8 L=150000U W=140000U AS=21875000000P
+ AD=16800000000P PS=460000U PD=380000U
* device instance $7709 r0 *1 24.04,16.47 nfet_01v8
M$7709 242 140 34 167 nfet_01v8 L=150000U W=140000U AS=16800000000P
+ AD=21875000000P PS=380000U PD=460000U
* device instance $7710 r0 *1 24.005,16.87 nfet_01v8
M$7710 167 209 242 167 nfet_01v8 L=150000U W=210000U AS=21875000000P
+ AD=51200000000P PS=460000U PD=775000U
* device instance $7711 r0 *1 24.005,17.26 nfet_01v8
M$7711 209 242 167 167 nfet_01v8 L=150000U W=210000U AS=51200000000P
+ AD=21875000000P PS=775000U PD=460000U
* device instance $7712 r0 *1 24.04,17.66 nfet_01v8
M$7712 33 140 209 167 nfet_01v8 L=150000U W=140000U AS=21875000000P
+ AD=16800000000P PS=460000U PD=380000U
* device instance $7713 r0 *1 24.04,18.05 nfet_01v8
M$7713 355 141 33 167 nfet_01v8 L=150000U W=140000U AS=16800000000P
+ AD=21875000000P PS=380000U PD=460000U
* device instance $7714 r0 *1 24.005,18.45 nfet_01v8
M$7714 167 574 355 167 nfet_01v8 L=150000U W=210000U AS=21875000000P
+ AD=51200000000P PS=460000U PD=775000U
* device instance $7715 r0 *1 24.005,18.84 nfet_01v8
M$7715 574 355 167 167 nfet_01v8 L=150000U W=210000U AS=51200000000P
+ AD=21875000000P PS=775000U PD=460000U
* device instance $7716 r0 *1 24.04,19.24 nfet_01v8
M$7716 34 141 574 167 nfet_01v8 L=150000U W=140000U AS=21875000000P
+ AD=16800000000P PS=460000U PD=380000U
* device instance $7717 r0 *1 34.94,13.31 nfet_01v8
M$7717 260 138 50 167 nfet_01v8 L=150000U W=140000U AS=16800000000P
+ AD=21875000000P PS=380000U PD=460000U
* device instance $7718 r0 *1 34.905,13.71 nfet_01v8
M$7718 167 380 260 167 nfet_01v8 L=150000U W=210000U AS=21875000000P
+ AD=51200000000P PS=460000U PD=775000U
* device instance $7719 r0 *1 34.905,14.1 nfet_01v8
M$7719 380 260 167 167 nfet_01v8 L=150000U W=210000U AS=51200000000P
+ AD=21875000000P PS=775000U PD=460000U
* device instance $7720 r0 *1 34.94,14.5 nfet_01v8
M$7720 49 138 380 167 nfet_01v8 L=150000U W=140000U AS=21875000000P
+ AD=16800000000P PS=460000U PD=380000U
* device instance $7721 r0 *1 34.94,14.89 nfet_01v8
M$7721 3248 139 49 167 nfet_01v8 L=150000U W=140000U AS=16800000000P
+ AD=21875000000P PS=380000U PD=460000U
* device instance $7722 r0 *1 34.905,15.29 nfet_01v8
M$7722 167 2022 3248 167 nfet_01v8 L=150000U W=210000U AS=21875000000P
+ AD=51200000000P PS=460000U PD=775000U
* device instance $7723 r0 *1 34.905,15.68 nfet_01v8
M$7723 2022 3248 167 167 nfet_01v8 L=150000U W=210000U AS=51200000000P
+ AD=21875000000P PS=775000U PD=460000U
* device instance $7724 r0 *1 34.94,16.08 nfet_01v8
M$7724 50 139 2022 167 nfet_01v8 L=150000U W=140000U AS=21875000000P
+ AD=16800000000P PS=460000U PD=380000U
* device instance $7725 r0 *1 34.94,16.47 nfet_01v8
M$7725 265 140 50 167 nfet_01v8 L=150000U W=140000U AS=16800000000P
+ AD=21875000000P PS=380000U PD=460000U
* device instance $7726 r0 *1 34.905,16.87 nfet_01v8
M$7726 167 397 265 167 nfet_01v8 L=150000U W=210000U AS=21875000000P
+ AD=51200000000P PS=460000U PD=775000U
* device instance $7727 r0 *1 34.905,17.26 nfet_01v8
M$7727 397 265 167 167 nfet_01v8 L=150000U W=210000U AS=51200000000P
+ AD=21875000000P PS=775000U PD=460000U
* device instance $7728 r0 *1 34.94,17.66 nfet_01v8
M$7728 49 140 397 167 nfet_01v8 L=150000U W=140000U AS=21875000000P
+ AD=16800000000P PS=460000U PD=380000U
* device instance $7729 r0 *1 34.94,18.05 nfet_01v8
M$7729 254 141 49 167 nfet_01v8 L=150000U W=140000U AS=16800000000P
+ AD=21875000000P PS=380000U PD=460000U
* device instance $7730 r0 *1 34.905,18.45 nfet_01v8
M$7730 167 372 254 167 nfet_01v8 L=150000U W=210000U AS=21875000000P
+ AD=51200000000P PS=460000U PD=775000U
* device instance $7731 r0 *1 34.905,18.84 nfet_01v8
M$7731 372 254 167 167 nfet_01v8 L=150000U W=210000U AS=51200000000P
+ AD=21875000000P PS=775000U PD=460000U
* device instance $7732 r0 *1 34.94,19.24 nfet_01v8
M$7732 50 141 372 167 nfet_01v8 L=150000U W=140000U AS=21875000000P
+ AD=16800000000P PS=460000U PD=380000U
* device instance $7733 r0 *1 45.84,13.31 nfet_01v8
M$7733 3242 138 66 167 nfet_01v8 L=150000U W=140000U AS=16800000000P
+ AD=21875000000P PS=380000U PD=460000U
* device instance $7734 r0 *1 45.805,13.71 nfet_01v8
M$7734 167 362 3242 167 nfet_01v8 L=150000U W=210000U AS=21875000000P
+ AD=51200000000P PS=460000U PD=775000U
* device instance $7735 r0 *1 45.805,14.1 nfet_01v8
M$7735 362 3242 167 167 nfet_01v8 L=150000U W=210000U AS=51200000000P
+ AD=21875000000P PS=775000U PD=460000U
* device instance $7736 r0 *1 45.84,14.5 nfet_01v8
M$7736 65 138 362 167 nfet_01v8 L=150000U W=140000U AS=21875000000P
+ AD=16800000000P PS=460000U PD=380000U
* device instance $7737 r0 *1 45.84,14.89 nfet_01v8
M$7737 3197 139 65 167 nfet_01v8 L=150000U W=140000U AS=16800000000P
+ AD=21875000000P PS=380000U PD=460000U
* device instance $7738 r0 *1 45.805,15.29 nfet_01v8
M$7738 167 2062 3197 167 nfet_01v8 L=150000U W=210000U AS=21875000000P
+ AD=51200000000P PS=460000U PD=775000U
* device instance $7739 r0 *1 45.805,15.68 nfet_01v8
M$7739 2062 3197 167 167 nfet_01v8 L=150000U W=210000U AS=51200000000P
+ AD=21875000000P PS=775000U PD=460000U
* device instance $7740 r0 *1 45.84,16.08 nfet_01v8
M$7740 66 139 2062 167 nfet_01v8 L=150000U W=140000U AS=21875000000P
+ AD=16800000000P PS=460000U PD=380000U
* device instance $7741 r0 *1 45.84,16.47 nfet_01v8
M$7741 3201 140 66 167 nfet_01v8 L=150000U W=140000U AS=16800000000P
+ AD=21875000000P PS=380000U PD=460000U
* device instance $7742 r0 *1 45.805,16.87 nfet_01v8
M$7742 167 453 3201 167 nfet_01v8 L=150000U W=210000U AS=21875000000P
+ AD=51200000000P PS=460000U PD=775000U
* device instance $7743 r0 *1 45.805,17.26 nfet_01v8
M$7743 453 3201 167 167 nfet_01v8 L=150000U W=210000U AS=51200000000P
+ AD=21875000000P PS=775000U PD=460000U
* device instance $7744 r0 *1 45.84,17.66 nfet_01v8
M$7744 65 140 453 167 nfet_01v8 L=150000U W=140000U AS=21875000000P
+ AD=16800000000P PS=460000U PD=380000U
* device instance $7745 r0 *1 45.84,18.05 nfet_01v8
M$7745 3202 141 65 167 nfet_01v8 L=150000U W=140000U AS=16800000000P
+ AD=21875000000P PS=380000U PD=460000U
* device instance $7746 r0 *1 45.805,18.45 nfet_01v8
M$7746 167 447 3202 167 nfet_01v8 L=150000U W=210000U AS=21875000000P
+ AD=51200000000P PS=460000U PD=775000U
* device instance $7747 r0 *1 45.805,18.84 nfet_01v8
M$7747 447 3202 167 167 nfet_01v8 L=150000U W=210000U AS=51200000000P
+ AD=21875000000P PS=775000U PD=460000U
* device instance $7748 r0 *1 45.84,19.24 nfet_01v8
M$7748 66 141 447 167 nfet_01v8 L=150000U W=140000U AS=21875000000P
+ AD=16800000000P PS=460000U PD=380000U
* device instance $7749 r0 *1 56.74,13.31 nfet_01v8
M$7749 3369 138 82 167 nfet_01v8 L=150000U W=140000U AS=16800000000P
+ AD=21875000000P PS=380000U PD=460000U
* device instance $7750 r0 *1 56.705,13.71 nfet_01v8
M$7750 167 483 3369 167 nfet_01v8 L=150000U W=210000U AS=21875000000P
+ AD=51200000000P PS=460000U PD=775000U
* device instance $7751 r0 *1 56.705,14.1 nfet_01v8
M$7751 483 3369 167 167 nfet_01v8 L=150000U W=210000U AS=51200000000P
+ AD=21875000000P PS=775000U PD=460000U
* device instance $7752 r0 *1 56.74,14.5 nfet_01v8
M$7752 81 138 483 167 nfet_01v8 L=150000U W=140000U AS=21875000000P
+ AD=16800000000P PS=460000U PD=380000U
* device instance $7753 r0 *1 56.74,14.89 nfet_01v8
M$7753 3365 139 81 167 nfet_01v8 L=150000U W=140000U AS=16800000000P
+ AD=21875000000P PS=380000U PD=460000U
* device instance $7754 r0 *1 56.705,15.29 nfet_01v8
M$7754 167 2011 3365 167 nfet_01v8 L=150000U W=210000U AS=21875000000P
+ AD=51200000000P PS=460000U PD=775000U
* device instance $7755 r0 *1 56.705,15.68 nfet_01v8
M$7755 2011 3365 167 167 nfet_01v8 L=150000U W=210000U AS=51200000000P
+ AD=21875000000P PS=775000U PD=460000U
* device instance $7756 r0 *1 56.74,16.08 nfet_01v8
M$7756 82 139 2011 167 nfet_01v8 L=150000U W=140000U AS=21875000000P
+ AD=16800000000P PS=460000U PD=380000U
* device instance $7757 r0 *1 56.74,16.47 nfet_01v8
M$7757 230 140 82 167 nfet_01v8 L=150000U W=140000U AS=16800000000P
+ AD=21875000000P PS=380000U PD=460000U
* device instance $7758 r0 *1 56.705,16.87 nfet_01v8
M$7758 167 175 230 167 nfet_01v8 L=150000U W=210000U AS=21875000000P
+ AD=51200000000P PS=460000U PD=775000U
* device instance $7759 r0 *1 56.705,17.26 nfet_01v8
M$7759 175 230 167 167 nfet_01v8 L=150000U W=210000U AS=51200000000P
+ AD=21875000000P PS=775000U PD=460000U
* device instance $7760 r0 *1 56.74,17.66 nfet_01v8
M$7760 81 140 175 167 nfet_01v8 L=150000U W=140000U AS=21875000000P
+ AD=16800000000P PS=460000U PD=380000U
* device instance $7761 r0 *1 56.74,18.05 nfet_01v8
M$7761 312 141 81 167 nfet_01v8 L=150000U W=140000U AS=16800000000P
+ AD=21875000000P PS=380000U PD=460000U
* device instance $7762 r0 *1 56.705,18.45 nfet_01v8
M$7762 167 491 312 167 nfet_01v8 L=150000U W=210000U AS=21875000000P
+ AD=51200000000P PS=460000U PD=775000U
* device instance $7763 r0 *1 56.705,18.84 nfet_01v8
M$7763 491 312 167 167 nfet_01v8 L=150000U W=210000U AS=51200000000P
+ AD=21875000000P PS=775000U PD=460000U
* device instance $7764 r0 *1 56.74,19.24 nfet_01v8
M$7764 82 141 491 167 nfet_01v8 L=150000U W=140000U AS=21875000000P
+ AD=16800000000P PS=460000U PD=380000U
* device instance $7765 r0 *1 67.64,13.31 nfet_01v8
M$7765 326 138 98 167 nfet_01v8 L=150000U W=140000U AS=16800000000P
+ AD=21875000000P PS=380000U PD=460000U
* device instance $7766 r0 *1 67.605,13.71 nfet_01v8
M$7766 167 522 326 167 nfet_01v8 L=150000U W=210000U AS=21875000000P
+ AD=51200000000P PS=460000U PD=775000U
* device instance $7767 r0 *1 67.605,14.1 nfet_01v8
M$7767 522 326 167 167 nfet_01v8 L=150000U W=210000U AS=51200000000P
+ AD=21875000000P PS=775000U PD=460000U
* device instance $7768 r0 *1 67.64,14.5 nfet_01v8
M$7768 97 138 522 167 nfet_01v8 L=150000U W=140000U AS=21875000000P
+ AD=16800000000P PS=460000U PD=380000U
* device instance $7769 r0 *1 67.64,14.89 nfet_01v8
M$7769 3416 139 97 167 nfet_01v8 L=150000U W=140000U AS=16800000000P
+ AD=21875000000P PS=380000U PD=460000U
* device instance $7770 r0 *1 67.605,15.29 nfet_01v8
M$7770 167 194 3416 167 nfet_01v8 L=150000U W=210000U AS=21875000000P
+ AD=51200000000P PS=460000U PD=775000U
* device instance $7771 r0 *1 67.605,15.68 nfet_01v8
M$7771 194 3416 167 167 nfet_01v8 L=150000U W=210000U AS=51200000000P
+ AD=21875000000P PS=775000U PD=460000U
* device instance $7772 r0 *1 67.64,16.08 nfet_01v8
M$7772 98 139 194 167 nfet_01v8 L=150000U W=140000U AS=21875000000P
+ AD=16800000000P PS=460000U PD=380000U
* device instance $7773 r0 *1 67.64,16.47 nfet_01v8
M$7773 233 140 98 167 nfet_01v8 L=150000U W=140000U AS=16800000000P
+ AD=21875000000P PS=380000U PD=460000U
* device instance $7774 r0 *1 67.605,16.87 nfet_01v8
M$7774 167 187 233 167 nfet_01v8 L=150000U W=210000U AS=21875000000P
+ AD=51200000000P PS=460000U PD=775000U
* device instance $7775 r0 *1 67.605,17.26 nfet_01v8
M$7775 187 233 167 167 nfet_01v8 L=150000U W=210000U AS=51200000000P
+ AD=21875000000P PS=775000U PD=460000U
* device instance $7776 r0 *1 67.64,17.66 nfet_01v8
M$7776 97 140 187 167 nfet_01v8 L=150000U W=140000U AS=21875000000P
+ AD=16800000000P PS=460000U PD=380000U
* device instance $7777 r0 *1 67.64,18.05 nfet_01v8
M$7777 3359 141 97 167 nfet_01v8 L=150000U W=140000U AS=16800000000P
+ AD=21875000000P PS=380000U PD=460000U
* device instance $7778 r0 *1 67.605,18.45 nfet_01v8
M$7778 167 544 3359 167 nfet_01v8 L=150000U W=210000U AS=21875000000P
+ AD=51200000000P PS=460000U PD=775000U
* device instance $7779 r0 *1 67.605,18.84 nfet_01v8
M$7779 544 3359 167 167 nfet_01v8 L=150000U W=210000U AS=51200000000P
+ AD=21875000000P PS=775000U PD=460000U
* device instance $7780 r0 *1 67.64,19.24 nfet_01v8
M$7780 98 141 544 167 nfet_01v8 L=150000U W=140000U AS=21875000000P
+ AD=16800000000P PS=460000U PD=380000U
* device instance $7781 r0 *1 78.54,13.31 nfet_01v8
M$7781 3373 138 114 167 nfet_01v8 L=150000U W=140000U AS=16800000000P
+ AD=21875000000P PS=380000U PD=460000U
* device instance $7782 r0 *1 78.505,13.71 nfet_01v8
M$7782 167 427 3373 167 nfet_01v8 L=150000U W=210000U AS=21875000000P
+ AD=51200000000P PS=460000U PD=775000U
* device instance $7783 r0 *1 78.505,14.1 nfet_01v8
M$7783 427 3373 167 167 nfet_01v8 L=150000U W=210000U AS=51200000000P
+ AD=21875000000P PS=775000U PD=460000U
* device instance $7784 r0 *1 78.54,14.5 nfet_01v8
M$7784 113 138 427 167 nfet_01v8 L=150000U W=140000U AS=21875000000P
+ AD=16800000000P PS=460000U PD=380000U
* device instance $7785 r0 *1 78.54,14.89 nfet_01v8
M$7785 3400 139 113 167 nfet_01v8 L=150000U W=140000U AS=16800000000P
+ AD=21875000000P PS=380000U PD=460000U
* device instance $7786 r0 *1 78.505,15.29 nfet_01v8
M$7786 167 2064 3400 167 nfet_01v8 L=150000U W=210000U AS=21875000000P
+ AD=51200000000P PS=460000U PD=775000U
* device instance $7787 r0 *1 78.505,15.68 nfet_01v8
M$7787 2064 3400 167 167 nfet_01v8 L=150000U W=210000U AS=51200000000P
+ AD=21875000000P PS=775000U PD=460000U
* device instance $7788 r0 *1 78.54,16.08 nfet_01v8
M$7788 114 139 2064 167 nfet_01v8 L=150000U W=140000U AS=21875000000P
+ AD=16800000000P PS=460000U PD=380000U
* device instance $7789 r0 *1 78.54,16.47 nfet_01v8
M$7789 267 140 114 167 nfet_01v8 L=150000U W=140000U AS=16800000000P
+ AD=21875000000P PS=380000U PD=460000U
* device instance $7790 r0 *1 78.505,16.87 nfet_01v8
M$7790 167 400 267 167 nfet_01v8 L=150000U W=210000U AS=21875000000P
+ AD=51200000000P PS=460000U PD=775000U
* device instance $7791 r0 *1 78.505,17.26 nfet_01v8
M$7791 400 267 167 167 nfet_01v8 L=150000U W=210000U AS=51200000000P
+ AD=21875000000P PS=775000U PD=460000U
* device instance $7792 r0 *1 78.54,17.66 nfet_01v8
M$7792 113 140 400 167 nfet_01v8 L=150000U W=140000U AS=21875000000P
+ AD=16800000000P PS=460000U PD=380000U
* device instance $7793 r0 *1 78.54,18.05 nfet_01v8
M$7793 3403 141 113 167 nfet_01v8 L=150000U W=140000U AS=16800000000P
+ AD=21875000000P PS=380000U PD=460000U
* device instance $7794 r0 *1 78.505,18.45 nfet_01v8
M$7794 167 370 3403 167 nfet_01v8 L=150000U W=210000U AS=21875000000P
+ AD=51200000000P PS=460000U PD=775000U
* device instance $7795 r0 *1 78.505,18.84 nfet_01v8
M$7795 370 3403 167 167 nfet_01v8 L=150000U W=210000U AS=51200000000P
+ AD=21875000000P PS=775000U PD=460000U
* device instance $7796 r0 *1 78.54,19.24 nfet_01v8
M$7796 114 141 370 167 nfet_01v8 L=150000U W=140000U AS=21875000000P
+ AD=16800000000P PS=460000U PD=380000U
* device instance $7797 r0 *1 13.14,5.41 nfet_01v8
M$7797 256 134 18 167 nfet_01v8 L=150000U W=140000U AS=16800000000P
+ AD=21875000000P PS=380000U PD=460000U
* device instance $7798 r0 *1 13.105,5.81 nfet_01v8
M$7798 167 376 256 167 nfet_01v8 L=150000U W=210000U AS=21875000000P
+ AD=51200000000P PS=460000U PD=775000U
* device instance $7799 r0 *1 13.105,6.2 nfet_01v8
M$7799 376 256 167 167 nfet_01v8 L=150000U W=210000U AS=51200000000P
+ AD=21875000000P PS=775000U PD=460000U
* device instance $7800 r0 *1 13.14,6.6 nfet_01v8
M$7800 17 134 376 167 nfet_01v8 L=150000U W=140000U AS=21875000000P
+ AD=16800000000P PS=460000U PD=380000U
* device instance $7801 r0 *1 13.14,6.99 nfet_01v8
M$7801 3224 135 17 167 nfet_01v8 L=150000U W=140000U AS=16800000000P
+ AD=21875000000P PS=380000U PD=460000U
* device instance $7802 r0 *1 13.105,7.39 nfet_01v8
M$7802 167 452 3224 167 nfet_01v8 L=150000U W=210000U AS=21875000000P
+ AD=51200000000P PS=460000U PD=775000U
* device instance $7803 r0 *1 13.105,7.78 nfet_01v8
M$7803 452 3224 167 167 nfet_01v8 L=150000U W=210000U AS=51200000000P
+ AD=21875000000P PS=775000U PD=460000U
* device instance $7804 r0 *1 13.14,8.18 nfet_01v8
M$7804 18 135 452 167 nfet_01v8 L=150000U W=140000U AS=21875000000P
+ AD=16800000000P PS=460000U PD=380000U
* device instance $7805 r0 *1 13.14,8.57 nfet_01v8
M$7805 293 136 18 167 nfet_01v8 L=150000U W=140000U AS=16800000000P
+ AD=21875000000P PS=380000U PD=460000U
* device instance $7806 r0 *1 13.105,8.97 nfet_01v8
M$7806 167 450 293 167 nfet_01v8 L=150000U W=210000U AS=21875000000P
+ AD=51200000000P PS=460000U PD=775000U
* device instance $7807 r0 *1 13.105,9.36 nfet_01v8
M$7807 450 293 167 167 nfet_01v8 L=150000U W=210000U AS=51200000000P
+ AD=21875000000P PS=775000U PD=460000U
* device instance $7808 r0 *1 13.14,9.76 nfet_01v8
M$7808 17 136 450 167 nfet_01v8 L=150000U W=140000U AS=21875000000P
+ AD=16800000000P PS=460000U PD=380000U
* device instance $7809 r0 *1 13.14,10.15 nfet_01v8
M$7809 3294 137 17 167 nfet_01v8 L=150000U W=140000U AS=16800000000P
+ AD=21875000000P PS=380000U PD=460000U
* device instance $7810 r0 *1 13.105,10.55 nfet_01v8
M$7810 167 448 3294 167 nfet_01v8 L=150000U W=210000U AS=21875000000P
+ AD=51200000000P PS=460000U PD=775000U
* device instance $7811 r0 *1 13.105,10.94 nfet_01v8
M$7811 448 3294 167 167 nfet_01v8 L=150000U W=210000U AS=51200000000P
+ AD=21875000000P PS=775000U PD=460000U
* device instance $7812 r0 *1 13.14,11.34 nfet_01v8
M$7812 18 137 448 167 nfet_01v8 L=150000U W=140000U AS=21875000000P
+ AD=16800000000P PS=460000U PD=380000U
* device instance $7813 r0 *1 24.04,5.41 nfet_01v8
M$7813 3184 134 34 167 nfet_01v8 L=150000U W=140000U AS=16800000000P
+ AD=21875000000P PS=380000U PD=460000U
* device instance $7814 r0 *1 24.005,5.81 nfet_01v8
M$7814 167 577 3184 167 nfet_01v8 L=150000U W=210000U AS=21875000000P
+ AD=51200000000P PS=460000U PD=775000U
* device instance $7815 r0 *1 24.005,6.2 nfet_01v8
M$7815 577 3184 167 167 nfet_01v8 L=150000U W=210000U AS=51200000000P
+ AD=21875000000P PS=775000U PD=460000U
* device instance $7816 r0 *1 24.04,6.6 nfet_01v8
M$7816 33 134 577 167 nfet_01v8 L=150000U W=140000U AS=21875000000P
+ AD=16800000000P PS=460000U PD=380000U
* device instance $7817 r0 *1 24.04,6.99 nfet_01v8
M$7817 3185 135 33 167 nfet_01v8 L=150000U W=140000U AS=16800000000P
+ AD=21875000000P PS=380000U PD=460000U
* device instance $7818 r0 *1 24.005,7.39 nfet_01v8
M$7818 167 575 3185 167 nfet_01v8 L=150000U W=210000U AS=21875000000P
+ AD=51200000000P PS=460000U PD=775000U
* device instance $7819 r0 *1 24.005,7.78 nfet_01v8
M$7819 575 3185 167 167 nfet_01v8 L=150000U W=210000U AS=51200000000P
+ AD=21875000000P PS=775000U PD=460000U
* device instance $7820 r0 *1 24.04,8.18 nfet_01v8
M$7820 34 135 575 167 nfet_01v8 L=150000U W=140000U AS=21875000000P
+ AD=16800000000P PS=460000U PD=380000U
* device instance $7821 r0 *1 24.04,8.57 nfet_01v8
M$7821 346 136 34 167 nfet_01v8 L=150000U W=140000U AS=16800000000P
+ AD=21875000000P PS=380000U PD=460000U
* device instance $7822 r0 *1 24.005,8.97 nfet_01v8
M$7822 167 558 346 167 nfet_01v8 L=150000U W=210000U AS=21875000000P
+ AD=51200000000P PS=460000U PD=775000U
* device instance $7823 r0 *1 24.005,9.36 nfet_01v8
M$7823 558 346 167 167 nfet_01v8 L=150000U W=210000U AS=51200000000P
+ AD=21875000000P PS=775000U PD=460000U
* device instance $7824 r0 *1 24.04,9.76 nfet_01v8
M$7824 33 136 558 167 nfet_01v8 L=150000U W=140000U AS=21875000000P
+ AD=16800000000P PS=460000U PD=380000U
* device instance $7825 r0 *1 24.04,10.15 nfet_01v8
M$7825 348 137 33 167 nfet_01v8 L=150000U W=140000U AS=16800000000P
+ AD=21875000000P PS=380000U PD=460000U
* device instance $7826 r0 *1 24.005,10.55 nfet_01v8
M$7826 167 560 348 167 nfet_01v8 L=150000U W=210000U AS=21875000000P
+ AD=51200000000P PS=460000U PD=775000U
* device instance $7827 r0 *1 24.005,10.94 nfet_01v8
M$7827 560 348 167 167 nfet_01v8 L=150000U W=210000U AS=51200000000P
+ AD=21875000000P PS=775000U PD=460000U
* device instance $7828 r0 *1 24.04,11.34 nfet_01v8
M$7828 34 137 560 167 nfet_01v8 L=150000U W=140000U AS=21875000000P
+ AD=16800000000P PS=460000U PD=380000U
* device instance $7829 r0 *1 34.94,5.41 nfet_01v8
M$7829 278 134 50 167 nfet_01v8 L=150000U W=140000U AS=16800000000P
+ AD=21875000000P PS=380000U PD=460000U
* device instance $7830 r0 *1 34.905,5.81 nfet_01v8
M$7830 167 419 278 167 nfet_01v8 L=150000U W=210000U AS=21875000000P
+ AD=51200000000P PS=460000U PD=775000U
* device instance $7831 r0 *1 34.905,6.2 nfet_01v8
M$7831 419 278 167 167 nfet_01v8 L=150000U W=210000U AS=51200000000P
+ AD=21875000000P PS=775000U PD=460000U
* device instance $7832 r0 *1 34.94,6.6 nfet_01v8
M$7832 49 134 419 167 nfet_01v8 L=150000U W=140000U AS=21875000000P
+ AD=16800000000P PS=460000U PD=380000U
* device instance $7833 r0 *1 34.94,6.99 nfet_01v8
M$7833 3225 135 49 167 nfet_01v8 L=150000U W=140000U AS=16800000000P
+ AD=21875000000P PS=380000U PD=460000U
* device instance $7834 r0 *1 34.905,7.39 nfet_01v8
M$7834 167 2039 3225 167 nfet_01v8 L=150000U W=210000U AS=21875000000P
+ AD=51200000000P PS=460000U PD=775000U
* device instance $7835 r0 *1 34.905,7.78 nfet_01v8
M$7835 2039 3225 167 167 nfet_01v8 L=150000U W=210000U AS=51200000000P
+ AD=21875000000P PS=775000U PD=460000U
* device instance $7836 r0 *1 34.94,8.18 nfet_01v8
M$7836 50 135 2039 167 nfet_01v8 L=150000U W=140000U AS=21875000000P
+ AD=16800000000P PS=460000U PD=380000U
* device instance $7837 r0 *1 34.94,8.57 nfet_01v8
M$7837 245 136 50 167 nfet_01v8 L=150000U W=140000U AS=16800000000P
+ AD=21875000000P PS=380000U PD=460000U
* device instance $7838 r0 *1 34.905,8.97 nfet_01v8
M$7838 167 223 245 167 nfet_01v8 L=150000U W=210000U AS=21875000000P
+ AD=51200000000P PS=460000U PD=775000U
* device instance $7839 r0 *1 34.905,9.36 nfet_01v8
M$7839 223 245 167 167 nfet_01v8 L=150000U W=210000U AS=51200000000P
+ AD=21875000000P PS=775000U PD=460000U
* device instance $7840 r0 *1 34.94,9.76 nfet_01v8
M$7840 49 136 223 167 nfet_01v8 L=150000U W=140000U AS=21875000000P
+ AD=16800000000P PS=460000U PD=380000U
* device instance $7841 r0 *1 34.94,10.15 nfet_01v8
M$7841 303 137 49 167 nfet_01v8 L=150000U W=140000U AS=16800000000P
+ AD=21875000000P PS=380000U PD=460000U
* device instance $7842 r0 *1 34.905,10.55 nfet_01v8
M$7842 167 471 303 167 nfet_01v8 L=150000U W=210000U AS=21875000000P
+ AD=51200000000P PS=460000U PD=775000U
* device instance $7843 r0 *1 34.905,10.94 nfet_01v8
M$7843 471 303 167 167 nfet_01v8 L=150000U W=210000U AS=51200000000P
+ AD=21875000000P PS=775000U PD=460000U
* device instance $7844 r0 *1 34.94,11.34 nfet_01v8
M$7844 50 137 471 167 nfet_01v8 L=150000U W=140000U AS=21875000000P
+ AD=16800000000P PS=460000U PD=380000U
* device instance $7845 r0 *1 45.84,5.41 nfet_01v8
M$7845 283 134 66 167 nfet_01v8 L=150000U W=140000U AS=16800000000P
+ AD=21875000000P PS=380000U PD=460000U
* device instance $7846 r0 *1 45.805,5.81 nfet_01v8
M$7846 167 426 283 167 nfet_01v8 L=150000U W=210000U AS=21875000000P
+ AD=51200000000P PS=460000U PD=775000U
* device instance $7847 r0 *1 45.805,6.2 nfet_01v8
M$7847 426 283 167 167 nfet_01v8 L=150000U W=210000U AS=51200000000P
+ AD=21875000000P PS=775000U PD=460000U
* device instance $7848 r0 *1 45.84,6.6 nfet_01v8
M$7848 65 134 426 167 nfet_01v8 L=150000U W=140000U AS=21875000000P
+ AD=16800000000P PS=460000U PD=380000U
* device instance $7849 r0 *1 45.84,6.99 nfet_01v8
M$7849 3231 135 65 167 nfet_01v8 L=150000U W=140000U AS=16800000000P
+ AD=21875000000P PS=380000U PD=460000U
* device instance $7850 r0 *1 45.805,7.39 nfet_01v8
M$7850 167 201 3231 167 nfet_01v8 L=150000U W=210000U AS=21875000000P
+ AD=51200000000P PS=460000U PD=775000U
* device instance $7851 r0 *1 45.805,7.78 nfet_01v8
M$7851 201 3231 167 167 nfet_01v8 L=150000U W=210000U AS=51200000000P
+ AD=21875000000P PS=775000U PD=460000U
* device instance $7852 r0 *1 45.84,8.18 nfet_01v8
M$7852 66 135 201 167 nfet_01v8 L=150000U W=140000U AS=21875000000P
+ AD=16800000000P PS=460000U PD=380000U
* device instance $7853 r0 *1 45.84,8.57 nfet_01v8
M$7853 3232 136 66 167 nfet_01v8 L=150000U W=140000U AS=16800000000P
+ AD=21875000000P PS=380000U PD=460000U
* device instance $7854 r0 *1 45.805,8.97 nfet_01v8
M$7854 167 431 3232 167 nfet_01v8 L=150000U W=210000U AS=21875000000P
+ AD=51200000000P PS=460000U PD=775000U
* device instance $7855 r0 *1 45.805,9.36 nfet_01v8
M$7855 431 3232 167 167 nfet_01v8 L=150000U W=210000U AS=51200000000P
+ AD=21875000000P PS=775000U PD=460000U
* device instance $7856 r0 *1 45.84,9.76 nfet_01v8
M$7856 65 136 431 167 nfet_01v8 L=150000U W=140000U AS=21875000000P
+ AD=16800000000P PS=460000U PD=380000U
* device instance $7857 r0 *1 45.84,10.15 nfet_01v8
M$7857 3193 137 65 167 nfet_01v8 L=150000U W=140000U AS=16800000000P
+ AD=21875000000P PS=380000U PD=460000U
* device instance $7858 r0 *1 45.805,10.55 nfet_01v8
M$7858 167 464 3193 167 nfet_01v8 L=150000U W=210000U AS=21875000000P
+ AD=51200000000P PS=460000U PD=775000U
* device instance $7859 r0 *1 45.805,10.94 nfet_01v8
M$7859 464 3193 167 167 nfet_01v8 L=150000U W=210000U AS=51200000000P
+ AD=21875000000P PS=775000U PD=460000U
* device instance $7860 r0 *1 45.84,11.34 nfet_01v8
M$7860 66 137 464 167 nfet_01v8 L=150000U W=140000U AS=21875000000P
+ AD=16800000000P PS=460000U PD=380000U
* device instance $7861 r0 *1 56.74,5.41 nfet_01v8
M$7861 3333 134 82 167 nfet_01v8 L=150000U W=140000U AS=16800000000P
+ AD=21875000000P PS=380000U PD=460000U
* device instance $7862 r0 *1 56.705,5.81 nfet_01v8
M$7862 167 478 3333 167 nfet_01v8 L=150000U W=210000U AS=21875000000P
+ AD=51200000000P PS=460000U PD=775000U
* device instance $7863 r0 *1 56.705,6.2 nfet_01v8
M$7863 478 3333 167 167 nfet_01v8 L=150000U W=210000U AS=51200000000P
+ AD=21875000000P PS=775000U PD=460000U
* device instance $7864 r0 *1 56.74,6.6 nfet_01v8
M$7864 81 134 478 167 nfet_01v8 L=150000U W=140000U AS=21875000000P
+ AD=16800000000P PS=460000U PD=380000U
* device instance $7865 r0 *1 56.74,6.99 nfet_01v8
M$7865 3334 135 81 167 nfet_01v8 L=150000U W=140000U AS=16800000000P
+ AD=21875000000P PS=380000U PD=460000U
* device instance $7866 r0 *1 56.705,7.39 nfet_01v8
M$7866 167 202 3334 167 nfet_01v8 L=150000U W=210000U AS=21875000000P
+ AD=51200000000P PS=460000U PD=775000U
* device instance $7867 r0 *1 56.705,7.78 nfet_01v8
M$7867 202 3334 167 167 nfet_01v8 L=150000U W=210000U AS=51200000000P
+ AD=21875000000P PS=775000U PD=460000U
* device instance $7868 r0 *1 56.74,8.18 nfet_01v8
M$7868 82 135 202 167 nfet_01v8 L=150000U W=140000U AS=21875000000P
+ AD=16800000000P PS=460000U PD=380000U
* device instance $7869 r0 *1 56.74,8.57 nfet_01v8
M$7869 3340 136 82 167 nfet_01v8 L=150000U W=140000U AS=16800000000P
+ AD=21875000000P PS=380000U PD=460000U
* device instance $7870 r0 *1 56.705,8.97 nfet_01v8
M$7870 167 197 3340 167 nfet_01v8 L=150000U W=210000U AS=21875000000P
+ AD=51200000000P PS=460000U PD=775000U
* device instance $7871 r0 *1 56.705,9.36 nfet_01v8
M$7871 197 3340 167 167 nfet_01v8 L=150000U W=210000U AS=51200000000P
+ AD=21875000000P PS=775000U PD=460000U
* device instance $7872 r0 *1 56.74,9.76 nfet_01v8
M$7872 81 136 197 167 nfet_01v8 L=150000U W=140000U AS=21875000000P
+ AD=16800000000P PS=460000U PD=380000U
* device instance $7873 r0 *1 56.74,10.15 nfet_01v8
M$7873 325 137 81 167 nfet_01v8 L=150000U W=140000U AS=16800000000P
+ AD=21875000000P PS=380000U PD=460000U
* device instance $7874 r0 *1 56.705,10.55 nfet_01v8
M$7874 167 519 325 167 nfet_01v8 L=150000U W=210000U AS=21875000000P
+ AD=51200000000P PS=460000U PD=775000U
* device instance $7875 r0 *1 56.705,10.94 nfet_01v8
M$7875 519 325 167 167 nfet_01v8 L=150000U W=210000U AS=51200000000P
+ AD=21875000000P PS=775000U PD=460000U
* device instance $7876 r0 *1 56.74,11.34 nfet_01v8
M$7876 82 137 519 167 nfet_01v8 L=150000U W=140000U AS=21875000000P
+ AD=16800000000P PS=460000U PD=380000U
* device instance $7877 r0 *1 67.64,5.41 nfet_01v8
M$7877 3344 134 98 167 nfet_01v8 L=150000U W=140000U AS=16800000000P
+ AD=21875000000P PS=380000U PD=460000U
* device instance $7878 r0 *1 67.605,5.81 nfet_01v8
M$7878 167 499 3344 167 nfet_01v8 L=150000U W=210000U AS=21875000000P
+ AD=51200000000P PS=460000U PD=775000U
* device instance $7879 r0 *1 67.605,6.2 nfet_01v8
M$7879 499 3344 167 167 nfet_01v8 L=150000U W=210000U AS=51200000000P
+ AD=21875000000P PS=775000U PD=460000U
* device instance $7880 r0 *1 67.64,6.6 nfet_01v8
M$7880 97 134 499 167 nfet_01v8 L=150000U W=140000U AS=21875000000P
+ AD=16800000000P PS=460000U PD=380000U
* device instance $7881 r0 *1 67.64,6.99 nfet_01v8
M$7881 3346 135 97 167 nfet_01v8 L=150000U W=140000U AS=16800000000P
+ AD=21875000000P PS=380000U PD=460000U
* device instance $7882 r0 *1 67.605,7.39 nfet_01v8
M$7882 167 2009 3346 167 nfet_01v8 L=150000U W=210000U AS=21875000000P
+ AD=51200000000P PS=460000U PD=775000U
* device instance $7883 r0 *1 67.605,7.78 nfet_01v8
M$7883 2009 3346 167 167 nfet_01v8 L=150000U W=210000U AS=51200000000P
+ AD=21875000000P PS=775000U PD=460000U
* device instance $7884 r0 *1 67.64,8.18 nfet_01v8
M$7884 98 135 2009 167 nfet_01v8 L=150000U W=140000U AS=21875000000P
+ AD=16800000000P PS=460000U PD=380000U
* device instance $7885 r0 *1 67.64,8.57 nfet_01v8
M$7885 3347 136 98 167 nfet_01v8 L=150000U W=140000U AS=16800000000P
+ AD=21875000000P PS=380000U PD=460000U
* device instance $7886 r0 *1 67.605,8.97 nfet_01v8
M$7886 167 217 3347 167 nfet_01v8 L=150000U W=210000U AS=21875000000P
+ AD=51200000000P PS=460000U PD=775000U
* device instance $7887 r0 *1 67.605,9.36 nfet_01v8
M$7887 217 3347 167 167 nfet_01v8 L=150000U W=210000U AS=51200000000P
+ AD=21875000000P PS=775000U PD=460000U
* device instance $7888 r0 *1 67.64,9.76 nfet_01v8
M$7888 97 136 217 167 nfet_01v8 L=150000U W=140000U AS=21875000000P
+ AD=16800000000P PS=460000U PD=380000U
* device instance $7889 r0 *1 67.64,10.15 nfet_01v8
M$7889 3460 137 97 167 nfet_01v8 L=150000U W=140000U AS=16800000000P
+ AD=21875000000P PS=380000U PD=460000U
* device instance $7890 r0 *1 67.605,10.55 nfet_01v8
M$7890 167 520 3460 167 nfet_01v8 L=150000U W=210000U AS=21875000000P
+ AD=51200000000P PS=460000U PD=775000U
* device instance $7891 r0 *1 67.605,10.94 nfet_01v8
M$7891 520 3460 167 167 nfet_01v8 L=150000U W=210000U AS=51200000000P
+ AD=21875000000P PS=775000U PD=460000U
* device instance $7892 r0 *1 67.64,11.34 nfet_01v8
M$7892 98 137 520 167 nfet_01v8 L=150000U W=140000U AS=21875000000P
+ AD=16800000000P PS=460000U PD=380000U
* device instance $7893 r0 *1 78.54,5.41 nfet_01v8
M$7893 3378 134 114 167 nfet_01v8 L=150000U W=140000U AS=16800000000P
+ AD=21875000000P PS=380000U PD=460000U
* device instance $7894 r0 *1 78.505,5.81 nfet_01v8
M$7894 167 393 3378 167 nfet_01v8 L=150000U W=210000U AS=21875000000P
+ AD=51200000000P PS=460000U PD=775000U
* device instance $7895 r0 *1 78.505,6.2 nfet_01v8
M$7895 393 3378 167 167 nfet_01v8 L=150000U W=210000U AS=51200000000P
+ AD=21875000000P PS=775000U PD=460000U
* device instance $7896 r0 *1 78.54,6.6 nfet_01v8
M$7896 113 134 393 167 nfet_01v8 L=150000U W=140000U AS=21875000000P
+ AD=16800000000P PS=460000U PD=380000U
* device instance $7897 r0 *1 78.54,6.99 nfet_01v8
M$7897 3380 135 113 167 nfet_01v8 L=150000U W=140000U AS=16800000000P
+ AD=21875000000P PS=380000U PD=460000U
* device instance $7898 r0 *1 78.505,7.39 nfet_01v8
M$7898 167 2038 3380 167 nfet_01v8 L=150000U W=210000U AS=21875000000P
+ AD=51200000000P PS=460000U PD=775000U
* device instance $7899 r0 *1 78.505,7.78 nfet_01v8
M$7899 2038 3380 167 167 nfet_01v8 L=150000U W=210000U AS=51200000000P
+ AD=21875000000P PS=775000U PD=460000U
* device instance $7900 r0 *1 78.54,8.18 nfet_01v8
M$7900 114 135 2038 167 nfet_01v8 L=150000U W=140000U AS=21875000000P
+ AD=16800000000P PS=460000U PD=380000U
* device instance $7901 r0 *1 78.54,8.57 nfet_01v8
M$7901 292 136 114 167 nfet_01v8 L=150000U W=140000U AS=16800000000P
+ AD=21875000000P PS=380000U PD=460000U
* device instance $7902 r0 *1 78.505,8.97 nfet_01v8
M$7902 167 449 292 167 nfet_01v8 L=150000U W=210000U AS=21875000000P
+ AD=51200000000P PS=460000U PD=775000U
* device instance $7903 r0 *1 78.505,9.36 nfet_01v8
M$7903 449 292 167 167 nfet_01v8 L=150000U W=210000U AS=51200000000P
+ AD=21875000000P PS=775000U PD=460000U
* device instance $7904 r0 *1 78.54,9.76 nfet_01v8
M$7904 113 136 449 167 nfet_01v8 L=150000U W=140000U AS=21875000000P
+ AD=16800000000P PS=460000U PD=380000U
* device instance $7905 r0 *1 78.54,10.15 nfet_01v8
M$7905 3353 137 113 167 nfet_01v8 L=150000U W=140000U AS=16800000000P
+ AD=21875000000P PS=380000U PD=460000U
* device instance $7906 r0 *1 78.505,10.55 nfet_01v8
M$7906 167 556 3353 167 nfet_01v8 L=150000U W=210000U AS=21875000000P
+ AD=51200000000P PS=460000U PD=775000U
* device instance $7907 r0 *1 78.505,10.94 nfet_01v8
M$7907 556 3353 167 167 nfet_01v8 L=150000U W=210000U AS=51200000000P
+ AD=21875000000P PS=775000U PD=460000U
* device instance $7908 r0 *1 78.54,11.34 nfet_01v8
M$7908 114 137 556 167 nfet_01v8 L=150000U W=140000U AS=21875000000P
+ AD=16800000000P PS=460000U PD=380000U
* device instance $7909 r0 *1 89.44,5.41 nfet_01v8
M$7909 3388 134 130 167 nfet_01v8 L=150000U W=140000U AS=16800000000P
+ AD=21875000000P PS=380000U PD=460000U
* device instance $7910 r0 *1 89.405,5.81 nfet_01v8
M$7910 167 374 3388 167 nfet_01v8 L=150000U W=210000U AS=21875000000P
+ AD=51200000000P PS=460000U PD=775000U
* device instance $7911 r0 *1 89.405,6.2 nfet_01v8
M$7911 374 3388 167 167 nfet_01v8 L=150000U W=210000U AS=51200000000P
+ AD=21875000000P PS=775000U PD=460000U
* device instance $7912 r0 *1 89.44,6.6 nfet_01v8
M$7912 129 134 374 167 nfet_01v8 L=150000U W=140000U AS=21875000000P
+ AD=16800000000P PS=460000U PD=380000U
* device instance $7913 r0 *1 89.44,6.99 nfet_01v8
M$7913 3382 135 129 167 nfet_01v8 L=150000U W=140000U AS=16800000000P
+ AD=21875000000P PS=380000U PD=460000U
* device instance $7914 r0 *1 89.405,7.39 nfet_01v8
M$7914 167 204 3382 167 nfet_01v8 L=150000U W=210000U AS=21875000000P
+ AD=51200000000P PS=460000U PD=775000U
* device instance $7915 r0 *1 89.405,7.78 nfet_01v8
M$7915 204 3382 167 167 nfet_01v8 L=150000U W=210000U AS=51200000000P
+ AD=21875000000P PS=775000U PD=460000U
* device instance $7916 r0 *1 89.44,8.18 nfet_01v8
M$7916 130 135 204 167 nfet_01v8 L=150000U W=140000U AS=21875000000P
+ AD=16800000000P PS=460000U PD=380000U
* device instance $7917 r0 *1 89.44,8.57 nfet_01v8
M$7917 239 136 130 167 nfet_01v8 L=150000U W=140000U AS=16800000000P
+ AD=21875000000P PS=380000U PD=460000U
* device instance $7918 r0 *1 89.405,8.97 nfet_01v8
M$7918 167 205 239 167 nfet_01v8 L=150000U W=210000U AS=21875000000P
+ AD=51200000000P PS=460000U PD=775000U
* device instance $7919 r0 *1 89.405,9.36 nfet_01v8
M$7919 205 239 167 167 nfet_01v8 L=150000U W=210000U AS=51200000000P
+ AD=21875000000P PS=775000U PD=460000U
* device instance $7920 r0 *1 89.44,9.76 nfet_01v8
M$7920 129 136 205 167 nfet_01v8 L=150000U W=140000U AS=21875000000P
+ AD=16800000000P PS=460000U PD=380000U
* device instance $7921 r0 *1 89.44,10.15 nfet_01v8
M$7921 3354 137 129 167 nfet_01v8 L=150000U W=140000U AS=16800000000P
+ AD=21875000000P PS=380000U PD=460000U
* device instance $7922 r0 *1 89.405,10.55 nfet_01v8
M$7922 167 573 3354 167 nfet_01v8 L=150000U W=210000U AS=21875000000P
+ AD=51200000000P PS=460000U PD=775000U
* device instance $7923 r0 *1 89.405,10.94 nfet_01v8
M$7923 573 3354 167 167 nfet_01v8 L=150000U W=210000U AS=51200000000P
+ AD=21875000000P PS=775000U PD=460000U
* device instance $7924 r0 *1 89.44,11.34 nfet_01v8
M$7924 130 137 573 167 nfet_01v8 L=150000U W=140000U AS=21875000000P
+ AD=16800000000P PS=460000U PD=380000U
* device instance $7925 r0 *1 89.44,13.31 nfet_01v8
M$7925 3397 138 130 167 nfet_01v8 L=150000U W=140000U AS=16800000000P
+ AD=21875000000P PS=380000U PD=460000U
* device instance $7926 r0 *1 89.405,13.71 nfet_01v8
M$7926 167 540 3397 167 nfet_01v8 L=150000U W=210000U AS=21875000000P
+ AD=51200000000P PS=460000U PD=775000U
* device instance $7927 r0 *1 89.405,14.1 nfet_01v8
M$7927 540 3397 167 167 nfet_01v8 L=150000U W=210000U AS=51200000000P
+ AD=21875000000P PS=775000U PD=460000U
* device instance $7928 r0 *1 89.44,14.5 nfet_01v8
M$7928 129 138 540 167 nfet_01v8 L=150000U W=140000U AS=21875000000P
+ AD=16800000000P PS=460000U PD=380000U
* device instance $7929 r0 *1 89.44,14.89 nfet_01v8
M$7929 3392 139 129 167 nfet_01v8 L=150000U W=140000U AS=16800000000P
+ AD=21875000000P PS=380000U PD=460000U
* device instance $7930 r0 *1 89.405,15.29 nfet_01v8
M$7930 167 1989 3392 167 nfet_01v8 L=150000U W=210000U AS=21875000000P
+ AD=51200000000P PS=460000U PD=775000U
* device instance $7931 r0 *1 89.405,15.68 nfet_01v8
M$7931 1989 3392 167 167 nfet_01v8 L=150000U W=210000U AS=51200000000P
+ AD=21875000000P PS=775000U PD=460000U
* device instance $7932 r0 *1 89.44,16.08 nfet_01v8
M$7932 130 139 1989 167 nfet_01v8 L=150000U W=140000U AS=21875000000P
+ AD=16800000000P PS=460000U PD=380000U
* device instance $7933 r0 *1 89.44,16.47 nfet_01v8
M$7933 329 140 130 167 nfet_01v8 L=150000U W=140000U AS=16800000000P
+ AD=21875000000P PS=380000U PD=460000U
* device instance $7934 r0 *1 89.405,16.87 nfet_01v8
M$7934 167 528 329 167 nfet_01v8 L=150000U W=210000U AS=21875000000P
+ AD=51200000000P PS=460000U PD=775000U
* device instance $7935 r0 *1 89.405,17.26 nfet_01v8
M$7935 528 329 167 167 nfet_01v8 L=150000U W=210000U AS=51200000000P
+ AD=21875000000P PS=775000U PD=460000U
* device instance $7936 r0 *1 89.44,17.66 nfet_01v8
M$7936 129 140 528 167 nfet_01v8 L=150000U W=140000U AS=21875000000P
+ AD=16800000000P PS=460000U PD=380000U
* device instance $7937 r0 *1 89.44,18.05 nfet_01v8
M$7937 354 141 129 167 nfet_01v8 L=150000U W=140000U AS=16800000000P
+ AD=21875000000P PS=380000U PD=460000U
* device instance $7938 r0 *1 89.405,18.45 nfet_01v8
M$7938 167 571 354 167 nfet_01v8 L=150000U W=210000U AS=21875000000P
+ AD=51200000000P PS=460000U PD=775000U
* device instance $7939 r0 *1 89.405,18.84 nfet_01v8
M$7939 571 354 167 167 nfet_01v8 L=150000U W=210000U AS=51200000000P
+ AD=21875000000P PS=775000U PD=460000U
* device instance $7940 r0 *1 89.44,19.24 nfet_01v8
M$7940 130 141 571 167 nfet_01v8 L=150000U W=140000U AS=21875000000P
+ AD=16800000000P PS=460000U PD=380000U
* device instance $7941 r0 *1 24.04,29.11 nfet_01v8
M$7941 352 146 34 167 nfet_01v8 L=150000U W=140000U AS=16800000000P
+ AD=21875000000P PS=380000U PD=460000U
* device instance $7942 r0 *1 24.005,29.51 nfet_01v8
M$7942 167 569 352 167 nfet_01v8 L=150000U W=210000U AS=21875000000P
+ AD=51200000000P PS=460000U PD=775000U
* device instance $7943 r0 *1 24.005,29.9 nfet_01v8
M$7943 569 352 167 167 nfet_01v8 L=150000U W=210000U AS=51200000000P
+ AD=21875000000P PS=775000U PD=460000U
* device instance $7944 r0 *1 24.04,30.3 nfet_01v8
M$7944 33 146 569 167 nfet_01v8 L=150000U W=140000U AS=21875000000P
+ AD=16800000000P PS=460000U PD=380000U
* device instance $7945 r0 *1 24.04,30.69 nfet_01v8
M$7945 3260 147 33 167 nfet_01v8 L=150000U W=140000U AS=16800000000P
+ AD=21875000000P PS=380000U PD=460000U
* device instance $7946 r0 *1 24.005,31.09 nfet_01v8
M$7946 167 1972 3260 167 nfet_01v8 L=150000U W=210000U AS=21875000000P
+ AD=51200000000P PS=460000U PD=775000U
* device instance $7947 r0 *1 24.005,31.48 nfet_01v8
M$7947 1972 3260 167 167 nfet_01v8 L=150000U W=210000U AS=51200000000P
+ AD=21875000000P PS=775000U PD=460000U
* device instance $7948 r0 *1 24.04,31.88 nfet_01v8
M$7948 34 147 1972 167 nfet_01v8 L=150000U W=140000U AS=21875000000P
+ AD=16800000000P PS=460000U PD=380000U
* device instance $7949 r0 *1 24.04,32.27 nfet_01v8
M$7949 351 148 34 167 nfet_01v8 L=150000U W=140000U AS=16800000000P
+ AD=21875000000P PS=380000U PD=460000U
* device instance $7950 r0 *1 24.005,32.67 nfet_01v8
M$7950 167 564 351 167 nfet_01v8 L=150000U W=210000U AS=21875000000P
+ AD=51200000000P PS=460000U PD=775000U
* device instance $7951 r0 *1 24.005,33.06 nfet_01v8
M$7951 564 351 167 167 nfet_01v8 L=150000U W=210000U AS=51200000000P
+ AD=21875000000P PS=775000U PD=460000U
* device instance $7952 r0 *1 24.04,33.46 nfet_01v8
M$7952 33 148 564 167 nfet_01v8 L=150000U W=140000U AS=21875000000P
+ AD=16800000000P PS=460000U PD=380000U
* device instance $7953 r0 *1 24.04,33.85 nfet_01v8
M$7953 3286 149 33 167 nfet_01v8 L=150000U W=140000U AS=16800000000P
+ AD=21875000000P PS=380000U PD=460000U
* device instance $7954 r0 *1 24.005,34.25 nfet_01v8
M$7954 167 566 3286 167 nfet_01v8 L=150000U W=210000U AS=21875000000P
+ AD=51200000000P PS=460000U PD=775000U
* device instance $7955 r0 *1 24.005,34.64 nfet_01v8
M$7955 566 3286 167 167 nfet_01v8 L=150000U W=210000U AS=51200000000P
+ AD=21875000000P PS=775000U PD=460000U
* device instance $7956 r0 *1 24.04,35.04 nfet_01v8
M$7956 34 149 566 167 nfet_01v8 L=150000U W=140000U AS=21875000000P
+ AD=16800000000P PS=460000U PD=380000U
* device instance $7957 r0 *1 34.94,29.11 nfet_01v8
M$7957 3669 146 50 167 nfet_01v8 L=150000U W=140000U AS=16800000000P
+ AD=21875000000P PS=380000U PD=460000U
* device instance $7958 r0 *1 34.905,29.51 nfet_01v8
M$7958 167 508 3669 167 nfet_01v8 L=150000U W=210000U AS=21875000000P
+ AD=51200000000P PS=460000U PD=775000U
* device instance $7959 r0 *1 34.905,29.9 nfet_01v8
M$7959 508 3669 167 167 nfet_01v8 L=150000U W=210000U AS=51200000000P
+ AD=21875000000P PS=775000U PD=460000U
* device instance $7960 r0 *1 34.94,30.3 nfet_01v8
M$7960 49 146 508 167 nfet_01v8 L=150000U W=140000U AS=21875000000P
+ AD=16800000000P PS=460000U PD=380000U
* device instance $7961 r0 *1 34.94,30.69 nfet_01v8
M$7961 3660 147 49 167 nfet_01v8 L=150000U W=140000U AS=16800000000P
+ AD=21875000000P PS=380000U PD=460000U
* device instance $7962 r0 *1 34.905,31.09 nfet_01v8
M$7962 167 507 3660 167 nfet_01v8 L=150000U W=210000U AS=21875000000P
+ AD=51200000000P PS=460000U PD=775000U
* device instance $7963 r0 *1 34.905,31.48 nfet_01v8
M$7963 507 3660 167 167 nfet_01v8 L=150000U W=210000U AS=51200000000P
+ AD=21875000000P PS=775000U PD=460000U
* device instance $7964 r0 *1 34.94,31.88 nfet_01v8
M$7964 50 147 507 167 nfet_01v8 L=150000U W=140000U AS=21875000000P
+ AD=16800000000P PS=460000U PD=380000U
* device instance $7965 r0 *1 34.94,32.27 nfet_01v8
M$7965 3656 148 50 167 nfet_01v8 L=150000U W=140000U AS=16800000000P
+ AD=21875000000P PS=380000U PD=460000U
* device instance $7966 r0 *1 34.905,32.67 nfet_01v8
M$7966 167 534 3656 167 nfet_01v8 L=150000U W=210000U AS=21875000000P
+ AD=51200000000P PS=460000U PD=775000U
* device instance $7967 r0 *1 34.905,33.06 nfet_01v8
M$7967 534 3656 167 167 nfet_01v8 L=150000U W=210000U AS=51200000000P
+ AD=21875000000P PS=775000U PD=460000U
* device instance $7968 r0 *1 34.94,33.46 nfet_01v8
M$7968 49 148 534 167 nfet_01v8 L=150000U W=140000U AS=21875000000P
+ AD=16800000000P PS=460000U PD=380000U
* device instance $7969 r0 *1 34.94,33.85 nfet_01v8
M$7969 3655 149 49 167 nfet_01v8 L=150000U W=140000U AS=16800000000P
+ AD=21875000000P PS=380000U PD=460000U
* device instance $7970 r0 *1 34.905,34.25 nfet_01v8
M$7970 167 557 3655 167 nfet_01v8 L=150000U W=210000U AS=21875000000P
+ AD=51200000000P PS=460000U PD=775000U
* device instance $7971 r0 *1 34.905,34.64 nfet_01v8
M$7971 557 3655 167 167 nfet_01v8 L=150000U W=210000U AS=51200000000P
+ AD=21875000000P PS=775000U PD=460000U
* device instance $7972 r0 *1 34.94,35.04 nfet_01v8
M$7972 50 149 557 167 nfet_01v8 L=150000U W=140000U AS=21875000000P
+ AD=16800000000P PS=460000U PD=380000U
* device instance $7973 r0 *1 45.84,29.11 nfet_01v8
M$7973 3678 146 66 167 nfet_01v8 L=150000U W=140000U AS=16800000000P
+ AD=21875000000P PS=380000U PD=460000U
* device instance $7974 r0 *1 45.805,29.51 nfet_01v8
M$7974 167 500 3678 167 nfet_01v8 L=150000U W=210000U AS=21875000000P
+ AD=51200000000P PS=460000U PD=775000U
* device instance $7975 r0 *1 45.805,29.9 nfet_01v8
M$7975 500 3678 167 167 nfet_01v8 L=150000U W=210000U AS=51200000000P
+ AD=21875000000P PS=775000U PD=460000U
* device instance $7976 r0 *1 45.84,30.3 nfet_01v8
M$7976 65 146 500 167 nfet_01v8 L=150000U W=140000U AS=21875000000P
+ AD=16800000000P PS=460000U PD=380000U
* device instance $7977 r0 *1 45.84,30.69 nfet_01v8
M$7977 3649 147 65 167 nfet_01v8 L=150000U W=140000U AS=16800000000P
+ AD=21875000000P PS=380000U PD=460000U
* device instance $7978 r0 *1 45.805,31.09 nfet_01v8
M$7978 167 2006 3649 167 nfet_01v8 L=150000U W=210000U AS=21875000000P
+ AD=51200000000P PS=460000U PD=775000U
* device instance $7979 r0 *1 45.805,31.48 nfet_01v8
M$7979 2006 3649 167 167 nfet_01v8 L=150000U W=210000U AS=51200000000P
+ AD=21875000000P PS=775000U PD=460000U
* device instance $7980 r0 *1 45.84,31.88 nfet_01v8
M$7980 66 147 2006 167 nfet_01v8 L=150000U W=140000U AS=21875000000P
+ AD=16800000000P PS=460000U PD=380000U
* device instance $7981 r0 *1 45.84,32.27 nfet_01v8
M$7981 3680 148 66 167 nfet_01v8 L=150000U W=140000U AS=16800000000P
+ AD=21875000000P PS=380000U PD=460000U
* device instance $7982 r0 *1 45.805,32.67 nfet_01v8
M$7982 167 525 3680 167 nfet_01v8 L=150000U W=210000U AS=21875000000P
+ AD=51200000000P PS=460000U PD=775000U
* device instance $7983 r0 *1 45.805,33.06 nfet_01v8
M$7983 525 3680 167 167 nfet_01v8 L=150000U W=210000U AS=51200000000P
+ AD=21875000000P PS=775000U PD=460000U
* device instance $7984 r0 *1 45.84,33.46 nfet_01v8
M$7984 65 148 525 167 nfet_01v8 L=150000U W=140000U AS=21875000000P
+ AD=16800000000P PS=460000U PD=380000U
* device instance $7985 r0 *1 45.84,33.85 nfet_01v8
M$7985 330 149 65 167 nfet_01v8 L=150000U W=140000U AS=16800000000P
+ AD=21875000000P PS=380000U PD=460000U
* device instance $7986 r0 *1 45.805,34.25 nfet_01v8
M$7986 167 529 330 167 nfet_01v8 L=150000U W=210000U AS=21875000000P
+ AD=51200000000P PS=460000U PD=775000U
* device instance $7987 r0 *1 45.805,34.64 nfet_01v8
M$7987 529 330 167 167 nfet_01v8 L=150000U W=210000U AS=51200000000P
+ AD=21875000000P PS=775000U PD=460000U
* device instance $7988 r0 *1 45.84,35.04 nfet_01v8
M$7988 66 149 529 167 nfet_01v8 L=150000U W=140000U AS=21875000000P
+ AD=16800000000P PS=460000U PD=380000U
* device instance $7989 r0 *1 56.74,29.11 nfet_01v8
M$7989 3475 146 82 167 nfet_01v8 L=150000U W=140000U AS=16800000000P
+ AD=21875000000P PS=380000U PD=460000U
* device instance $7990 r0 *1 56.705,29.51 nfet_01v8
M$7990 167 472 3475 167 nfet_01v8 L=150000U W=210000U AS=21875000000P
+ AD=51200000000P PS=460000U PD=775000U
* device instance $7991 r0 *1 56.705,29.9 nfet_01v8
M$7991 472 3475 167 167 nfet_01v8 L=150000U W=210000U AS=51200000000P
+ AD=21875000000P PS=775000U PD=460000U
* device instance $7992 r0 *1 56.74,30.3 nfet_01v8
M$7992 81 146 472 167 nfet_01v8 L=150000U W=140000U AS=21875000000P
+ AD=16800000000P PS=460000U PD=380000U
* device instance $7993 r0 *1 56.74,30.69 nfet_01v8
M$7993 3476 147 81 167 nfet_01v8 L=150000U W=140000U AS=16800000000P
+ AD=21875000000P PS=380000U PD=460000U
* device instance $7994 r0 *1 56.705,31.09 nfet_01v8
M$7994 167 2049 3476 167 nfet_01v8 L=150000U W=210000U AS=21875000000P
+ AD=51200000000P PS=460000U PD=775000U
* device instance $7995 r0 *1 56.705,31.48 nfet_01v8
M$7995 2049 3476 167 167 nfet_01v8 L=150000U W=210000U AS=51200000000P
+ AD=21875000000P PS=775000U PD=460000U
* device instance $7996 r0 *1 56.74,31.88 nfet_01v8
M$7996 82 147 2049 167 nfet_01v8 L=150000U W=140000U AS=21875000000P
+ AD=16800000000P PS=460000U PD=380000U
* device instance $7997 r0 *1 56.74,32.27 nfet_01v8
M$7997 235 148 82 167 nfet_01v8 L=150000U W=140000U AS=16800000000P
+ AD=21875000000P PS=380000U PD=460000U
* device instance $7998 r0 *1 56.705,32.67 nfet_01v8
M$7998 167 189 235 167 nfet_01v8 L=150000U W=210000U AS=21875000000P
+ AD=51200000000P PS=460000U PD=775000U
* device instance $7999 r0 *1 56.705,33.06 nfet_01v8
M$7999 189 235 167 167 nfet_01v8 L=150000U W=210000U AS=51200000000P
+ AD=21875000000P PS=775000U PD=460000U
* device instance $8000 r0 *1 56.74,33.46 nfet_01v8
M$8000 81 148 189 167 nfet_01v8 L=150000U W=140000U AS=21875000000P
+ AD=16800000000P PS=460000U PD=380000U
* device instance $8001 r0 *1 56.74,33.85 nfet_01v8
M$8001 274 149 81 167 nfet_01v8 L=150000U W=140000U AS=16800000000P
+ AD=21875000000P PS=380000U PD=460000U
* device instance $8002 r0 *1 56.705,34.25 nfet_01v8
M$8002 167 413 274 167 nfet_01v8 L=150000U W=210000U AS=21875000000P
+ AD=51200000000P PS=460000U PD=775000U
* device instance $8003 r0 *1 56.705,34.64 nfet_01v8
M$8003 413 274 167 167 nfet_01v8 L=150000U W=210000U AS=51200000000P
+ AD=21875000000P PS=775000U PD=460000U
* device instance $8004 r0 *1 56.74,35.04 nfet_01v8
M$8004 82 149 413 167 nfet_01v8 L=150000U W=140000U AS=21875000000P
+ AD=16800000000P PS=460000U PD=380000U
* device instance $8005 r0 *1 67.64,29.11 nfet_01v8
M$8005 3466 146 98 167 nfet_01v8 L=150000U W=140000U AS=16800000000P
+ AD=21875000000P PS=380000U PD=460000U
* device instance $8006 r0 *1 67.605,29.51 nfet_01v8
M$8006 167 430 3466 167 nfet_01v8 L=150000U W=210000U AS=21875000000P
+ AD=51200000000P PS=460000U PD=775000U
* device instance $8007 r0 *1 67.605,29.9 nfet_01v8
M$8007 430 3466 167 167 nfet_01v8 L=150000U W=210000U AS=51200000000P
+ AD=21875000000P PS=775000U PD=460000U
* device instance $8008 r0 *1 67.64,30.3 nfet_01v8
M$8008 97 146 430 167 nfet_01v8 L=150000U W=140000U AS=21875000000P
+ AD=16800000000P PS=460000U PD=380000U
* device instance $8009 r0 *1 67.64,30.69 nfet_01v8
M$8009 3465 147 97 167 nfet_01v8 L=150000U W=140000U AS=16800000000P
+ AD=21875000000P PS=380000U PD=460000U
* device instance $8010 r0 *1 67.605,31.09 nfet_01v8
M$8010 167 428 3465 167 nfet_01v8 L=150000U W=210000U AS=21875000000P
+ AD=51200000000P PS=460000U PD=775000U
* device instance $8011 r0 *1 67.605,31.48 nfet_01v8
M$8011 428 3465 167 167 nfet_01v8 L=150000U W=210000U AS=51200000000P
+ AD=21875000000P PS=775000U PD=460000U
* device instance $8012 r0 *1 67.64,31.88 nfet_01v8
M$8012 98 147 428 167 nfet_01v8 L=150000U W=140000U AS=21875000000P
+ AD=16800000000P PS=460000U PD=380000U
* device instance $8013 r0 *1 67.64,32.27 nfet_01v8
M$8013 300 148 98 167 nfet_01v8 L=150000U W=140000U AS=16800000000P
+ AD=21875000000P PS=380000U PD=460000U
* device instance $8014 r0 *1 67.605,32.67 nfet_01v8
M$8014 167 465 300 167 nfet_01v8 L=150000U W=210000U AS=21875000000P
+ AD=51200000000P PS=460000U PD=775000U
* device instance $8015 r0 *1 67.605,33.06 nfet_01v8
M$8015 465 300 167 167 nfet_01v8 L=150000U W=210000U AS=51200000000P
+ AD=21875000000P PS=775000U PD=460000U
* device instance $8016 r0 *1 67.64,33.46 nfet_01v8
M$8016 97 148 465 167 nfet_01v8 L=150000U W=140000U AS=21875000000P
+ AD=16800000000P PS=460000U PD=380000U
* device instance $8017 r0 *1 67.64,33.85 nfet_01v8
M$8017 302 149 97 167 nfet_01v8 L=150000U W=140000U AS=16800000000P
+ AD=21875000000P PS=380000U PD=460000U
* device instance $8018 r0 *1 67.605,34.25 nfet_01v8
M$8018 167 470 302 167 nfet_01v8 L=150000U W=210000U AS=21875000000P
+ AD=51200000000P PS=460000U PD=775000U
* device instance $8019 r0 *1 67.605,34.64 nfet_01v8
M$8019 470 302 167 167 nfet_01v8 L=150000U W=210000U AS=51200000000P
+ AD=21875000000P PS=775000U PD=460000U
* device instance $8020 r0 *1 67.64,35.04 nfet_01v8
M$8020 98 149 470 167 nfet_01v8 L=150000U W=140000U AS=21875000000P
+ AD=16800000000P PS=460000U PD=380000U
* device instance $8021 r0 *1 78.54,29.11 nfet_01v8
M$8021 3436 146 114 167 nfet_01v8 L=150000U W=140000U AS=16800000000P
+ AD=21875000000P PS=380000U PD=460000U
* device instance $8022 r0 *1 78.505,29.51 nfet_01v8
M$8022 167 424 3436 167 nfet_01v8 L=150000U W=210000U AS=21875000000P
+ AD=51200000000P PS=460000U PD=775000U
* device instance $8023 r0 *1 78.505,29.9 nfet_01v8
M$8023 424 3436 167 167 nfet_01v8 L=150000U W=210000U AS=51200000000P
+ AD=21875000000P PS=775000U PD=460000U
* device instance $8024 r0 *1 78.54,30.3 nfet_01v8
M$8024 113 146 424 167 nfet_01v8 L=150000U W=140000U AS=21875000000P
+ AD=16800000000P PS=460000U PD=380000U
* device instance $8025 r0 *1 78.54,30.69 nfet_01v8
M$8025 3444 147 113 167 nfet_01v8 L=150000U W=140000U AS=16800000000P
+ AD=21875000000P PS=380000U PD=460000U
* device instance $8026 r0 *1 78.505,31.09 nfet_01v8
M$8026 167 466 3444 167 nfet_01v8 L=150000U W=210000U AS=21875000000P
+ AD=51200000000P PS=460000U PD=775000U
* device instance $8027 r0 *1 78.505,31.48 nfet_01v8
M$8027 466 3444 167 167 nfet_01v8 L=150000U W=210000U AS=51200000000P
+ AD=21875000000P PS=775000U PD=460000U
* device instance $8028 r0 *1 78.54,31.88 nfet_01v8
M$8028 114 147 466 167 nfet_01v8 L=150000U W=140000U AS=21875000000P
+ AD=16800000000P PS=460000U PD=380000U
* device instance $8029 r0 *1 78.54,32.27 nfet_01v8
M$8029 3428 148 114 167 nfet_01v8 L=150000U W=140000U AS=16800000000P
+ AD=21875000000P PS=380000U PD=460000U
* device instance $8030 r0 *1 78.505,32.67 nfet_01v8
M$8030 167 215 3428 167 nfet_01v8 L=150000U W=210000U AS=21875000000P
+ AD=51200000000P PS=460000U PD=775000U
* device instance $8031 r0 *1 78.505,33.06 nfet_01v8
M$8031 215 3428 167 167 nfet_01v8 L=150000U W=210000U AS=51200000000P
+ AD=21875000000P PS=775000U PD=460000U
* device instance $8032 r0 *1 78.54,33.46 nfet_01v8
M$8032 113 148 215 167 nfet_01v8 L=150000U W=140000U AS=21875000000P
+ AD=16800000000P PS=460000U PD=380000U
* device instance $8033 r0 *1 78.54,33.85 nfet_01v8
M$8033 263 149 113 167 nfet_01v8 L=150000U W=140000U AS=16800000000P
+ AD=21875000000P PS=380000U PD=460000U
* device instance $8034 r0 *1 78.505,34.25 nfet_01v8
M$8034 167 383 263 167 nfet_01v8 L=150000U W=210000U AS=21875000000P
+ AD=51200000000P PS=460000U PD=775000U
* device instance $8035 r0 *1 78.505,34.64 nfet_01v8
M$8035 383 263 167 167 nfet_01v8 L=150000U W=210000U AS=51200000000P
+ AD=21875000000P PS=775000U PD=460000U
* device instance $8036 r0 *1 78.54,35.04 nfet_01v8
M$8036 114 149 383 167 nfet_01v8 L=150000U W=140000U AS=21875000000P
+ AD=16800000000P PS=460000U PD=380000U
* device instance $8037 r0 *1 89.44,29.11 nfet_01v8
M$8037 3241 146 130 167 nfet_01v8 L=150000U W=140000U AS=16800000000P
+ AD=21875000000P PS=380000U PD=460000U
* device instance $8038 r0 *1 89.405,29.51 nfet_01v8
M$8038 167 358 3241 167 nfet_01v8 L=150000U W=210000U AS=21875000000P
+ AD=51200000000P PS=460000U PD=775000U
* device instance $8039 r0 *1 89.405,29.9 nfet_01v8
M$8039 358 3241 167 167 nfet_01v8 L=150000U W=210000U AS=51200000000P
+ AD=21875000000P PS=775000U PD=460000U
* device instance $8040 r0 *1 89.44,30.3 nfet_01v8
M$8040 129 146 358 167 nfet_01v8 L=150000U W=140000U AS=21875000000P
+ AD=16800000000P PS=460000U PD=380000U
* device instance $8041 r0 *1 89.44,30.69 nfet_01v8
M$8041 3426 147 129 167 nfet_01v8 L=150000U W=140000U AS=16800000000P
+ AD=21875000000P PS=380000U PD=460000U
* device instance $8042 r0 *1 89.405,31.09 nfet_01v8
M$8042 167 218 3426 167 nfet_01v8 L=150000U W=210000U AS=21875000000P
+ AD=51200000000P PS=460000U PD=775000U
* device instance $8043 r0 *1 89.405,31.48 nfet_01v8
M$8043 218 3426 167 167 nfet_01v8 L=150000U W=210000U AS=51200000000P
+ AD=21875000000P PS=775000U PD=460000U
* device instance $8044 r0 *1 89.44,31.88 nfet_01v8
M$8044 130 147 218 167 nfet_01v8 L=150000U W=140000U AS=21875000000P
+ AD=16800000000P PS=460000U PD=380000U
* device instance $8045 r0 *1 89.44,32.27 nfet_01v8
M$8045 3236 148 130 167 nfet_01v8 L=150000U W=140000U AS=16800000000P
+ AD=21875000000P PS=380000U PD=460000U
* device instance $8046 r0 *1 89.405,32.67 nfet_01v8
M$8046 167 384 3236 167 nfet_01v8 L=150000U W=210000U AS=21875000000P
+ AD=51200000000P PS=460000U PD=775000U
* device instance $8047 r0 *1 89.405,33.06 nfet_01v8
M$8047 384 3236 167 167 nfet_01v8 L=150000U W=210000U AS=51200000000P
+ AD=21875000000P PS=775000U PD=460000U
* device instance $8048 r0 *1 89.44,33.46 nfet_01v8
M$8048 129 148 384 167 nfet_01v8 L=150000U W=140000U AS=21875000000P
+ AD=16800000000P PS=460000U PD=380000U
* device instance $8049 r0 *1 89.44,33.85 nfet_01v8
M$8049 3237 149 129 167 nfet_01v8 L=150000U W=140000U AS=16800000000P
+ AD=21875000000P PS=380000U PD=460000U
* device instance $8050 r0 *1 89.405,34.25 nfet_01v8
M$8050 167 389 3237 167 nfet_01v8 L=150000U W=210000U AS=21875000000P
+ AD=51200000000P PS=460000U PD=775000U
* device instance $8051 r0 *1 89.405,34.64 nfet_01v8
M$8051 389 3237 167 167 nfet_01v8 L=150000U W=210000U AS=51200000000P
+ AD=21875000000P PS=775000U PD=460000U
* device instance $8052 r0 *1 89.44,35.04 nfet_01v8
M$8052 130 149 389 167 nfet_01v8 L=150000U W=140000U AS=21875000000P
+ AD=16800000000P PS=460000U PD=380000U
* device instance $8053 r0 *1 24.04,60.71 nfet_01v8
M$8053 321 162 34 167 nfet_01v8 L=150000U W=140000U AS=16800000000P
+ AD=21875000000P PS=380000U PD=460000U
* device instance $8054 r0 *1 24.005,61.11 nfet_01v8
M$8054 167 510 321 167 nfet_01v8 L=150000U W=210000U AS=21875000000P
+ AD=51200000000P PS=460000U PD=775000U
* device instance $8055 r0 *1 24.005,61.5 nfet_01v8
M$8055 510 321 167 167 nfet_01v8 L=150000U W=210000U AS=51200000000P
+ AD=21875000000P PS=775000U PD=460000U
* device instance $8056 r0 *1 24.04,61.9 nfet_01v8
M$8056 33 162 510 167 nfet_01v8 L=150000U W=140000U AS=21875000000P
+ AD=16800000000P PS=460000U PD=380000U
* device instance $8057 r0 *1 24.04,62.29 nfet_01v8
M$8057 3704 163 33 167 nfet_01v8 L=150000U W=140000U AS=16800000000P
+ AD=21875000000P PS=380000U PD=460000U
* device instance $8058 r0 *1 24.005,62.69 nfet_01v8
M$8058 167 1988 3704 167 nfet_01v8 L=150000U W=210000U AS=21875000000P
+ AD=51200000000P PS=460000U PD=775000U
* device instance $8059 r0 *1 24.005,63.08 nfet_01v8
M$8059 1988 3704 167 167 nfet_01v8 L=150000U W=210000U AS=51200000000P
+ AD=21875000000P PS=775000U PD=460000U
* device instance $8060 r0 *1 24.04,63.48 nfet_01v8
M$8060 34 163 1988 167 nfet_01v8 L=150000U W=140000U AS=21875000000P
+ AD=16800000000P PS=460000U PD=380000U
* device instance $8061 r0 *1 24.04,63.87 nfet_01v8
M$8061 226 164 34 167 nfet_01v8 L=150000U W=140000U AS=16800000000P
+ AD=21875000000P PS=380000U PD=460000U
* device instance $8062 r0 *1 24.005,64.27 nfet_01v8
M$8062 167 169 226 167 nfet_01v8 L=150000U W=210000U AS=21875000000P
+ AD=51200000000P PS=460000U PD=775000U
* device instance $8063 r0 *1 24.005,64.66 nfet_01v8
M$8063 169 226 167 167 nfet_01v8 L=150000U W=210000U AS=51200000000P
+ AD=21875000000P PS=775000U PD=460000U
* device instance $8064 r0 *1 24.04,65.06 nfet_01v8
M$8064 33 164 169 167 nfet_01v8 L=150000U W=140000U AS=21875000000P
+ AD=16800000000P PS=460000U PD=380000U
* device instance $8065 r0 *1 24.04,65.45 nfet_01v8
M$8065 328 165 33 167 nfet_01v8 L=150000U W=140000U AS=16800000000P
+ AD=21875000000P PS=380000U PD=460000U
* device instance $8066 r0 *1 24.005,65.85 nfet_01v8
M$8066 167 524 328 167 nfet_01v8 L=150000U W=210000U AS=21875000000P
+ AD=51200000000P PS=460000U PD=775000U
* device instance $8067 r0 *1 24.005,66.24 nfet_01v8
M$8067 524 328 167 167 nfet_01v8 L=150000U W=210000U AS=51200000000P
+ AD=21875000000P PS=775000U PD=460000U
* device instance $8068 r0 *1 24.04,66.64 nfet_01v8
M$8068 34 165 524 167 nfet_01v8 L=150000U W=140000U AS=21875000000P
+ AD=16800000000P PS=460000U PD=380000U
* device instance $8069 r0 *1 13.14,21.21 nfet_01v8
M$8069 340 142 18 167 nfet_01v8 L=150000U W=140000U AS=16800000000P
+ AD=21875000000P PS=380000U PD=460000U
* device instance $8070 r0 *1 13.105,21.61 nfet_01v8
M$8070 167 547 340 167 nfet_01v8 L=150000U W=210000U AS=21875000000P
+ AD=51200000000P PS=460000U PD=775000U
* device instance $8071 r0 *1 13.105,22 nfet_01v8
M$8071 547 340 167 167 nfet_01v8 L=150000U W=210000U AS=51200000000P
+ AD=21875000000P PS=775000U PD=460000U
* device instance $8072 r0 *1 13.14,22.4 nfet_01v8
M$8072 17 142 547 167 nfet_01v8 L=150000U W=140000U AS=21875000000P
+ AD=16800000000P PS=460000U PD=380000U
* device instance $8073 r0 *1 13.14,22.79 nfet_01v8
M$8073 3317 143 17 167 nfet_01v8 L=150000U W=140000U AS=16800000000P
+ AD=21875000000P PS=380000U PD=460000U
* device instance $8074 r0 *1 13.105,23.19 nfet_01v8
M$8074 167 554 3317 167 nfet_01v8 L=150000U W=210000U AS=21875000000P
+ AD=51200000000P PS=460000U PD=775000U
* device instance $8075 r0 *1 13.105,23.58 nfet_01v8
M$8075 554 3317 167 167 nfet_01v8 L=150000U W=210000U AS=51200000000P
+ AD=21875000000P PS=775000U PD=460000U
* device instance $8076 r0 *1 13.14,23.98 nfet_01v8
M$8076 18 143 554 167 nfet_01v8 L=150000U W=140000U AS=21875000000P
+ AD=16800000000P PS=460000U PD=380000U
* device instance $8077 r0 *1 13.14,24.37 nfet_01v8
M$8077 234 144 18 167 nfet_01v8 L=150000U W=140000U AS=16800000000P
+ AD=21875000000P PS=380000U PD=460000U
* device instance $8078 r0 *1 13.105,24.77 nfet_01v8
M$8078 167 188 234 167 nfet_01v8 L=150000U W=210000U AS=21875000000P
+ AD=51200000000P PS=460000U PD=775000U
* device instance $8079 r0 *1 13.105,25.16 nfet_01v8
M$8079 188 234 167 167 nfet_01v8 L=150000U W=210000U AS=51200000000P
+ AD=21875000000P PS=775000U PD=460000U
* device instance $8080 r0 *1 13.14,25.56 nfet_01v8
M$8080 17 144 188 167 nfet_01v8 L=150000U W=140000U AS=21875000000P
+ AD=16800000000P PS=460000U PD=380000U
* device instance $8081 r0 *1 13.14,25.95 nfet_01v8
M$8081 338 145 17 167 nfet_01v8 L=150000U W=140000U AS=16800000000P
+ AD=21875000000P PS=380000U PD=460000U
* device instance $8082 r0 *1 13.105,26.35 nfet_01v8
M$8082 167 545 338 167 nfet_01v8 L=150000U W=210000U AS=21875000000P
+ AD=51200000000P PS=460000U PD=775000U
* device instance $8083 r0 *1 13.105,26.74 nfet_01v8
M$8083 545 338 167 167 nfet_01v8 L=150000U W=210000U AS=51200000000P
+ AD=21875000000P PS=775000U PD=460000U
* device instance $8084 r0 *1 13.14,27.14 nfet_01v8
M$8084 18 145 545 167 nfet_01v8 L=150000U W=140000U AS=21875000000P
+ AD=16800000000P PS=460000U PD=380000U
* device instance $8085 r0 *1 24.04,21.21 nfet_01v8
M$8085 310 142 34 167 nfet_01v8 L=150000U W=140000U AS=16800000000P
+ AD=21875000000P PS=380000U PD=460000U
* device instance $8086 r0 *1 24.005,21.61 nfet_01v8
M$8086 167 489 310 167 nfet_01v8 L=150000U W=210000U AS=21875000000P
+ AD=51200000000P PS=460000U PD=775000U
* device instance $8087 r0 *1 24.005,22 nfet_01v8
M$8087 489 310 167 167 nfet_01v8 L=150000U W=210000U AS=51200000000P
+ AD=21875000000P PS=775000U PD=460000U
* device instance $8088 r0 *1 24.04,22.4 nfet_01v8
M$8088 33 142 489 167 nfet_01v8 L=150000U W=140000U AS=21875000000P
+ AD=16800000000P PS=460000U PD=380000U
* device instance $8089 r0 *1 24.04,22.79 nfet_01v8
M$8089 3327 143 33 167 nfet_01v8 L=150000U W=140000U AS=16800000000P
+ AD=21875000000P PS=380000U PD=460000U
* device instance $8090 r0 *1 24.005,23.19 nfet_01v8
M$8090 167 2007 3327 167 nfet_01v8 L=150000U W=210000U AS=21875000000P
+ AD=51200000000P PS=460000U PD=775000U
* device instance $8091 r0 *1 24.005,23.58 nfet_01v8
M$8091 2007 3327 167 167 nfet_01v8 L=150000U W=210000U AS=51200000000P
+ AD=21875000000P PS=775000U PD=460000U
* device instance $8092 r0 *1 24.04,23.98 nfet_01v8
M$8092 34 143 2007 167 nfet_01v8 L=150000U W=140000U AS=21875000000P
+ AD=16800000000P PS=460000U PD=380000U
* device instance $8093 r0 *1 24.04,24.37 nfet_01v8
M$8093 317 144 34 167 nfet_01v8 L=150000U W=140000U AS=16800000000P
+ AD=21875000000P PS=380000U PD=460000U
* device instance $8094 r0 *1 24.005,24.77 nfet_01v8
M$8094 167 502 317 167 nfet_01v8 L=150000U W=210000U AS=21875000000P
+ AD=51200000000P PS=460000U PD=775000U
* device instance $8095 r0 *1 24.005,25.16 nfet_01v8
M$8095 502 317 167 167 nfet_01v8 L=150000U W=210000U AS=51200000000P
+ AD=21875000000P PS=775000U PD=460000U
* device instance $8096 r0 *1 24.04,25.56 nfet_01v8
M$8096 33 144 502 167 nfet_01v8 L=150000U W=140000U AS=21875000000P
+ AD=16800000000P PS=460000U PD=380000U
* device instance $8097 r0 *1 24.04,25.95 nfet_01v8
M$8097 3320 145 33 167 nfet_01v8 L=150000U W=140000U AS=16800000000P
+ AD=21875000000P PS=380000U PD=460000U
* device instance $8098 r0 *1 24.005,26.35 nfet_01v8
M$8098 167 494 3320 167 nfet_01v8 L=150000U W=210000U AS=21875000000P
+ AD=51200000000P PS=460000U PD=775000U
* device instance $8099 r0 *1 24.005,26.74 nfet_01v8
M$8099 494 3320 167 167 nfet_01v8 L=150000U W=210000U AS=51200000000P
+ AD=21875000000P PS=775000U PD=460000U
* device instance $8100 r0 *1 24.04,27.14 nfet_01v8
M$8100 34 145 494 167 nfet_01v8 L=150000U W=140000U AS=21875000000P
+ AD=16800000000P PS=460000U PD=380000U
* device instance $8101 r0 *1 34.94,21.21 nfet_01v8
M$8101 3272 142 50 167 nfet_01v8 L=150000U W=140000U AS=16800000000P
+ AD=21875000000P PS=380000U PD=460000U
* device instance $8102 r0 *1 34.905,21.61 nfet_01v8
M$8102 167 561 3272 167 nfet_01v8 L=150000U W=210000U AS=21875000000P
+ AD=51200000000P PS=460000U PD=775000U
* device instance $8103 r0 *1 34.905,22 nfet_01v8
M$8103 561 3272 167 167 nfet_01v8 L=150000U W=210000U AS=51200000000P
+ AD=21875000000P PS=775000U PD=460000U
* device instance $8104 r0 *1 34.94,22.4 nfet_01v8
M$8104 49 142 561 167 nfet_01v8 L=150000U W=140000U AS=21875000000P
+ AD=16800000000P PS=460000U PD=380000U
* device instance $8105 r0 *1 34.94,22.79 nfet_01v8
M$8105 3703 143 49 167 nfet_01v8 L=150000U W=140000U AS=16800000000P
+ AD=21875000000P PS=380000U PD=460000U
* device instance $8106 r0 *1 34.905,23.19 nfet_01v8
M$8106 167 173 3703 167 nfet_01v8 L=150000U W=210000U AS=21875000000P
+ AD=51200000000P PS=460000U PD=775000U
* device instance $8107 r0 *1 34.905,23.58 nfet_01v8
M$8107 173 3703 167 167 nfet_01v8 L=150000U W=210000U AS=51200000000P
+ AD=21875000000P PS=775000U PD=460000U
* device instance $8108 r0 *1 34.94,23.98 nfet_01v8
M$8108 50 143 173 167 nfet_01v8 L=150000U W=140000U AS=21875000000P
+ AD=16800000000P PS=460000U PD=380000U
* device instance $8109 r0 *1 34.94,24.37 nfet_01v8
M$8109 228 144 50 167 nfet_01v8 L=150000U W=140000U AS=16800000000P
+ AD=21875000000P PS=380000U PD=460000U
* device instance $8110 r0 *1 34.905,24.77 nfet_01v8
M$8110 167 172 228 167 nfet_01v8 L=150000U W=210000U AS=21875000000P
+ AD=51200000000P PS=460000U PD=775000U
* device instance $8111 r0 *1 34.905,25.16 nfet_01v8
M$8111 172 228 167 167 nfet_01v8 L=150000U W=210000U AS=51200000000P
+ AD=21875000000P PS=775000U PD=460000U
* device instance $8112 r0 *1 34.94,25.56 nfet_01v8
M$8112 49 144 172 167 nfet_01v8 L=150000U W=140000U AS=21875000000P
+ AD=16800000000P PS=460000U PD=380000U
* device instance $8113 r0 *1 34.94,25.95 nfet_01v8
M$8113 3665 145 49 167 nfet_01v8 L=150000U W=140000U AS=16800000000P
+ AD=21875000000P PS=380000U PD=460000U
* device instance $8114 r0 *1 34.905,26.35 nfet_01v8
M$8114 167 552 3665 167 nfet_01v8 L=150000U W=210000U AS=21875000000P
+ AD=51200000000P PS=460000U PD=775000U
* device instance $8115 r0 *1 34.905,26.74 nfet_01v8
M$8115 552 3665 167 167 nfet_01v8 L=150000U W=210000U AS=51200000000P
+ AD=21875000000P PS=775000U PD=460000U
* device instance $8116 r0 *1 34.94,27.14 nfet_01v8
M$8116 50 145 552 167 nfet_01v8 L=150000U W=140000U AS=21875000000P
+ AD=16800000000P PS=460000U PD=380000U
* device instance $8117 r0 *1 45.84,21.21 nfet_01v8
M$8117 3282 142 66 167 nfet_01v8 L=150000U W=140000U AS=16800000000P
+ AD=21875000000P PS=380000U PD=460000U
* device instance $8118 r0 *1 45.805,21.61 nfet_01v8
M$8118 167 576 3282 167 nfet_01v8 L=150000U W=210000U AS=21875000000P
+ AD=51200000000P PS=460000U PD=775000U
* device instance $8119 r0 *1 45.805,22 nfet_01v8
M$8119 576 3282 167 167 nfet_01v8 L=150000U W=210000U AS=51200000000P
+ AD=21875000000P PS=775000U PD=460000U
* device instance $8120 r0 *1 45.84,22.4 nfet_01v8
M$8120 65 142 576 167 nfet_01v8 L=150000U W=140000U AS=21875000000P
+ AD=16800000000P PS=460000U PD=380000U
* device instance $8121 r0 *1 45.84,22.79 nfet_01v8
M$8121 3283 143 65 167 nfet_01v8 L=150000U W=140000U AS=16800000000P
+ AD=21875000000P PS=380000U PD=460000U
* device instance $8122 r0 *1 45.805,23.19 nfet_01v8
M$8122 167 493 3283 167 nfet_01v8 L=150000U W=210000U AS=21875000000P
+ AD=51200000000P PS=460000U PD=775000U
* device instance $8123 r0 *1 45.805,23.58 nfet_01v8
M$8123 493 3283 167 167 nfet_01v8 L=150000U W=210000U AS=51200000000P
+ AD=21875000000P PS=775000U PD=460000U
* device instance $8124 r0 *1 45.84,23.98 nfet_01v8
M$8124 66 143 493 167 nfet_01v8 L=150000U W=140000U AS=21875000000P
+ AD=16800000000P PS=460000U PD=380000U
* device instance $8125 r0 *1 45.84,24.37 nfet_01v8
M$8125 3273 144 66 167 nfet_01v8 L=150000U W=140000U AS=16800000000P
+ AD=21875000000P PS=380000U PD=460000U
* device instance $8126 r0 *1 45.805,24.77 nfet_01v8
M$8126 167 178 3273 167 nfet_01v8 L=150000U W=210000U AS=21875000000P
+ AD=51200000000P PS=460000U PD=775000U
* device instance $8127 r0 *1 45.805,25.16 nfet_01v8
M$8127 178 3273 167 167 nfet_01v8 L=150000U W=210000U AS=51200000000P
+ AD=21875000000P PS=775000U PD=460000U
* device instance $8128 r0 *1 45.84,25.56 nfet_01v8
M$8128 65 144 178 167 nfet_01v8 L=150000U W=140000U AS=21875000000P
+ AD=16800000000P PS=460000U PD=380000U
* device instance $8129 r0 *1 45.84,25.95 nfet_01v8
M$8129 3274 145 65 167 nfet_01v8 L=150000U W=140000U AS=16800000000P
+ AD=21875000000P PS=380000U PD=460000U
* device instance $8130 r0 *1 45.805,26.35 nfet_01v8
M$8130 167 521 3274 167 nfet_01v8 L=150000U W=210000U AS=21875000000P
+ AD=51200000000P PS=460000U PD=775000U
* device instance $8131 r0 *1 45.805,26.74 nfet_01v8
M$8131 521 3274 167 167 nfet_01v8 L=150000U W=210000U AS=51200000000P
+ AD=21875000000P PS=775000U PD=460000U
* device instance $8132 r0 *1 45.84,27.14 nfet_01v8
M$8132 66 145 521 167 nfet_01v8 L=150000U W=140000U AS=21875000000P
+ AD=16800000000P PS=460000U PD=380000U
* device instance $8133 r0 *1 56.74,21.21 nfet_01v8
M$8133 3449 142 82 167 nfet_01v8 L=150000U W=140000U AS=16800000000P
+ AD=21875000000P PS=380000U PD=460000U
* device instance $8134 r0 *1 56.705,21.61 nfet_01v8
M$8134 167 395 3449 167 nfet_01v8 L=150000U W=210000U AS=21875000000P
+ AD=51200000000P PS=460000U PD=775000U
* device instance $8135 r0 *1 56.705,22 nfet_01v8
M$8135 395 3449 167 167 nfet_01v8 L=150000U W=210000U AS=51200000000P
+ AD=21875000000P PS=775000U PD=460000U
* device instance $8136 r0 *1 56.74,22.4 nfet_01v8
M$8136 81 142 395 167 nfet_01v8 L=150000U W=140000U AS=21875000000P
+ AD=16800000000P PS=460000U PD=380000U
* device instance $8137 r0 *1 56.74,22.79 nfet_01v8
M$8137 3448 143 81 167 nfet_01v8 L=150000U W=140000U AS=16800000000P
+ AD=21875000000P PS=380000U PD=460000U
* device instance $8138 r0 *1 56.705,23.19 nfet_01v8
M$8138 167 441 3448 167 nfet_01v8 L=150000U W=210000U AS=21875000000P
+ AD=51200000000P PS=460000U PD=775000U
* device instance $8139 r0 *1 56.705,23.58 nfet_01v8
M$8139 441 3448 167 167 nfet_01v8 L=150000U W=210000U AS=51200000000P
+ AD=21875000000P PS=775000U PD=460000U
* device instance $8140 r0 *1 56.74,23.98 nfet_01v8
M$8140 82 143 441 167 nfet_01v8 L=150000U W=140000U AS=21875000000P
+ AD=16800000000P PS=460000U PD=380000U
* device instance $8141 r0 *1 56.74,24.37 nfet_01v8
M$8141 3478 144 82 167 nfet_01v8 L=150000U W=140000U AS=16800000000P
+ AD=21875000000P PS=380000U PD=460000U
* device instance $8142 r0 *1 56.705,24.77 nfet_01v8
M$8142 167 182 3478 167 nfet_01v8 L=150000U W=210000U AS=21875000000P
+ AD=51200000000P PS=460000U PD=775000U
* device instance $8143 r0 *1 56.705,25.16 nfet_01v8
M$8143 182 3478 167 167 nfet_01v8 L=150000U W=210000U AS=51200000000P
+ AD=21875000000P PS=775000U PD=460000U
* device instance $8144 r0 *1 56.74,25.56 nfet_01v8
M$8144 81 144 182 167 nfet_01v8 L=150000U W=140000U AS=21875000000P
+ AD=16800000000P PS=460000U PD=380000U
* device instance $8145 r0 *1 56.74,25.95 nfet_01v8
M$8145 3480 145 81 167 nfet_01v8 L=150000U W=140000U AS=16800000000P
+ AD=21875000000P PS=380000U PD=460000U
* device instance $8146 r0 *1 56.705,26.35 nfet_01v8
M$8146 167 375 3480 167 nfet_01v8 L=150000U W=210000U AS=21875000000P
+ AD=51200000000P PS=460000U PD=775000U
* device instance $8147 r0 *1 56.705,26.74 nfet_01v8
M$8147 375 3480 167 167 nfet_01v8 L=150000U W=210000U AS=51200000000P
+ AD=21875000000P PS=775000U PD=460000U
* device instance $8148 r0 *1 56.74,27.14 nfet_01v8
M$8148 82 145 375 167 nfet_01v8 L=150000U W=140000U AS=21875000000P
+ AD=16800000000P PS=460000U PD=380000U
* device instance $8149 r0 *1 67.64,21.21 nfet_01v8
M$8149 304 142 98 167 nfet_01v8 L=150000U W=140000U AS=16800000000P
+ AD=21875000000P PS=380000U PD=460000U
* device instance $8150 r0 *1 67.605,21.61 nfet_01v8
M$8150 167 473 304 167 nfet_01v8 L=150000U W=210000U AS=21875000000P
+ AD=51200000000P PS=460000U PD=775000U
* device instance $8151 r0 *1 67.605,22 nfet_01v8
M$8151 473 304 167 167 nfet_01v8 L=150000U W=210000U AS=51200000000P
+ AD=21875000000P PS=775000U PD=460000U
* device instance $8152 r0 *1 67.64,22.4 nfet_01v8
M$8152 97 142 473 167 nfet_01v8 L=150000U W=140000U AS=21875000000P
+ AD=16800000000P PS=460000U PD=380000U
* device instance $8153 r0 *1 67.64,22.79 nfet_01v8
M$8153 3456 143 97 167 nfet_01v8 L=150000U W=140000U AS=16800000000P
+ AD=21875000000P PS=380000U PD=460000U
* device instance $8154 r0 *1 67.605,23.19 nfet_01v8
M$8154 167 183 3456 167 nfet_01v8 L=150000U W=210000U AS=21875000000P
+ AD=51200000000P PS=460000U PD=775000U
* device instance $8155 r0 *1 67.605,23.58 nfet_01v8
M$8155 183 3456 167 167 nfet_01v8 L=150000U W=210000U AS=51200000000P
+ AD=21875000000P PS=775000U PD=460000U
* device instance $8156 r0 *1 67.64,23.98 nfet_01v8
M$8156 98 143 183 167 nfet_01v8 L=150000U W=140000U AS=21875000000P
+ AD=16800000000P PS=460000U PD=380000U
* device instance $8157 r0 *1 67.64,24.37 nfet_01v8
M$8157 3453 144 98 167 nfet_01v8 L=150000U W=140000U AS=16800000000P
+ AD=21875000000P PS=380000U PD=460000U
* device instance $8158 r0 *1 67.605,24.77 nfet_01v8
M$8158 167 415 3453 167 nfet_01v8 L=150000U W=210000U AS=21875000000P
+ AD=51200000000P PS=460000U PD=775000U
* device instance $8159 r0 *1 67.605,25.16 nfet_01v8
M$8159 415 3453 167 167 nfet_01v8 L=150000U W=210000U AS=51200000000P
+ AD=21875000000P PS=775000U PD=460000U
* device instance $8160 r0 *1 67.64,25.56 nfet_01v8
M$8160 97 144 415 167 nfet_01v8 L=150000U W=140000U AS=21875000000P
+ AD=16800000000P PS=460000U PD=380000U
* device instance $8161 r0 *1 67.64,25.95 nfet_01v8
M$8161 347 145 97 167 nfet_01v8 L=150000U W=140000U AS=16800000000P
+ AD=21875000000P PS=380000U PD=460000U
* device instance $8162 r0 *1 67.605,26.35 nfet_01v8
M$8162 167 559 347 167 nfet_01v8 L=150000U W=210000U AS=21875000000P
+ AD=51200000000P PS=460000U PD=775000U
* device instance $8163 r0 *1 67.605,26.74 nfet_01v8
M$8163 559 347 167 167 nfet_01v8 L=150000U W=210000U AS=51200000000P
+ AD=21875000000P PS=775000U PD=460000U
* device instance $8164 r0 *1 67.64,27.14 nfet_01v8
M$8164 98 145 559 167 nfet_01v8 L=150000U W=140000U AS=21875000000P
+ AD=16800000000P PS=460000U PD=380000U
* device instance $8165 r0 *1 78.54,21.21 nfet_01v8
M$8165 281 142 114 167 nfet_01v8 L=150000U W=140000U AS=16800000000P
+ AD=21875000000P PS=380000U PD=460000U
* device instance $8166 r0 *1 78.505,21.61 nfet_01v8
M$8166 167 423 281 167 nfet_01v8 L=150000U W=210000U AS=21875000000P
+ AD=51200000000P PS=460000U PD=775000U
* device instance $8167 r0 *1 78.505,22 nfet_01v8
M$8167 423 281 167 167 nfet_01v8 L=150000U W=210000U AS=51200000000P
+ AD=21875000000P PS=775000U PD=460000U
* device instance $8168 r0 *1 78.54,22.4 nfet_01v8
M$8168 113 142 423 167 nfet_01v8 L=150000U W=140000U AS=21875000000P
+ AD=16800000000P PS=460000U PD=380000U
* device instance $8169 r0 *1 78.54,22.79 nfet_01v8
M$8169 3408 143 113 167 nfet_01v8 L=150000U W=140000U AS=16800000000P
+ AD=21875000000P PS=380000U PD=460000U
* device instance $8170 r0 *1 78.505,23.19 nfet_01v8
M$8170 167 207 3408 167 nfet_01v8 L=150000U W=210000U AS=21875000000P
+ AD=51200000000P PS=460000U PD=775000U
* device instance $8171 r0 *1 78.505,23.58 nfet_01v8
M$8171 207 3408 167 167 nfet_01v8 L=150000U W=210000U AS=51200000000P
+ AD=21875000000P PS=775000U PD=460000U
* device instance $8172 r0 *1 78.54,23.98 nfet_01v8
M$8172 114 143 207 167 nfet_01v8 L=150000U W=140000U AS=21875000000P
+ AD=16800000000P PS=460000U PD=380000U
* device instance $8173 r0 *1 78.54,24.37 nfet_01v8
M$8173 277 144 114 167 nfet_01v8 L=150000U W=140000U AS=16800000000P
+ AD=21875000000P PS=380000U PD=460000U
* device instance $8174 r0 *1 78.505,24.77 nfet_01v8
M$8174 167 418 277 167 nfet_01v8 L=150000U W=210000U AS=21875000000P
+ AD=51200000000P PS=460000U PD=775000U
* device instance $8175 r0 *1 78.505,25.16 nfet_01v8
M$8175 418 277 167 167 nfet_01v8 L=150000U W=210000U AS=51200000000P
+ AD=21875000000P PS=775000U PD=460000U
* device instance $8176 r0 *1 78.54,25.56 nfet_01v8
M$8176 113 144 418 167 nfet_01v8 L=150000U W=140000U AS=21875000000P
+ AD=16800000000P PS=460000U PD=380000U
* device instance $8177 r0 *1 78.54,25.95 nfet_01v8
M$8177 3438 145 113 167 nfet_01v8 L=150000U W=140000U AS=16800000000P
+ AD=21875000000P PS=380000U PD=460000U
* device instance $8178 r0 *1 78.505,26.35 nfet_01v8
M$8178 167 414 3438 167 nfet_01v8 L=150000U W=210000U AS=21875000000P
+ AD=51200000000P PS=460000U PD=775000U
* device instance $8179 r0 *1 78.505,26.74 nfet_01v8
M$8179 414 3438 167 167 nfet_01v8 L=150000U W=210000U AS=51200000000P
+ AD=21875000000P PS=775000U PD=460000U
* device instance $8180 r0 *1 78.54,27.14 nfet_01v8
M$8180 114 145 414 167 nfet_01v8 L=150000U W=140000U AS=21875000000P
+ AD=16800000000P PS=460000U PD=380000U
* device instance $8181 r0 *1 13.14,13.31 nfet_01v8
M$8181 3212 138 18 167 nfet_01v8 L=150000U W=140000U AS=16800000000P
+ AD=21875000000P PS=380000U PD=460000U
* device instance $8182 r0 *1 13.105,13.71 nfet_01v8
M$8182 167 361 3212 167 nfet_01v8 L=150000U W=210000U AS=21875000000P
+ AD=51200000000P PS=460000U PD=775000U
* device instance $8183 r0 *1 13.105,14.1 nfet_01v8
M$8183 361 3212 167 167 nfet_01v8 L=150000U W=210000U AS=51200000000P
+ AD=21875000000P PS=775000U PD=460000U
* device instance $8184 r0 *1 13.14,14.5 nfet_01v8
M$8184 17 138 361 167 nfet_01v8 L=150000U W=140000U AS=21875000000P
+ AD=16800000000P PS=460000U PD=380000U
* device instance $8185 r0 *1 13.14,14.89 nfet_01v8
M$8185 3310 139 17 167 nfet_01v8 L=150000U W=140000U AS=16800000000P
+ AD=21875000000P PS=380000U PD=460000U
* device instance $8186 r0 *1 13.105,15.29 nfet_01v8
M$8186 167 366 3310 167 nfet_01v8 L=150000U W=210000U AS=21875000000P
+ AD=51200000000P PS=460000U PD=775000U
* device instance $8187 r0 *1 13.105,15.68 nfet_01v8
M$8187 366 3310 167 167 nfet_01v8 L=150000U W=210000U AS=51200000000P
+ AD=21875000000P PS=775000U PD=460000U
* device instance $8188 r0 *1 13.14,16.08 nfet_01v8
M$8188 18 139 366 167 nfet_01v8 L=150000U W=140000U AS=21875000000P
+ AD=16800000000P PS=460000U PD=380000U
* device instance $8189 r0 *1 13.14,16.47 nfet_01v8
M$8189 3205 140 18 167 nfet_01v8 L=150000U W=140000U AS=16800000000P
+ AD=21875000000P PS=380000U PD=460000U
* device instance $8190 r0 *1 13.105,16.87 nfet_01v8
M$8190 167 357 3205 167 nfet_01v8 L=150000U W=210000U AS=21875000000P
+ AD=51200000000P PS=460000U PD=775000U
* device instance $8191 r0 *1 13.105,17.26 nfet_01v8
M$8191 357 3205 167 167 nfet_01v8 L=150000U W=210000U AS=51200000000P
+ AD=21875000000P PS=775000U PD=460000U
* device instance $8192 r0 *1 13.14,17.66 nfet_01v8
M$8192 17 140 357 167 nfet_01v8 L=150000U W=140000U AS=21875000000P
+ AD=16800000000P PS=460000U PD=380000U
* device instance $8193 r0 *1 13.14,18.05 nfet_01v8
M$8193 259 141 17 167 nfet_01v8 L=150000U W=140000U AS=16800000000P
+ AD=21875000000P PS=380000U PD=460000U
* device instance $8194 r0 *1 13.105,18.45 nfet_01v8
M$8194 167 379 259 167 nfet_01v8 L=150000U W=210000U AS=21875000000P
+ AD=51200000000P PS=460000U PD=775000U
* device instance $8195 r0 *1 13.105,18.84 nfet_01v8
M$8195 379 259 167 167 nfet_01v8 L=150000U W=210000U AS=51200000000P
+ AD=21875000000P PS=775000U PD=460000U
* device instance $8196 r0 *1 13.14,19.24 nfet_01v8
M$8196 18 141 379 167 nfet_01v8 L=150000U W=140000U AS=21875000000P
+ AD=16800000000P PS=460000U PD=380000U
* device instance $8197 r0 *1 89.44,21.21 nfet_01v8
M$8197 3419 142 130 167 nfet_01v8 L=150000U W=140000U AS=16800000000P
+ AD=21875000000P PS=380000U PD=460000U
* device instance $8198 r0 *1 89.405,21.61 nfet_01v8
M$8198 167 408 3419 167 nfet_01v8 L=150000U W=210000U AS=21875000000P
+ AD=51200000000P PS=460000U PD=775000U
* device instance $8199 r0 *1 89.405,22 nfet_01v8
M$8199 408 3419 167 167 nfet_01v8 L=150000U W=210000U AS=51200000000P
+ AD=21875000000P PS=775000U PD=460000U
* device instance $8200 r0 *1 89.44,22.4 nfet_01v8
M$8200 129 142 408 167 nfet_01v8 L=150000U W=140000U AS=21875000000P
+ AD=16800000000P PS=460000U PD=380000U
* device instance $8201 r0 *1 89.44,22.79 nfet_01v8
M$8201 3417 143 129 167 nfet_01v8 L=150000U W=140000U AS=16800000000P
+ AD=21875000000P PS=380000U PD=460000U
* device instance $8202 r0 *1 89.405,23.19 nfet_01v8
M$8202 167 462 3417 167 nfet_01v8 L=150000U W=210000U AS=21875000000P
+ AD=51200000000P PS=460000U PD=775000U
* device instance $8203 r0 *1 89.405,23.58 nfet_01v8
M$8203 462 3417 167 167 nfet_01v8 L=150000U W=210000U AS=51200000000P
+ AD=21875000000P PS=775000U PD=460000U
* device instance $8204 r0 *1 89.44,23.98 nfet_01v8
M$8204 130 143 462 167 nfet_01v8 L=150000U W=140000U AS=21875000000P
+ AD=16800000000P PS=460000U PD=380000U
* device instance $8205 r0 *1 89.44,24.37 nfet_01v8
M$8205 3411 144 130 167 nfet_01v8 L=150000U W=140000U AS=16800000000P
+ AD=21875000000P PS=380000U PD=460000U
* device instance $8206 r0 *1 89.405,24.77 nfet_01v8
M$8206 167 360 3411 167 nfet_01v8 L=150000U W=210000U AS=21875000000P
+ AD=51200000000P PS=460000U PD=775000U
* device instance $8207 r0 *1 89.405,25.16 nfet_01v8
M$8207 360 3411 167 167 nfet_01v8 L=150000U W=210000U AS=51200000000P
+ AD=21875000000P PS=775000U PD=460000U
* device instance $8208 r0 *1 89.44,25.56 nfet_01v8
M$8208 129 144 360 167 nfet_01v8 L=150000U W=140000U AS=21875000000P
+ AD=16800000000P PS=460000U PD=380000U
* device instance $8209 r0 *1 89.44,25.95 nfet_01v8
M$8209 248 145 129 167 nfet_01v8 L=150000U W=140000U AS=16800000000P
+ AD=21875000000P PS=380000U PD=460000U
* device instance $8210 r0 *1 89.405,26.35 nfet_01v8
M$8210 167 363 248 167 nfet_01v8 L=150000U W=210000U AS=21875000000P
+ AD=51200000000P PS=460000U PD=775000U
* device instance $8211 r0 *1 89.405,26.74 nfet_01v8
M$8211 363 248 167 167 nfet_01v8 L=150000U W=210000U AS=51200000000P
+ AD=21875000000P PS=775000U PD=460000U
* device instance $8212 r0 *1 89.44,27.14 nfet_01v8
M$8212 130 145 363 167 nfet_01v8 L=150000U W=140000U AS=21875000000P
+ AD=16800000000P PS=460000U PD=380000U
* device instance $8213 r0 *1 2.24,60.71 nfet_01v8
M$8213 282 162 2 167 nfet_01v8 L=150000U W=140000U AS=16800000000P
+ AD=21875000000P PS=380000U PD=460000U
* device instance $8214 r0 *1 2.205,61.11 nfet_01v8
M$8214 167 425 282 167 nfet_01v8 L=150000U W=210000U AS=21875000000P
+ AD=51200000000P PS=460000U PD=775000U
* device instance $8215 r0 *1 2.205,61.5 nfet_01v8
M$8215 425 282 167 167 nfet_01v8 L=150000U W=210000U AS=51200000000P
+ AD=21875000000P PS=775000U PD=460000U
* device instance $8216 r0 *1 2.24,61.9 nfet_01v8
M$8216 1 162 425 167 nfet_01v8 L=150000U W=140000U AS=21875000000P
+ AD=16800000000P PS=460000U PD=380000U
* device instance $8217 r0 *1 2.24,62.29 nfet_01v8
M$8217 3712 163 1 167 nfet_01v8 L=150000U W=140000U AS=16800000000P
+ AD=21875000000P PS=380000U PD=460000U
* device instance $8218 r0 *1 2.205,62.69 nfet_01v8
M$8218 167 214 3712 167 nfet_01v8 L=150000U W=210000U AS=21875000000P
+ AD=51200000000P PS=460000U PD=775000U
* device instance $8219 r0 *1 2.205,63.08 nfet_01v8
M$8219 214 3712 167 167 nfet_01v8 L=150000U W=210000U AS=51200000000P
+ AD=21875000000P PS=775000U PD=460000U
* device instance $8220 r0 *1 2.24,63.48 nfet_01v8
M$8220 2 163 214 167 nfet_01v8 L=150000U W=140000U AS=21875000000P
+ AD=16800000000P PS=460000U PD=380000U
* device instance $8221 r0 *1 2.24,63.87 nfet_01v8
M$8221 3719 164 2 167 nfet_01v8 L=150000U W=140000U AS=16800000000P
+ AD=21875000000P PS=380000U PD=460000U
* device instance $8222 r0 *1 2.205,64.27 nfet_01v8
M$8222 167 216 3719 167 nfet_01v8 L=150000U W=210000U AS=21875000000P
+ AD=51200000000P PS=460000U PD=775000U
* device instance $8223 r0 *1 2.205,64.66 nfet_01v8
M$8223 216 3719 167 167 nfet_01v8 L=150000U W=210000U AS=51200000000P
+ AD=21875000000P PS=775000U PD=460000U
* device instance $8224 r0 *1 2.24,65.06 nfet_01v8
M$8224 1 164 216 167 nfet_01v8 L=150000U W=140000U AS=21875000000P
+ AD=16800000000P PS=460000U PD=380000U
* device instance $8225 r0 *1 2.24,65.45 nfet_01v8
M$8225 261 165 1 167 nfet_01v8 L=150000U W=140000U AS=16800000000P
+ AD=21875000000P PS=380000U PD=460000U
* device instance $8226 r0 *1 2.205,65.85 nfet_01v8
M$8226 167 381 261 167 nfet_01v8 L=150000U W=210000U AS=21875000000P
+ AD=51200000000P PS=460000U PD=775000U
* device instance $8227 r0 *1 2.205,66.24 nfet_01v8
M$8227 381 261 167 167 nfet_01v8 L=150000U W=210000U AS=51200000000P
+ AD=21875000000P PS=775000U PD=460000U
* device instance $8228 r0 *1 2.24,66.64 nfet_01v8
M$8228 2 165 381 167 nfet_01v8 L=150000U W=140000U AS=21875000000P
+ AD=16800000000P PS=460000U PD=380000U
* device instance $8229 r0 *1 13.14,60.71 nfet_01v8
M$8229 3689 162 18 167 nfet_01v8 L=150000U W=140000U AS=16800000000P
+ AD=21875000000P PS=380000U PD=460000U
* device instance $8230 r0 *1 13.105,61.11 nfet_01v8
M$8230 167 501 3689 167 nfet_01v8 L=150000U W=210000U AS=21875000000P
+ AD=51200000000P PS=460000U PD=775000U
* device instance $8231 r0 *1 13.105,61.5 nfet_01v8
M$8231 501 3689 167 167 nfet_01v8 L=150000U W=210000U AS=51200000000P
+ AD=21875000000P PS=775000U PD=460000U
* device instance $8232 r0 *1 13.14,61.9 nfet_01v8
M$8232 17 162 501 167 nfet_01v8 L=150000U W=140000U AS=21875000000P
+ AD=16800000000P PS=460000U PD=380000U
* device instance $8233 r0 *1 13.14,62.29 nfet_01v8
M$8233 3714 163 17 167 nfet_01v8 L=150000U W=140000U AS=16800000000P
+ AD=21875000000P PS=380000U PD=460000U
* device instance $8234 r0 *1 13.105,62.69 nfet_01v8
M$8234 167 198 3714 167 nfet_01v8 L=150000U W=210000U AS=21875000000P
+ AD=51200000000P PS=460000U PD=775000U
* device instance $8235 r0 *1 13.105,63.08 nfet_01v8
M$8235 198 3714 167 167 nfet_01v8 L=150000U W=210000U AS=51200000000P
+ AD=21875000000P PS=775000U PD=460000U
* device instance $8236 r0 *1 13.14,63.48 nfet_01v8
M$8236 18 163 198 167 nfet_01v8 L=150000U W=140000U AS=21875000000P
+ AD=16800000000P PS=460000U PD=380000U
* device instance $8237 r0 *1 13.14,63.87 nfet_01v8
M$8237 241 164 18 167 nfet_01v8 L=150000U W=140000U AS=16800000000P
+ AD=21875000000P PS=380000U PD=460000U
* device instance $8238 r0 *1 13.105,64.27 nfet_01v8
M$8238 167 208 241 167 nfet_01v8 L=150000U W=210000U AS=21875000000P
+ AD=51200000000P PS=460000U PD=775000U
* device instance $8239 r0 *1 13.105,64.66 nfet_01v8
M$8239 208 241 167 167 nfet_01v8 L=150000U W=210000U AS=51200000000P
+ AD=21875000000P PS=775000U PD=460000U
* device instance $8240 r0 *1 13.14,65.06 nfet_01v8
M$8240 17 164 208 167 nfet_01v8 L=150000U W=140000U AS=21875000000P
+ AD=16800000000P PS=460000U PD=380000U
* device instance $8241 r0 *1 13.14,65.45 nfet_01v8
M$8241 318 165 17 167 nfet_01v8 L=150000U W=140000U AS=16800000000P
+ AD=21875000000P PS=380000U PD=460000U
* device instance $8242 r0 *1 13.105,65.85 nfet_01v8
M$8242 167 503 318 167 nfet_01v8 L=150000U W=210000U AS=21875000000P
+ AD=51200000000P PS=460000U PD=775000U
* device instance $8243 r0 *1 13.105,66.24 nfet_01v8
M$8243 503 318 167 167 nfet_01v8 L=150000U W=210000U AS=51200000000P
+ AD=21875000000P PS=775000U PD=460000U
* device instance $8244 r0 *1 13.14,66.64 nfet_01v8
M$8244 18 165 503 167 nfet_01v8 L=150000U W=140000U AS=21875000000P
+ AD=16800000000P PS=460000U PD=380000U
* device instance $8245 r0 *1 2.24,52.81 nfet_01v8
M$8245 341 158 2 167 nfet_01v8 L=150000U W=140000U AS=16800000000P
+ AD=21875000000P PS=380000U PD=460000U
* device instance $8246 r0 *1 2.205,53.21 nfet_01v8
M$8246 167 548 341 167 nfet_01v8 L=150000U W=210000U AS=21875000000P
+ AD=51200000000P PS=460000U PD=775000U
* device instance $8247 r0 *1 2.205,53.6 nfet_01v8
M$8247 548 341 167 167 nfet_01v8 L=150000U W=210000U AS=51200000000P
+ AD=21875000000P PS=775000U PD=460000U
* device instance $8248 r0 *1 2.24,54 nfet_01v8
M$8248 1 158 548 167 nfet_01v8 L=150000U W=140000U AS=21875000000P
+ AD=16800000000P PS=460000U PD=380000U
* device instance $8249 r0 *1 2.24,54.39 nfet_01v8
M$8249 3690 159 1 167 nfet_01v8 L=150000U W=140000U AS=16800000000P
+ AD=21875000000P PS=380000U PD=460000U
* device instance $8250 r0 *1 2.205,54.79 nfet_01v8
M$8250 167 2054 3690 167 nfet_01v8 L=150000U W=210000U AS=21875000000P
+ AD=51200000000P PS=460000U PD=775000U
* device instance $8251 r0 *1 2.205,55.18 nfet_01v8
M$8251 2054 3690 167 167 nfet_01v8 L=150000U W=210000U AS=51200000000P
+ AD=21875000000P PS=775000U PD=460000U
* device instance $8252 r0 *1 2.24,55.58 nfet_01v8
M$8252 2 159 2054 167 nfet_01v8 L=150000U W=140000U AS=21875000000P
+ AD=16800000000P PS=460000U PD=380000U
* device instance $8253 r0 *1 2.24,55.97 nfet_01v8
M$8253 225 160 2 167 nfet_01v8 L=150000U W=140000U AS=16800000000P
+ AD=21875000000P PS=380000U PD=460000U
* device instance $8254 r0 *1 2.205,56.37 nfet_01v8
M$8254 167 168 225 167 nfet_01v8 L=150000U W=210000U AS=21875000000P
+ AD=51200000000P PS=460000U PD=775000U
* device instance $8255 r0 *1 2.205,56.76 nfet_01v8
M$8255 168 225 167 167 nfet_01v8 L=150000U W=210000U AS=51200000000P
+ AD=21875000000P PS=775000U PD=460000U
* device instance $8256 r0 *1 2.24,57.16 nfet_01v8
M$8256 1 160 168 167 nfet_01v8 L=150000U W=140000U AS=21875000000P
+ AD=16800000000P PS=460000U PD=380000U
* device instance $8257 r0 *1 2.24,57.55 nfet_01v8
M$8257 294 161 1 167 nfet_01v8 L=150000U W=140000U AS=16800000000P
+ AD=21875000000P PS=380000U PD=460000U
* device instance $8258 r0 *1 2.205,57.95 nfet_01v8
M$8258 167 454 294 167 nfet_01v8 L=150000U W=210000U AS=21875000000P
+ AD=51200000000P PS=460000U PD=775000U
* device instance $8259 r0 *1 2.205,58.34 nfet_01v8
M$8259 454 294 167 167 nfet_01v8 L=150000U W=210000U AS=51200000000P
+ AD=21875000000P PS=775000U PD=460000U
* device instance $8260 r0 *1 2.24,58.74 nfet_01v8
M$8260 2 161 454 167 nfet_01v8 L=150000U W=140000U AS=21875000000P
+ AD=16800000000P PS=460000U PD=380000U
* device instance $8261 r0 *1 2.24,44.91 nfet_01v8
M$8261 272 154 2 167 nfet_01v8 L=150000U W=140000U AS=16800000000P
+ AD=21875000000P PS=380000U PD=460000U
* device instance $8262 r0 *1 2.205,45.31 nfet_01v8
M$8262 167 411 272 167 nfet_01v8 L=150000U W=210000U AS=21875000000P
+ AD=51200000000P PS=460000U PD=775000U
* device instance $8263 r0 *1 2.205,45.7 nfet_01v8
M$8263 411 272 167 167 nfet_01v8 L=150000U W=210000U AS=51200000000P
+ AD=21875000000P PS=775000U PD=460000U
* device instance $8264 r0 *1 2.24,46.1 nfet_01v8
M$8264 1 154 411 167 nfet_01v8 L=150000U W=140000U AS=21875000000P
+ AD=16800000000P PS=460000U PD=380000U
* device instance $8265 r0 *1 2.24,46.49 nfet_01v8
M$8265 3754 155 1 167 nfet_01v8 L=150000U W=140000U AS=16800000000P
+ AD=21875000000P PS=380000U PD=460000U
* device instance $8266 r0 *1 2.205,46.89 nfet_01v8
M$8266 167 410 3754 167 nfet_01v8 L=150000U W=210000U AS=21875000000P
+ AD=51200000000P PS=460000U PD=775000U
* device instance $8267 r0 *1 2.205,47.28 nfet_01v8
M$8267 410 3754 167 167 nfet_01v8 L=150000U W=210000U AS=51200000000P
+ AD=21875000000P PS=775000U PD=460000U
* device instance $8268 r0 *1 2.24,47.68 nfet_01v8
M$8268 2 155 410 167 nfet_01v8 L=150000U W=140000U AS=21875000000P
+ AD=16800000000P PS=460000U PD=380000U
* device instance $8269 r0 *1 2.24,48.07 nfet_01v8
M$8269 280 156 2 167 nfet_01v8 L=150000U W=140000U AS=16800000000P
+ AD=21875000000P PS=380000U PD=460000U
* device instance $8270 r0 *1 2.205,48.47 nfet_01v8
M$8270 167 422 280 167 nfet_01v8 L=150000U W=210000U AS=21875000000P
+ AD=51200000000P PS=460000U PD=775000U
* device instance $8271 r0 *1 2.205,48.86 nfet_01v8
M$8271 422 280 167 167 nfet_01v8 L=150000U W=210000U AS=51200000000P
+ AD=21875000000P PS=775000U PD=460000U
* device instance $8272 r0 *1 2.24,49.26 nfet_01v8
M$8272 1 156 422 167 nfet_01v8 L=150000U W=140000U AS=21875000000P
+ AD=16800000000P PS=460000U PD=380000U
* device instance $8273 r0 *1 2.24,49.65 nfet_01v8
M$8273 298 157 1 167 nfet_01v8 L=150000U W=140000U AS=16800000000P
+ AD=21875000000P PS=380000U PD=460000U
* device instance $8274 r0 *1 2.205,50.05 nfet_01v8
M$8274 167 461 298 167 nfet_01v8 L=150000U W=210000U AS=21875000000P
+ AD=51200000000P PS=460000U PD=775000U
* device instance $8275 r0 *1 2.205,50.44 nfet_01v8
M$8275 461 298 167 167 nfet_01v8 L=150000U W=210000U AS=51200000000P
+ AD=21875000000P PS=775000U PD=460000U
* device instance $8276 r0 *1 2.24,50.84 nfet_01v8
M$8276 2 157 461 167 nfet_01v8 L=150000U W=140000U AS=21875000000P
+ AD=16800000000P PS=460000U PD=380000U
* device instance $8277 r0 *1 2.24,37.01 nfet_01v8
M$8277 285 150 2 167 nfet_01v8 L=150000U W=140000U AS=16800000000P
+ AD=21875000000P PS=380000U PD=460000U
* device instance $8278 r0 *1 2.205,37.41 nfet_01v8
M$8278 167 438 285 167 nfet_01v8 L=150000U W=210000U AS=21875000000P
+ AD=51200000000P PS=460000U PD=775000U
* device instance $8279 r0 *1 2.205,37.8 nfet_01v8
M$8279 438 285 167 167 nfet_01v8 L=150000U W=210000U AS=51200000000P
+ AD=21875000000P PS=775000U PD=460000U
* device instance $8280 r0 *1 2.24,38.2 nfet_01v8
M$8280 1 150 438 167 nfet_01v8 L=150000U W=140000U AS=21875000000P
+ AD=16800000000P PS=460000U PD=380000U
* device instance $8281 r0 *1 2.24,38.59 nfet_01v8
M$8281 3731 151 1 167 nfet_01v8 L=150000U W=140000U AS=16800000000P
+ AD=21875000000P PS=380000U PD=460000U
* device instance $8282 r0 *1 2.205,38.99 nfet_01v8
M$8282 167 429 3731 167 nfet_01v8 L=150000U W=210000U AS=21875000000P
+ AD=51200000000P PS=460000U PD=775000U
* device instance $8283 r0 *1 2.205,39.38 nfet_01v8
M$8283 429 3731 167 167 nfet_01v8 L=150000U W=210000U AS=51200000000P
+ AD=21875000000P PS=775000U PD=460000U
* device instance $8284 r0 *1 2.24,39.78 nfet_01v8
M$8284 2 151 429 167 nfet_01v8 L=150000U W=140000U AS=21875000000P
+ AD=16800000000P PS=460000U PD=380000U
* device instance $8285 r0 *1 2.24,40.17 nfet_01v8
M$8285 291 152 2 167 nfet_01v8 L=150000U W=140000U AS=16800000000P
+ AD=21875000000P PS=380000U PD=460000U
* device instance $8286 r0 *1 2.205,40.57 nfet_01v8
M$8286 167 445 291 167 nfet_01v8 L=150000U W=210000U AS=21875000000P
+ AD=51200000000P PS=460000U PD=775000U
* device instance $8287 r0 *1 2.205,40.96 nfet_01v8
M$8287 445 291 167 167 nfet_01v8 L=150000U W=210000U AS=51200000000P
+ AD=21875000000P PS=775000U PD=460000U
* device instance $8288 r0 *1 2.24,41.36 nfet_01v8
M$8288 1 152 445 167 nfet_01v8 L=150000U W=140000U AS=21875000000P
+ AD=16800000000P PS=460000U PD=380000U
* device instance $8289 r0 *1 2.24,41.75 nfet_01v8
M$8289 273 153 1 167 nfet_01v8 L=150000U W=140000U AS=16800000000P
+ AD=21875000000P PS=380000U PD=460000U
* device instance $8290 r0 *1 2.205,42.15 nfet_01v8
M$8290 167 412 273 167 nfet_01v8 L=150000U W=210000U AS=21875000000P
+ AD=51200000000P PS=460000U PD=775000U
* device instance $8291 r0 *1 2.205,42.54 nfet_01v8
M$8291 412 273 167 167 nfet_01v8 L=150000U W=210000U AS=51200000000P
+ AD=21875000000P PS=775000U PD=460000U
* device instance $8292 r0 *1 2.24,42.94 nfet_01v8
M$8292 2 153 412 167 nfet_01v8 L=150000U W=140000U AS=21875000000P
+ AD=16800000000P PS=460000U PD=380000U
* device instance $8293 r0 *1 2.24,29.11 nfet_01v8
M$8293 353 146 2 167 nfet_01v8 L=150000U W=140000U AS=16800000000P
+ AD=21875000000P PS=380000U PD=460000U
* device instance $8294 r0 *1 2.205,29.51 nfet_01v8
M$8294 167 570 353 167 nfet_01v8 L=150000U W=210000U AS=21875000000P
+ AD=51200000000P PS=460000U PD=775000U
* device instance $8295 r0 *1 2.205,29.9 nfet_01v8
M$8295 570 353 167 167 nfet_01v8 L=150000U W=210000U AS=51200000000P
+ AD=21875000000P PS=775000U PD=460000U
* device instance $8296 r0 *1 2.24,30.3 nfet_01v8
M$8296 1 146 570 167 nfet_01v8 L=150000U W=140000U AS=21875000000P
+ AD=16800000000P PS=460000U PD=380000U
* device instance $8297 r0 *1 2.24,30.69 nfet_01v8
M$8297 3266 147 1 167 nfet_01v8 L=150000U W=140000U AS=16800000000P
+ AD=21875000000P PS=380000U PD=460000U
* device instance $8298 r0 *1 2.205,31.09 nfet_01v8
M$8298 167 2000 3266 167 nfet_01v8 L=150000U W=210000U AS=21875000000P
+ AD=51200000000P PS=460000U PD=775000U
* device instance $8299 r0 *1 2.205,31.48 nfet_01v8
M$8299 2000 3266 167 167 nfet_01v8 L=150000U W=210000U AS=51200000000P
+ AD=21875000000P PS=775000U PD=460000U
* device instance $8300 r0 *1 2.24,31.88 nfet_01v8
M$8300 2 147 2000 167 nfet_01v8 L=150000U W=140000U AS=21875000000P
+ AD=16800000000P PS=460000U PD=380000U
* device instance $8301 r0 *1 2.24,32.27 nfet_01v8
M$8301 316 148 2 167 nfet_01v8 L=150000U W=140000U AS=16800000000P
+ AD=21875000000P PS=380000U PD=460000U
* device instance $8302 r0 *1 2.205,32.67 nfet_01v8
M$8302 167 498 316 167 nfet_01v8 L=150000U W=210000U AS=21875000000P
+ AD=51200000000P PS=460000U PD=775000U
* device instance $8303 r0 *1 2.205,33.06 nfet_01v8
M$8303 498 316 167 167 nfet_01v8 L=150000U W=210000U AS=51200000000P
+ AD=21875000000P PS=775000U PD=460000U
* device instance $8304 r0 *1 2.24,33.46 nfet_01v8
M$8304 1 148 498 167 nfet_01v8 L=150000U W=140000U AS=21875000000P
+ AD=16800000000P PS=460000U PD=380000U
* device instance $8305 r0 *1 2.24,33.85 nfet_01v8
M$8305 3262 149 1 167 nfet_01v8 L=150000U W=140000U AS=16800000000P
+ AD=21875000000P PS=380000U PD=460000U
* device instance $8306 r0 *1 2.205,34.25 nfet_01v8
M$8306 167 474 3262 167 nfet_01v8 L=150000U W=210000U AS=21875000000P
+ AD=51200000000P PS=460000U PD=775000U
* device instance $8307 r0 *1 2.205,34.64 nfet_01v8
M$8307 474 3262 167 167 nfet_01v8 L=150000U W=210000U AS=51200000000P
+ AD=21875000000P PS=775000U PD=460000U
* device instance $8308 r0 *1 2.24,35.04 nfet_01v8
M$8308 2 149 474 167 nfet_01v8 L=150000U W=140000U AS=21875000000P
+ AD=16800000000P PS=460000U PD=380000U
* device instance $8309 r0 *1 2.24,21.21 nfet_01v8
M$8309 3313 142 2 167 nfet_01v8 L=150000U W=140000U AS=16800000000P
+ AD=21875000000P PS=380000U PD=460000U
* device instance $8310 r0 *1 2.205,21.61 nfet_01v8
M$8310 167 394 3313 167 nfet_01v8 L=150000U W=210000U AS=21875000000P
+ AD=51200000000P PS=460000U PD=775000U
* device instance $8311 r0 *1 2.205,22 nfet_01v8
M$8311 394 3313 167 167 nfet_01v8 L=150000U W=210000U AS=51200000000P
+ AD=21875000000P PS=775000U PD=460000U
* device instance $8312 r0 *1 2.24,22.4 nfet_01v8
M$8312 1 142 394 167 nfet_01v8 L=150000U W=140000U AS=21875000000P
+ AD=16800000000P PS=460000U PD=380000U
* device instance $8313 r0 *1 2.24,22.79 nfet_01v8
M$8313 3314 143 1 167 nfet_01v8 L=150000U W=140000U AS=16800000000P
+ AD=21875000000P PS=380000U PD=460000U
* device instance $8314 r0 *1 2.205,23.19 nfet_01v8
M$8314 167 184 3314 167 nfet_01v8 L=150000U W=210000U AS=21875000000P
+ AD=51200000000P PS=460000U PD=775000U
* device instance $8315 r0 *1 2.205,23.58 nfet_01v8
M$8315 184 3314 167 167 nfet_01v8 L=150000U W=210000U AS=51200000000P
+ AD=21875000000P PS=775000U PD=460000U
* device instance $8316 r0 *1 2.24,23.98 nfet_01v8
M$8316 2 143 184 167 nfet_01v8 L=150000U W=140000U AS=21875000000P
+ AD=16800000000P PS=460000U PD=380000U
* device instance $8317 r0 *1 2.24,24.37 nfet_01v8
M$8317 3311 144 2 167 nfet_01v8 L=150000U W=140000U AS=16800000000P
+ AD=21875000000P PS=380000U PD=460000U
* device instance $8318 r0 *1 2.205,24.77 nfet_01v8
M$8318 167 399 3311 167 nfet_01v8 L=150000U W=210000U AS=21875000000P
+ AD=51200000000P PS=460000U PD=775000U
* device instance $8319 r0 *1 2.205,25.16 nfet_01v8
M$8319 399 3311 167 167 nfet_01v8 L=150000U W=210000U AS=51200000000P
+ AD=21875000000P PS=775000U PD=460000U
* device instance $8320 r0 *1 2.24,25.56 nfet_01v8
M$8320 1 144 399 167 nfet_01v8 L=150000U W=140000U AS=21875000000P
+ AD=16800000000P PS=460000U PD=380000U
* device instance $8321 r0 *1 2.24,25.95 nfet_01v8
M$8321 3312 145 1 167 nfet_01v8 L=150000U W=140000U AS=16800000000P
+ AD=21875000000P PS=380000U PD=460000U
* device instance $8322 r0 *1 2.205,26.35 nfet_01v8
M$8322 167 401 3312 167 nfet_01v8 L=150000U W=210000U AS=21875000000P
+ AD=51200000000P PS=460000U PD=775000U
* device instance $8323 r0 *1 2.205,26.74 nfet_01v8
M$8323 401 3312 167 167 nfet_01v8 L=150000U W=210000U AS=51200000000P
+ AD=21875000000P PS=775000U PD=460000U
* device instance $8324 r0 *1 2.24,27.14 nfet_01v8
M$8324 2 145 401 167 nfet_01v8 L=150000U W=140000U AS=21875000000P
+ AD=16800000000P PS=460000U PD=380000U
* device instance $8325 r0 *1 2.24,13.31 nfet_01v8
M$8325 276 138 2 167 nfet_01v8 L=150000U W=140000U AS=16800000000P
+ AD=21875000000P PS=380000U PD=460000U
* device instance $8326 r0 *1 2.205,13.71 nfet_01v8
M$8326 167 417 276 167 nfet_01v8 L=150000U W=210000U AS=21875000000P
+ AD=51200000000P PS=460000U PD=775000U
* device instance $8327 r0 *1 2.205,14.1 nfet_01v8
M$8327 417 276 167 167 nfet_01v8 L=150000U W=210000U AS=51200000000P
+ AD=21875000000P PS=775000U PD=460000U
* device instance $8328 r0 *1 2.24,14.5 nfet_01v8
M$8328 1 138 417 167 nfet_01v8 L=150000U W=140000U AS=21875000000P
+ AD=16800000000P PS=460000U PD=380000U
* device instance $8329 r0 *1 2.24,14.89 nfet_01v8
M$8329 3309 139 1 167 nfet_01v8 L=150000U W=140000U AS=16800000000P
+ AD=21875000000P PS=380000U PD=460000U
* device instance $8330 r0 *1 2.205,15.29 nfet_01v8
M$8330 167 196 3309 167 nfet_01v8 L=150000U W=210000U AS=21875000000P
+ AD=51200000000P PS=460000U PD=775000U
* device instance $8331 r0 *1 2.205,15.68 nfet_01v8
M$8331 196 3309 167 167 nfet_01v8 L=150000U W=210000U AS=51200000000P
+ AD=21875000000P PS=775000U PD=460000U
* device instance $8332 r0 *1 2.24,16.08 nfet_01v8
M$8332 2 139 196 167 nfet_01v8 L=150000U W=140000U AS=21875000000P
+ AD=16800000000P PS=460000U PD=380000U
* device instance $8333 r0 *1 2.24,16.47 nfet_01v8
M$8333 3208 140 2 167 nfet_01v8 L=150000U W=140000U AS=16800000000P
+ AD=21875000000P PS=380000U PD=460000U
* device instance $8334 r0 *1 2.205,16.87 nfet_01v8
M$8334 167 186 3208 167 nfet_01v8 L=150000U W=210000U AS=21875000000P
+ AD=51200000000P PS=460000U PD=775000U
* device instance $8335 r0 *1 2.205,17.26 nfet_01v8
M$8335 186 3208 167 167 nfet_01v8 L=150000U W=210000U AS=51200000000P
+ AD=21875000000P PS=775000U PD=460000U
* device instance $8336 r0 *1 2.24,17.66 nfet_01v8
M$8336 1 140 186 167 nfet_01v8 L=150000U W=140000U AS=21875000000P
+ AD=16800000000P PS=460000U PD=380000U
* device instance $8337 r0 *1 2.24,18.05 nfet_01v8
M$8337 3209 141 1 167 nfet_01v8 L=150000U W=140000U AS=16800000000P
+ AD=21875000000P PS=380000U PD=460000U
* device instance $8338 r0 *1 2.205,18.45 nfet_01v8
M$8338 167 420 3209 167 nfet_01v8 L=150000U W=210000U AS=21875000000P
+ AD=51200000000P PS=460000U PD=775000U
* device instance $8339 r0 *1 2.205,18.84 nfet_01v8
M$8339 420 3209 167 167 nfet_01v8 L=150000U W=210000U AS=51200000000P
+ AD=21875000000P PS=775000U PD=460000U
* device instance $8340 r0 *1 2.24,19.24 nfet_01v8
M$8340 2 141 420 167 nfet_01v8 L=150000U W=140000U AS=21875000000P
+ AD=16800000000P PS=460000U PD=380000U
* device instance $8341 r0 *1 2.24,5.41 nfet_01v8
M$8341 3220 134 2 167 nfet_01v8 L=150000U W=140000U AS=16800000000P
+ AD=21875000000P PS=380000U PD=460000U
* device instance $8342 r0 *1 2.205,5.81 nfet_01v8
M$8342 167 436 3220 167 nfet_01v8 L=150000U W=210000U AS=21875000000P
+ AD=51200000000P PS=460000U PD=775000U
* device instance $8343 r0 *1 2.205,6.2 nfet_01v8
M$8343 436 3220 167 167 nfet_01v8 L=150000U W=210000U AS=51200000000P
+ AD=21875000000P PS=775000U PD=460000U
* device instance $8344 r0 *1 2.24,6.6 nfet_01v8
M$8344 1 134 436 167 nfet_01v8 L=150000U W=140000U AS=21875000000P
+ AD=16800000000P PS=460000U PD=380000U
* device instance $8345 r0 *1 2.24,6.99 nfet_01v8
M$8345 3218 135 1 167 nfet_01v8 L=150000U W=140000U AS=16800000000P
+ AD=21875000000P PS=380000U PD=460000U
* device instance $8346 r0 *1 2.205,7.39 nfet_01v8
M$8346 167 433 3218 167 nfet_01v8 L=150000U W=210000U AS=21875000000P
+ AD=51200000000P PS=460000U PD=775000U
* device instance $8347 r0 *1 2.205,7.78 nfet_01v8
M$8347 433 3218 167 167 nfet_01v8 L=150000U W=210000U AS=51200000000P
+ AD=21875000000P PS=775000U PD=460000U
* device instance $8348 r0 *1 2.24,8.18 nfet_01v8
M$8348 2 135 433 167 nfet_01v8 L=150000U W=140000U AS=21875000000P
+ AD=16800000000P PS=460000U PD=380000U
* device instance $8349 r0 *1 2.24,8.57 nfet_01v8
M$8349 3219 136 2 167 nfet_01v8 L=150000U W=140000U AS=16800000000P
+ AD=21875000000P PS=380000U PD=460000U
* device instance $8350 r0 *1 2.205,8.97 nfet_01v8
M$8350 167 171 3219 167 nfet_01v8 L=150000U W=210000U AS=21875000000P
+ AD=51200000000P PS=460000U PD=775000U
* device instance $8351 r0 *1 2.205,9.36 nfet_01v8
M$8351 171 3219 167 167 nfet_01v8 L=150000U W=210000U AS=51200000000P
+ AD=21875000000P PS=775000U PD=460000U
* device instance $8352 r0 *1 2.24,9.76 nfet_01v8
M$8352 1 136 171 167 nfet_01v8 L=150000U W=140000U AS=21875000000P
+ AD=16800000000P PS=460000U PD=380000U
* device instance $8353 r0 *1 2.24,10.15 nfet_01v8
M$8353 258 137 1 167 nfet_01v8 L=150000U W=140000U AS=16800000000P
+ AD=21875000000P PS=380000U PD=460000U
* device instance $8354 r0 *1 2.205,10.55 nfet_01v8
M$8354 167 378 258 167 nfet_01v8 L=150000U W=210000U AS=21875000000P
+ AD=51200000000P PS=460000U PD=775000U
* device instance $8355 r0 *1 2.205,10.94 nfet_01v8
M$8355 378 258 167 167 nfet_01v8 L=150000U W=210000U AS=51200000000P
+ AD=21875000000P PS=775000U PD=460000U
* device instance $8356 r0 *1 2.24,11.34 nfet_01v8
M$8356 2 137 378 167 nfet_01v8 L=150000U W=140000U AS=21875000000P
+ AD=16800000000P PS=460000U PD=380000U
* device instance $8357 r0 *1 91.26,68.61 nfet_01v8
M$8357 3960 166 131 167 nfet_01v8 L=150000U W=140000U AS=16800000000P
+ AD=21875000000P PS=380000U PD=460000U
* device instance $8358 r0 *1 91.295,69.01 nfet_01v8
M$8358 167 4159 3960 167 nfet_01v8 L=150000U W=210000U AS=21875000000P
+ AD=51200000000P PS=460000U PD=775000U
* device instance $8359 r0 *1 91.295,69.4 nfet_01v8
M$8359 4159 3960 167 167 nfet_01v8 L=150000U W=210000U AS=51200000000P
+ AD=21875000000P PS=775000U PD=460000U
* device instance $8360 r0 *1 91.26,69.8 nfet_01v8
M$8360 132 166 4159 167 nfet_01v8 L=150000U W=140000U AS=21875000000P
+ AD=16800000000P PS=460000U PD=380000U
* device instance $8361 r0 *1 91.26,60.71 nfet_01v8
M$8361 4050 162 131 167 nfet_01v8 L=150000U W=140000U AS=16800000000P
+ AD=21875000000P PS=380000U PD=460000U
* device instance $8362 r0 *1 91.295,61.11 nfet_01v8
M$8362 167 4268 4050 167 nfet_01v8 L=150000U W=210000U AS=21875000000P
+ AD=51200000000P PS=460000U PD=775000U
* device instance $8363 r0 *1 91.295,61.5 nfet_01v8
M$8363 4268 4050 167 167 nfet_01v8 L=150000U W=210000U AS=51200000000P
+ AD=21875000000P PS=775000U PD=460000U
* device instance $8364 r0 *1 91.26,61.9 nfet_01v8
M$8364 132 162 4268 167 nfet_01v8 L=150000U W=140000U AS=21875000000P
+ AD=16800000000P PS=460000U PD=380000U
* device instance $8365 r0 *1 91.26,62.29 nfet_01v8
M$8365 4295 163 132 167 nfet_01v8 L=150000U W=140000U AS=16800000000P
+ AD=21875000000P PS=380000U PD=460000U
* device instance $8366 r0 *1 91.295,62.69 nfet_01v8
M$8366 167 3860 4295 167 nfet_01v8 L=150000U W=210000U AS=21875000000P
+ AD=51200000000P PS=460000U PD=775000U
* device instance $8367 r0 *1 91.295,63.08 nfet_01v8
M$8367 3860 4295 167 167 nfet_01v8 L=150000U W=210000U AS=51200000000P
+ AD=21875000000P PS=775000U PD=460000U
* device instance $8368 r0 *1 91.26,63.48 nfet_01v8
M$8368 131 163 3860 167 nfet_01v8 L=150000U W=140000U AS=21875000000P
+ AD=16800000000P PS=460000U PD=380000U
* device instance $8369 r0 *1 91.26,63.87 nfet_01v8
M$8369 3911 164 131 167 nfet_01v8 L=150000U W=140000U AS=16800000000P
+ AD=21875000000P PS=380000U PD=460000U
* device instance $8370 r0 *1 91.295,64.27 nfet_01v8
M$8370 167 4101 3911 167 nfet_01v8 L=150000U W=210000U AS=21875000000P
+ AD=51200000000P PS=460000U PD=775000U
* device instance $8371 r0 *1 91.295,64.66 nfet_01v8
M$8371 4101 3911 167 167 nfet_01v8 L=150000U W=210000U AS=51200000000P
+ AD=21875000000P PS=775000U PD=460000U
* device instance $8372 r0 *1 91.26,65.06 nfet_01v8
M$8372 132 164 4101 167 nfet_01v8 L=150000U W=140000U AS=21875000000P
+ AD=16800000000P PS=460000U PD=380000U
* device instance $8373 r0 *1 91.26,65.45 nfet_01v8
M$8373 3954 165 132 167 nfet_01v8 L=150000U W=140000U AS=16800000000P
+ AD=21875000000P PS=380000U PD=460000U
* device instance $8374 r0 *1 91.295,65.85 nfet_01v8
M$8374 167 4153 3954 167 nfet_01v8 L=150000U W=210000U AS=21875000000P
+ AD=51200000000P PS=460000U PD=775000U
* device instance $8375 r0 *1 91.295,66.24 nfet_01v8
M$8375 4153 3954 167 167 nfet_01v8 L=150000U W=210000U AS=51200000000P
+ AD=21875000000P PS=775000U PD=460000U
* device instance $8376 r0 *1 91.26,66.64 nfet_01v8
M$8376 131 165 4153 167 nfet_01v8 L=150000U W=140000U AS=21875000000P
+ AD=16800000000P PS=460000U PD=380000U
* device instance $8377 r0 *1 5.94,68.61 nfet_01v8
M$8377 2497 166 6 167 nfet_01v8 L=150000U W=140000U AS=16800000000P
+ AD=21875000000P PS=380000U PD=460000U
* device instance $8378 r0 *1 6.46,68.61 nfet_01v8
M$8378 892 166 7 167 nfet_01v8 L=150000U W=140000U AS=16800000000P
+ AD=21875000000P PS=380000U PD=460000U
* device instance $8379 r0 *1 5.905,69.01 nfet_01v8
M$8379 167 3017 2497 167 nfet_01v8 L=150000U W=210000U AS=21875000000P
+ AD=40400000000P PS=460000U PD=560000U
* device instance $8380 r0 *1 6.495,69.01 nfet_01v8
M$8380 167 1407 892 167 nfet_01v8 L=150000U W=210000U AS=21875000000P
+ AD=40400000000P PS=460000U PD=560000U
* device instance $8381 r0 *1 5.905,69.4 nfet_01v8
M$8381 3017 2497 167 167 nfet_01v8 L=150000U W=210000U AS=40400000000P
+ AD=21875000000P PS=560000U PD=460000U
* device instance $8382 r0 *1 6.495,69.4 nfet_01v8
M$8382 1407 892 167 167 nfet_01v8 L=150000U W=210000U AS=40400000000P
+ AD=21875000000P PS=560000U PD=460000U
* device instance $8383 r0 *1 5.94,69.8 nfet_01v8
M$8383 5 166 3017 167 nfet_01v8 L=150000U W=140000U AS=21875000000P
+ AD=16800000000P PS=460000U PD=380000U
* device instance $8384 r0 *1 6.46,69.8 nfet_01v8
M$8384 8 166 1407 167 nfet_01v8 L=150000U W=140000U AS=21875000000P
+ AD=16800000000P PS=460000U PD=380000U
* device instance $8385 r0 *1 5.94,60.71 nfet_01v8
M$8385 2461 162 6 167 nfet_01v8 L=150000U W=140000U AS=16800000000P
+ AD=21875000000P PS=380000U PD=460000U
* device instance $8386 r0 *1 6.46,60.71 nfet_01v8
M$8386 883 162 7 167 nfet_01v8 L=150000U W=140000U AS=16800000000P
+ AD=21875000000P PS=380000U PD=460000U
* device instance $8387 r0 *1 5.905,61.11 nfet_01v8
M$8387 167 2941 2461 167 nfet_01v8 L=150000U W=210000U AS=21875000000P
+ AD=40400000000P PS=460000U PD=560000U
* device instance $8388 r0 *1 6.495,61.11 nfet_01v8
M$8388 167 1394 883 167 nfet_01v8 L=150000U W=210000U AS=21875000000P
+ AD=40400000000P PS=460000U PD=560000U
* device instance $8389 r0 *1 5.905,61.5 nfet_01v8
M$8389 2941 2461 167 167 nfet_01v8 L=150000U W=210000U AS=40400000000P
+ AD=21875000000P PS=560000U PD=460000U
* device instance $8390 r0 *1 6.495,61.5 nfet_01v8
M$8390 1394 883 167 167 nfet_01v8 L=150000U W=210000U AS=40400000000P
+ AD=21875000000P PS=560000U PD=460000U
* device instance $8391 r0 *1 5.94,61.9 nfet_01v8
M$8391 5 162 2941 167 nfet_01v8 L=150000U W=140000U AS=21875000000P
+ AD=16800000000P PS=460000U PD=380000U
* device instance $8392 r0 *1 6.46,61.9 nfet_01v8
M$8392 8 162 1394 167 nfet_01v8 L=150000U W=140000U AS=21875000000P
+ AD=16800000000P PS=460000U PD=380000U
* device instance $8393 r0 *1 5.94,62.29 nfet_01v8
M$8393 3711 163 5 167 nfet_01v8 L=150000U W=140000U AS=16800000000P
+ AD=21875000000P PS=380000U PD=460000U
* device instance $8394 r0 *1 6.46,62.29 nfet_01v8
M$8394 4429 163 8 167 nfet_01v8 L=150000U W=140000U AS=16800000000P
+ AD=21875000000P PS=380000U PD=460000U
* device instance $8395 r0 *1 5.905,62.69 nfet_01v8
M$8395 167 2059 3711 167 nfet_01v8 L=150000U W=210000U AS=21875000000P
+ AD=40400000000P PS=460000U PD=560000U
* device instance $8396 r0 *1 6.495,62.69 nfet_01v8
M$8396 167 1386 4429 167 nfet_01v8 L=150000U W=210000U AS=21875000000P
+ AD=40400000000P PS=460000U PD=560000U
* device instance $8397 r0 *1 5.905,63.08 nfet_01v8
M$8397 2059 3711 167 167 nfet_01v8 L=150000U W=210000U AS=40400000000P
+ AD=21875000000P PS=560000U PD=460000U
* device instance $8398 r0 *1 6.495,63.08 nfet_01v8
M$8398 1386 4429 167 167 nfet_01v8 L=150000U W=210000U AS=40400000000P
+ AD=21875000000P PS=560000U PD=460000U
* device instance $8399 r0 *1 5.94,63.48 nfet_01v8
M$8399 6 163 2059 167 nfet_01v8 L=150000U W=140000U AS=21875000000P
+ AD=16800000000P PS=460000U PD=380000U
* device instance $8400 r0 *1 6.46,63.48 nfet_01v8
M$8400 7 163 1386 167 nfet_01v8 L=150000U W=140000U AS=21875000000P
+ AD=16800000000P PS=460000U PD=380000U
* device instance $8401 r0 *1 5.94,63.87 nfet_01v8
M$8401 3709 164 6 167 nfet_01v8 L=150000U W=140000U AS=16800000000P
+ AD=21875000000P PS=380000U PD=460000U
* device instance $8402 r0 *1 6.46,63.87 nfet_01v8
M$8402 899 164 7 167 nfet_01v8 L=150000U W=140000U AS=16800000000P
+ AD=21875000000P PS=380000U PD=460000U
* device instance $8403 r0 *1 5.905,64.27 nfet_01v8
M$8403 167 3022 3709 167 nfet_01v8 L=150000U W=210000U AS=21875000000P
+ AD=40400000000P PS=460000U PD=560000U
* device instance $8404 r0 *1 6.495,64.27 nfet_01v8
M$8404 167 1416 899 167 nfet_01v8 L=150000U W=210000U AS=21875000000P
+ AD=40400000000P PS=460000U PD=560000U
* device instance $8405 r0 *1 5.905,64.66 nfet_01v8
M$8405 3022 3709 167 167 nfet_01v8 L=150000U W=210000U AS=40400000000P
+ AD=21875000000P PS=560000U PD=460000U
* device instance $8406 r0 *1 6.495,64.66 nfet_01v8
M$8406 1416 899 167 167 nfet_01v8 L=150000U W=210000U AS=40400000000P
+ AD=21875000000P PS=560000U PD=460000U
* device instance $8407 r0 *1 5.94,65.06 nfet_01v8
M$8407 5 164 3022 167 nfet_01v8 L=150000U W=140000U AS=21875000000P
+ AD=16800000000P PS=460000U PD=380000U
* device instance $8408 r0 *1 6.46,65.06 nfet_01v8
M$8408 8 164 1416 167 nfet_01v8 L=150000U W=140000U AS=21875000000P
+ AD=16800000000P PS=460000U PD=380000U
* device instance $8409 r0 *1 5.94,65.45 nfet_01v8
M$8409 2505 165 5 167 nfet_01v8 L=150000U W=140000U AS=16800000000P
+ AD=21875000000P PS=380000U PD=460000U
* device instance $8410 r0 *1 6.46,65.45 nfet_01v8
M$8410 916 165 8 167 nfet_01v8 L=150000U W=140000U AS=16800000000P
+ AD=21875000000P PS=380000U PD=460000U
* device instance $8411 r0 *1 5.905,65.85 nfet_01v8
M$8411 167 3039 2505 167 nfet_01v8 L=150000U W=210000U AS=21875000000P
+ AD=40400000000P PS=460000U PD=560000U
* device instance $8412 r0 *1 6.495,65.85 nfet_01v8
M$8412 167 1433 916 167 nfet_01v8 L=150000U W=210000U AS=21875000000P
+ AD=40400000000P PS=460000U PD=560000U
* device instance $8413 r0 *1 5.905,66.24 nfet_01v8
M$8413 3039 2505 167 167 nfet_01v8 L=150000U W=210000U AS=40400000000P
+ AD=21875000000P PS=560000U PD=460000U
* device instance $8414 r0 *1 6.495,66.24 nfet_01v8
M$8414 1433 916 167 167 nfet_01v8 L=150000U W=210000U AS=40400000000P
+ AD=21875000000P PS=560000U PD=460000U
* device instance $8415 r0 *1 5.94,66.64 nfet_01v8
M$8415 6 165 3039 167 nfet_01v8 L=150000U W=140000U AS=21875000000P
+ AD=16800000000P PS=460000U PD=380000U
* device instance $8416 r0 *1 6.46,66.64 nfet_01v8
M$8416 7 165 1433 167 nfet_01v8 L=150000U W=140000U AS=21875000000P
+ AD=16800000000P PS=460000U PD=380000U
* device instance $8417 r0 *1 16.84,68.61 nfet_01v8
M$8417 2484 166 22 167 nfet_01v8 L=150000U W=140000U AS=16800000000P
+ AD=21875000000P PS=380000U PD=460000U
* device instance $8418 r0 *1 17.36,68.61 nfet_01v8
M$8418 905 166 23 167 nfet_01v8 L=150000U W=140000U AS=16800000000P
+ AD=21875000000P PS=380000U PD=460000U
* device instance $8419 r0 *1 16.805,69.01 nfet_01v8
M$8419 167 2990 2484 167 nfet_01v8 L=150000U W=210000U AS=21875000000P
+ AD=40400000000P PS=460000U PD=560000U
* device instance $8420 r0 *1 17.395,69.01 nfet_01v8
M$8420 167 1422 905 167 nfet_01v8 L=150000U W=210000U AS=21875000000P
+ AD=40400000000P PS=460000U PD=560000U
* device instance $8421 r0 *1 16.805,69.4 nfet_01v8
M$8421 2990 2484 167 167 nfet_01v8 L=150000U W=210000U AS=40400000000P
+ AD=21875000000P PS=560000U PD=460000U
* device instance $8422 r0 *1 17.395,69.4 nfet_01v8
M$8422 1422 905 167 167 nfet_01v8 L=150000U W=210000U AS=40400000000P
+ AD=21875000000P PS=560000U PD=460000U
* device instance $8423 r0 *1 16.84,69.8 nfet_01v8
M$8423 21 166 2990 167 nfet_01v8 L=150000U W=140000U AS=21875000000P
+ AD=16800000000P PS=460000U PD=380000U
* device instance $8424 r0 *1 17.36,69.8 nfet_01v8
M$8424 24 166 1422 167 nfet_01v8 L=150000U W=140000U AS=21875000000P
+ AD=16800000000P PS=460000U PD=380000U
* device instance $8425 r0 *1 27.74,68.61 nfet_01v8
M$8425 3542 166 38 167 nfet_01v8 L=150000U W=140000U AS=16800000000P
+ AD=21875000000P PS=380000U PD=460000U
* device instance $8426 r0 *1 28.26,68.61 nfet_01v8
M$8426 900 166 39 167 nfet_01v8 L=150000U W=140000U AS=16800000000P
+ AD=21875000000P PS=380000U PD=460000U
* device instance $8427 r0 *1 27.705,69.01 nfet_01v8
M$8427 167 2581 3542 167 nfet_01v8 L=150000U W=210000U AS=21875000000P
+ AD=40400000000P PS=460000U PD=560000U
* device instance $8428 r0 *1 28.295,69.01 nfet_01v8
M$8428 167 1417 900 167 nfet_01v8 L=150000U W=210000U AS=21875000000P
+ AD=40400000000P PS=460000U PD=560000U
* device instance $8429 r0 *1 27.705,69.4 nfet_01v8
M$8429 2581 3542 167 167 nfet_01v8 L=150000U W=210000U AS=40400000000P
+ AD=21875000000P PS=560000U PD=460000U
* device instance $8430 r0 *1 28.295,69.4 nfet_01v8
M$8430 1417 900 167 167 nfet_01v8 L=150000U W=210000U AS=40400000000P
+ AD=21875000000P PS=560000U PD=460000U
* device instance $8431 r0 *1 27.74,69.8 nfet_01v8
M$8431 37 166 2581 167 nfet_01v8 L=150000U W=140000U AS=21875000000P
+ AD=16800000000P PS=460000U PD=380000U
* device instance $8432 r0 *1 28.26,69.8 nfet_01v8
M$8432 40 166 1417 167 nfet_01v8 L=150000U W=140000U AS=21875000000P
+ AD=16800000000P PS=460000U PD=380000U
* device instance $8433 r0 *1 38.64,68.61 nfet_01v8
M$8433 2275 166 54 167 nfet_01v8 L=150000U W=140000U AS=16800000000P
+ AD=21875000000P PS=380000U PD=460000U
* device instance $8434 r0 *1 39.16,68.61 nfet_01v8
M$8434 1204 166 55 167 nfet_01v8 L=150000U W=140000U AS=16800000000P
+ AD=21875000000P PS=380000U PD=460000U
* device instance $8435 r0 *1 38.605,69.01 nfet_01v8
M$8435 167 2569 2275 167 nfet_01v8 L=150000U W=210000U AS=21875000000P
+ AD=40400000000P PS=460000U PD=560000U
* device instance $8436 r0 *1 39.195,69.01 nfet_01v8
M$8436 167 1774 1204 167 nfet_01v8 L=150000U W=210000U AS=21875000000P
+ AD=40400000000P PS=460000U PD=560000U
* device instance $8437 r0 *1 38.605,69.4 nfet_01v8
M$8437 2569 2275 167 167 nfet_01v8 L=150000U W=210000U AS=40400000000P
+ AD=21875000000P PS=560000U PD=460000U
* device instance $8438 r0 *1 39.195,69.4 nfet_01v8
M$8438 1774 1204 167 167 nfet_01v8 L=150000U W=210000U AS=40400000000P
+ AD=21875000000P PS=560000U PD=460000U
* device instance $8439 r0 *1 38.64,69.8 nfet_01v8
M$8439 53 166 2569 167 nfet_01v8 L=150000U W=140000U AS=21875000000P
+ AD=16800000000P PS=460000U PD=380000U
* device instance $8440 r0 *1 39.16,69.8 nfet_01v8
M$8440 56 166 1774 167 nfet_01v8 L=150000U W=140000U AS=21875000000P
+ AD=16800000000P PS=460000U PD=380000U
* device instance $8441 r0 *1 49.54,68.61 nfet_01v8
M$8441 2298 166 70 167 nfet_01v8 L=150000U W=140000U AS=16800000000P
+ AD=21875000000P PS=380000U PD=460000U
* device instance $8442 r0 *1 50.06,68.61 nfet_01v8
M$8442 946 166 71 167 nfet_01v8 L=150000U W=140000U AS=16800000000P
+ AD=21875000000P PS=380000U PD=460000U
* device instance $8443 r0 *1 49.505,69.01 nfet_01v8
M$8443 167 2615 2298 167 nfet_01v8 L=150000U W=210000U AS=21875000000P
+ AD=40400000000P PS=460000U PD=560000U
* device instance $8444 r0 *1 50.095,69.01 nfet_01v8
M$8444 167 1470 946 167 nfet_01v8 L=150000U W=210000U AS=21875000000P
+ AD=40400000000P PS=460000U PD=560000U
* device instance $8445 r0 *1 49.505,69.4 nfet_01v8
M$8445 2615 2298 167 167 nfet_01v8 L=150000U W=210000U AS=40400000000P
+ AD=21875000000P PS=560000U PD=460000U
* device instance $8446 r0 *1 50.095,69.4 nfet_01v8
M$8446 1470 946 167 167 nfet_01v8 L=150000U W=210000U AS=40400000000P
+ AD=21875000000P PS=560000U PD=460000U
* device instance $8447 r0 *1 49.54,69.8 nfet_01v8
M$8447 69 166 2615 167 nfet_01v8 L=150000U W=140000U AS=21875000000P
+ AD=16800000000P PS=460000U PD=380000U
* device instance $8448 r0 *1 50.06,69.8 nfet_01v8
M$8448 72 166 1470 167 nfet_01v8 L=150000U W=140000U AS=21875000000P
+ AD=16800000000P PS=460000U PD=380000U
* device instance $8449 r0 *1 60.44,68.61 nfet_01v8
M$8449 2274 166 86 167 nfet_01v8 L=150000U W=140000U AS=16800000000P
+ AD=21875000000P PS=380000U PD=460000U
* device instance $8450 r0 *1 60.96,68.61 nfet_01v8
M$8450 879 166 87 167 nfet_01v8 L=150000U W=140000U AS=16800000000P
+ AD=21875000000P PS=380000U PD=460000U
* device instance $8451 r0 *1 60.405,69.01 nfet_01v8
M$8451 167 2562 2274 167 nfet_01v8 L=150000U W=210000U AS=21875000000P
+ AD=40400000000P PS=460000U PD=560000U
* device instance $8452 r0 *1 60.995,69.01 nfet_01v8
M$8452 167 1389 879 167 nfet_01v8 L=150000U W=210000U AS=21875000000P
+ AD=40400000000P PS=460000U PD=560000U
* device instance $8453 r0 *1 60.405,69.4 nfet_01v8
M$8453 2562 2274 167 167 nfet_01v8 L=150000U W=210000U AS=40400000000P
+ AD=21875000000P PS=560000U PD=460000U
* device instance $8454 r0 *1 60.995,69.4 nfet_01v8
M$8454 1389 879 167 167 nfet_01v8 L=150000U W=210000U AS=40400000000P
+ AD=21875000000P PS=560000U PD=460000U
* device instance $8455 r0 *1 60.44,69.8 nfet_01v8
M$8455 85 166 2562 167 nfet_01v8 L=150000U W=140000U AS=21875000000P
+ AD=16800000000P PS=460000U PD=380000U
* device instance $8456 r0 *1 60.96,69.8 nfet_01v8
M$8456 88 166 1389 167 nfet_01v8 L=150000U W=140000U AS=21875000000P
+ AD=16800000000P PS=460000U PD=380000U
* device instance $8457 r0 *1 71.34,68.61 nfet_01v8
M$8457 2464 166 102 167 nfet_01v8 L=150000U W=140000U AS=16800000000P
+ AD=21875000000P PS=380000U PD=460000U
* device instance $8458 r0 *1 71.86,68.61 nfet_01v8
M$8458 1007 166 103 167 nfet_01v8 L=150000U W=140000U AS=16800000000P
+ AD=21875000000P PS=380000U PD=460000U
* device instance $8459 r0 *1 71.305,69.01 nfet_01v8
M$8459 167 2945 2464 167 nfet_01v8 L=150000U W=210000U AS=21875000000P
+ AD=40400000000P PS=460000U PD=560000U
* device instance $8460 r0 *1 71.895,69.01 nfet_01v8
M$8460 167 1542 1007 167 nfet_01v8 L=150000U W=210000U AS=21875000000P
+ AD=40400000000P PS=460000U PD=560000U
* device instance $8461 r0 *1 71.305,69.4 nfet_01v8
M$8461 2945 2464 167 167 nfet_01v8 L=150000U W=210000U AS=40400000000P
+ AD=21875000000P PS=560000U PD=460000U
* device instance $8462 r0 *1 71.895,69.4 nfet_01v8
M$8462 1542 1007 167 167 nfet_01v8 L=150000U W=210000U AS=40400000000P
+ AD=21875000000P PS=560000U PD=460000U
* device instance $8463 r0 *1 71.34,69.8 nfet_01v8
M$8463 101 166 2945 167 nfet_01v8 L=150000U W=140000U AS=21875000000P
+ AD=16800000000P PS=460000U PD=380000U
* device instance $8464 r0 *1 71.86,69.8 nfet_01v8
M$8464 104 166 1542 167 nfet_01v8 L=150000U W=140000U AS=21875000000P
+ AD=16800000000P PS=460000U PD=380000U
* device instance $8465 r0 *1 82.24,68.61 nfet_01v8
M$8465 3163 166 118 167 nfet_01v8 L=150000U W=140000U AS=16800000000P
+ AD=21875000000P PS=380000U PD=460000U
* device instance $8466 r0 *1 82.76,68.61 nfet_01v8
M$8466 979 166 119 167 nfet_01v8 L=150000U W=140000U AS=16800000000P
+ AD=21875000000P PS=380000U PD=460000U
* device instance $8467 r0 *1 82.205,69.01 nfet_01v8
M$8467 167 2833 3163 167 nfet_01v8 L=150000U W=210000U AS=21875000000P
+ AD=40400000000P PS=460000U PD=560000U
* device instance $8468 r0 *1 82.795,69.01 nfet_01v8
M$8468 167 1511 979 167 nfet_01v8 L=150000U W=210000U AS=21875000000P
+ AD=40400000000P PS=460000U PD=560000U
* device instance $8469 r0 *1 82.205,69.4 nfet_01v8
M$8469 2833 3163 167 167 nfet_01v8 L=150000U W=210000U AS=40400000000P
+ AD=21875000000P PS=560000U PD=460000U
* device instance $8470 r0 *1 82.795,69.4 nfet_01v8
M$8470 1511 979 167 167 nfet_01v8 L=150000U W=210000U AS=40400000000P
+ AD=21875000000P PS=560000U PD=460000U
* device instance $8471 r0 *1 82.24,69.8 nfet_01v8
M$8471 117 166 2833 167 nfet_01v8 L=150000U W=140000U AS=21875000000P
+ AD=16800000000P PS=460000U PD=380000U
* device instance $8472 r0 *1 82.76,69.8 nfet_01v8
M$8472 120 166 1511 167 nfet_01v8 L=150000U W=140000U AS=21875000000P
+ AD=16800000000P PS=460000U PD=380000U
* device instance $8473 r0 *1 8.34,68.61 nfet_01v8
M$8473 2504 166 10 167 nfet_01v8 L=150000U W=140000U AS=16800000000P
+ AD=21875000000P PS=380000U PD=460000U
* device instance $8474 r0 *1 8.86,68.61 nfet_01v8
M$8474 890 166 11 167 nfet_01v8 L=150000U W=140000U AS=16800000000P
+ AD=21875000000P PS=380000U PD=460000U
* device instance $8475 r0 *1 8.305,69.01 nfet_01v8
M$8475 167 3037 2504 167 nfet_01v8 L=150000U W=210000U AS=21875000000P
+ AD=40400000000P PS=460000U PD=560000U
* device instance $8476 r0 *1 8.895,69.01 nfet_01v8
M$8476 167 1405 890 167 nfet_01v8 L=150000U W=210000U AS=21875000000P
+ AD=40400000000P PS=460000U PD=560000U
* device instance $8477 r0 *1 8.305,69.4 nfet_01v8
M$8477 3037 2504 167 167 nfet_01v8 L=150000U W=210000U AS=40400000000P
+ AD=21875000000P PS=560000U PD=460000U
* device instance $8478 r0 *1 8.895,69.4 nfet_01v8
M$8478 1405 890 167 167 nfet_01v8 L=150000U W=210000U AS=40400000000P
+ AD=21875000000P PS=560000U PD=460000U
* device instance $8479 r0 *1 8.34,69.8 nfet_01v8
M$8479 9 166 3037 167 nfet_01v8 L=150000U W=140000U AS=21875000000P
+ AD=16800000000P PS=460000U PD=380000U
* device instance $8480 r0 *1 8.86,69.8 nfet_01v8
M$8480 12 166 1405 167 nfet_01v8 L=150000U W=140000U AS=21875000000P
+ AD=16800000000P PS=460000U PD=380000U
* device instance $8481 r0 *1 8.34,60.71 nfet_01v8
M$8481 2465 162 10 167 nfet_01v8 L=150000U W=140000U AS=16800000000P
+ AD=21875000000P PS=380000U PD=460000U
* device instance $8482 r0 *1 8.86,60.71 nfet_01v8
M$8482 874 162 11 167 nfet_01v8 L=150000U W=140000U AS=16800000000P
+ AD=21875000000P PS=380000U PD=460000U
* device instance $8483 r0 *1 8.305,61.11 nfet_01v8
M$8483 167 2947 2465 167 nfet_01v8 L=150000U W=210000U AS=21875000000P
+ AD=40400000000P PS=460000U PD=560000U
* device instance $8484 r0 *1 8.895,61.11 nfet_01v8
M$8484 167 1382 874 167 nfet_01v8 L=150000U W=210000U AS=21875000000P
+ AD=40400000000P PS=460000U PD=560000U
* device instance $8485 r0 *1 8.305,61.5 nfet_01v8
M$8485 2947 2465 167 167 nfet_01v8 L=150000U W=210000U AS=40400000000P
+ AD=21875000000P PS=560000U PD=460000U
* device instance $8486 r0 *1 8.895,61.5 nfet_01v8
M$8486 1382 874 167 167 nfet_01v8 L=150000U W=210000U AS=40400000000P
+ AD=21875000000P PS=560000U PD=460000U
* device instance $8487 r0 *1 8.34,61.9 nfet_01v8
M$8487 9 162 2947 167 nfet_01v8 L=150000U W=140000U AS=21875000000P
+ AD=16800000000P PS=460000U PD=380000U
* device instance $8488 r0 *1 8.86,61.9 nfet_01v8
M$8488 12 162 1382 167 nfet_01v8 L=150000U W=140000U AS=21875000000P
+ AD=16800000000P PS=460000U PD=380000U
* device instance $8489 r0 *1 8.34,62.29 nfet_01v8
M$8489 3716 163 9 167 nfet_01v8 L=150000U W=140000U AS=16800000000P
+ AD=21875000000P PS=380000U PD=460000U
* device instance $8490 r0 *1 8.86,62.29 nfet_01v8
M$8490 4428 163 12 167 nfet_01v8 L=150000U W=140000U AS=16800000000P
+ AD=21875000000P PS=380000U PD=460000U
* device instance $8491 r0 *1 8.305,62.69 nfet_01v8
M$8491 167 2166 3716 167 nfet_01v8 L=150000U W=210000U AS=21875000000P
+ AD=40400000000P PS=460000U PD=560000U
* device instance $8492 r0 *1 8.895,62.69 nfet_01v8
M$8492 167 1383 4428 167 nfet_01v8 L=150000U W=210000U AS=21875000000P
+ AD=40400000000P PS=460000U PD=560000U
* device instance $8493 r0 *1 8.305,63.08 nfet_01v8
M$8493 2166 3716 167 167 nfet_01v8 L=150000U W=210000U AS=40400000000P
+ AD=21875000000P PS=560000U PD=460000U
* device instance $8494 r0 *1 8.895,63.08 nfet_01v8
M$8494 1383 4428 167 167 nfet_01v8 L=150000U W=210000U AS=40400000000P
+ AD=21875000000P PS=560000U PD=460000U
* device instance $8495 r0 *1 8.34,63.48 nfet_01v8
M$8495 10 163 2166 167 nfet_01v8 L=150000U W=140000U AS=21875000000P
+ AD=16800000000P PS=460000U PD=380000U
* device instance $8496 r0 *1 8.86,63.48 nfet_01v8
M$8496 11 163 1383 167 nfet_01v8 L=150000U W=140000U AS=21875000000P
+ AD=16800000000P PS=460000U PD=380000U
* device instance $8497 r0 *1 8.34,63.87 nfet_01v8
M$8497 2086 164 10 167 nfet_01v8 L=150000U W=140000U AS=16800000000P
+ AD=21875000000P PS=380000U PD=460000U
* device instance $8498 r0 *1 8.86,63.87 nfet_01v8
M$8498 649 164 11 167 nfet_01v8 L=150000U W=140000U AS=16800000000P
+ AD=21875000000P PS=380000U PD=460000U
* device instance $8499 r0 *1 8.305,64.27 nfet_01v8
M$8499 167 2172 2086 167 nfet_01v8 L=150000U W=210000U AS=21875000000P
+ AD=40400000000P PS=460000U PD=560000U
* device instance $8500 r0 *1 8.895,64.27 nfet_01v8
M$8500 167 819 649 167 nfet_01v8 L=150000U W=210000U AS=21875000000P
+ AD=40400000000P PS=460000U PD=560000U
* device instance $8501 r0 *1 8.305,64.66 nfet_01v8
M$8501 2172 2086 167 167 nfet_01v8 L=150000U W=210000U AS=40400000000P
+ AD=21875000000P PS=560000U PD=460000U
* device instance $8502 r0 *1 8.895,64.66 nfet_01v8
M$8502 819 649 167 167 nfet_01v8 L=150000U W=210000U AS=40400000000P
+ AD=21875000000P PS=560000U PD=460000U
* device instance $8503 r0 *1 8.34,65.06 nfet_01v8
M$8503 9 164 2172 167 nfet_01v8 L=150000U W=140000U AS=21875000000P
+ AD=16800000000P PS=460000U PD=380000U
* device instance $8504 r0 *1 8.86,65.06 nfet_01v8
M$8504 12 164 819 167 nfet_01v8 L=150000U W=140000U AS=21875000000P
+ AD=16800000000P PS=460000U PD=380000U
* device instance $8505 r0 *1 8.34,65.45 nfet_01v8
M$8505 3715 165 9 167 nfet_01v8 L=150000U W=140000U AS=16800000000P
+ AD=21875000000P PS=380000U PD=460000U
* device instance $8506 r0 *1 8.86,65.45 nfet_01v8
M$8506 936 165 12 167 nfet_01v8 L=150000U W=140000U AS=16800000000P
+ AD=21875000000P PS=380000U PD=460000U
* device instance $8507 r0 *1 8.305,65.85 nfet_01v8
M$8507 167 3038 3715 167 nfet_01v8 L=150000U W=210000U AS=21875000000P
+ AD=40400000000P PS=460000U PD=560000U
* device instance $8508 r0 *1 8.895,65.85 nfet_01v8
M$8508 167 1459 936 167 nfet_01v8 L=150000U W=210000U AS=21875000000P
+ AD=40400000000P PS=460000U PD=560000U
* device instance $8509 r0 *1 8.305,66.24 nfet_01v8
M$8509 3038 3715 167 167 nfet_01v8 L=150000U W=210000U AS=40400000000P
+ AD=21875000000P PS=560000U PD=460000U
* device instance $8510 r0 *1 8.895,66.24 nfet_01v8
M$8510 1459 936 167 167 nfet_01v8 L=150000U W=210000U AS=40400000000P
+ AD=21875000000P PS=560000U PD=460000U
* device instance $8511 r0 *1 8.34,66.64 nfet_01v8
M$8511 10 165 3038 167 nfet_01v8 L=150000U W=140000U AS=21875000000P
+ AD=16800000000P PS=460000U PD=380000U
* device instance $8512 r0 *1 8.86,66.64 nfet_01v8
M$8512 11 165 1459 167 nfet_01v8 L=150000U W=140000U AS=21875000000P
+ AD=16800000000P PS=460000U PD=380000U
* device instance $8513 r0 *1 19.24,68.61 nfet_01v8
M$8513 2483 166 26 167 nfet_01v8 L=150000U W=140000U AS=16800000000P
+ AD=21875000000P PS=380000U PD=460000U
* device instance $8514 r0 *1 19.76,68.61 nfet_01v8
M$8514 898 166 27 167 nfet_01v8 L=150000U W=140000U AS=16800000000P
+ AD=21875000000P PS=380000U PD=460000U
* device instance $8515 r0 *1 19.205,69.01 nfet_01v8
M$8515 167 2987 2483 167 nfet_01v8 L=150000U W=210000U AS=21875000000P
+ AD=40400000000P PS=460000U PD=560000U
* device instance $8516 r0 *1 19.795,69.01 nfet_01v8
M$8516 167 1415 898 167 nfet_01v8 L=150000U W=210000U AS=21875000000P
+ AD=40400000000P PS=460000U PD=560000U
* device instance $8517 r0 *1 19.205,69.4 nfet_01v8
M$8517 2987 2483 167 167 nfet_01v8 L=150000U W=210000U AS=40400000000P
+ AD=21875000000P PS=560000U PD=460000U
* device instance $8518 r0 *1 19.795,69.4 nfet_01v8
M$8518 1415 898 167 167 nfet_01v8 L=150000U W=210000U AS=40400000000P
+ AD=21875000000P PS=560000U PD=460000U
* device instance $8519 r0 *1 19.24,69.8 nfet_01v8
M$8519 25 166 2987 167 nfet_01v8 L=150000U W=140000U AS=21875000000P
+ AD=16800000000P PS=460000U PD=380000U
* device instance $8520 r0 *1 19.76,69.8 nfet_01v8
M$8520 28 166 1415 167 nfet_01v8 L=150000U W=140000U AS=21875000000P
+ AD=16800000000P PS=460000U PD=380000U
* device instance $8521 r0 *1 30.14,68.61 nfet_01v8
M$8521 3540 166 42 167 nfet_01v8 L=150000U W=140000U AS=16800000000P
+ AD=21875000000P PS=380000U PD=460000U
* device instance $8522 r0 *1 30.66,68.61 nfet_01v8
M$8522 1330 166 43 167 nfet_01v8 L=150000U W=140000U AS=16800000000P
+ AD=21875000000P PS=380000U PD=460000U
* device instance $8523 r0 *1 30.105,69.01 nfet_01v8
M$8523 167 2577 3540 167 nfet_01v8 L=150000U W=210000U AS=21875000000P
+ AD=40400000000P PS=460000U PD=560000U
* device instance $8524 r0 *1 30.695,69.01 nfet_01v8
M$8524 167 1911 1330 167 nfet_01v8 L=150000U W=210000U AS=21875000000P
+ AD=40400000000P PS=460000U PD=560000U
* device instance $8525 r0 *1 30.105,69.4 nfet_01v8
M$8525 2577 3540 167 167 nfet_01v8 L=150000U W=210000U AS=40400000000P
+ AD=21875000000P PS=560000U PD=460000U
* device instance $8526 r0 *1 30.695,69.4 nfet_01v8
M$8526 1911 1330 167 167 nfet_01v8 L=150000U W=210000U AS=40400000000P
+ AD=21875000000P PS=560000U PD=460000U
* device instance $8527 r0 *1 30.14,69.8 nfet_01v8
M$8527 41 166 2577 167 nfet_01v8 L=150000U W=140000U AS=21875000000P
+ AD=16800000000P PS=460000U PD=380000U
* device instance $8528 r0 *1 30.66,69.8 nfet_01v8
M$8528 44 166 1911 167 nfet_01v8 L=150000U W=140000U AS=21875000000P
+ AD=16800000000P PS=460000U PD=380000U
* device instance $8529 r0 *1 41.04,68.61 nfet_01v8
M$8529 3494 166 58 167 nfet_01v8 L=150000U W=140000U AS=16800000000P
+ AD=21875000000P PS=380000U PD=460000U
* device instance $8530 r0 *1 41.56,68.61 nfet_01v8
M$8530 1290 166 59 167 nfet_01v8 L=150000U W=140000U AS=16800000000P
+ AD=21875000000P PS=380000U PD=460000U
* device instance $8531 r0 *1 41.005,69.01 nfet_01v8
M$8531 167 2582 3494 167 nfet_01v8 L=150000U W=210000U AS=21875000000P
+ AD=40400000000P PS=460000U PD=560000U
* device instance $8532 r0 *1 41.595,69.01 nfet_01v8
M$8532 167 1867 1290 167 nfet_01v8 L=150000U W=210000U AS=21875000000P
+ AD=40400000000P PS=460000U PD=560000U
* device instance $8533 r0 *1 41.005,69.4 nfet_01v8
M$8533 2582 3494 167 167 nfet_01v8 L=150000U W=210000U AS=40400000000P
+ AD=21875000000P PS=560000U PD=460000U
* device instance $8534 r0 *1 41.595,69.4 nfet_01v8
M$8534 1867 1290 167 167 nfet_01v8 L=150000U W=210000U AS=40400000000P
+ AD=21875000000P PS=560000U PD=460000U
* device instance $8535 r0 *1 41.04,69.8 nfet_01v8
M$8535 57 166 2582 167 nfet_01v8 L=150000U W=140000U AS=21875000000P
+ AD=16800000000P PS=460000U PD=380000U
* device instance $8536 r0 *1 41.56,69.8 nfet_01v8
M$8536 60 166 1867 167 nfet_01v8 L=150000U W=140000U AS=21875000000P
+ AD=16800000000P PS=460000U PD=380000U
* device instance $8537 r0 *1 51.94,68.61 nfet_01v8
M$8537 2314 166 74 167 nfet_01v8 L=150000U W=140000U AS=16800000000P
+ AD=21875000000P PS=380000U PD=460000U
* device instance $8538 r0 *1 52.46,68.61 nfet_01v8
M$8538 1289 166 75 167 nfet_01v8 L=150000U W=140000U AS=16800000000P
+ AD=21875000000P PS=380000U PD=460000U
* device instance $8539 r0 *1 51.905,69.01 nfet_01v8
M$8539 167 2647 2314 167 nfet_01v8 L=150000U W=210000U AS=21875000000P
+ AD=40400000000P PS=460000U PD=560000U
* device instance $8540 r0 *1 52.495,69.01 nfet_01v8
M$8540 167 1866 1289 167 nfet_01v8 L=150000U W=210000U AS=21875000000P
+ AD=40400000000P PS=460000U PD=560000U
* device instance $8541 r0 *1 51.905,69.4 nfet_01v8
M$8541 2647 2314 167 167 nfet_01v8 L=150000U W=210000U AS=40400000000P
+ AD=21875000000P PS=560000U PD=460000U
* device instance $8542 r0 *1 52.495,69.4 nfet_01v8
M$8542 1866 1289 167 167 nfet_01v8 L=150000U W=210000U AS=40400000000P
+ AD=21875000000P PS=560000U PD=460000U
* device instance $8543 r0 *1 51.94,69.8 nfet_01v8
M$8543 73 166 2647 167 nfet_01v8 L=150000U W=140000U AS=21875000000P
+ AD=16800000000P PS=460000U PD=380000U
* device instance $8544 r0 *1 52.46,69.8 nfet_01v8
M$8544 76 166 1866 167 nfet_01v8 L=150000U W=140000U AS=21875000000P
+ AD=16800000000P PS=460000U PD=380000U
* device instance $8545 r0 *1 62.84,68.61 nfet_01v8
M$8545 2500 166 90 167 nfet_01v8 L=150000U W=140000U AS=16800000000P
+ AD=21875000000P PS=380000U PD=460000U
* device instance $8546 r0 *1 63.36,68.61 nfet_01v8
M$8546 878 166 91 167 nfet_01v8 L=150000U W=140000U AS=16800000000P
+ AD=21875000000P PS=380000U PD=460000U
* device instance $8547 r0 *1 62.805,69.01 nfet_01v8
M$8547 167 3027 2500 167 nfet_01v8 L=150000U W=210000U AS=21875000000P
+ AD=40400000000P PS=460000U PD=560000U
* device instance $8548 r0 *1 63.395,69.01 nfet_01v8
M$8548 167 1388 878 167 nfet_01v8 L=150000U W=210000U AS=21875000000P
+ AD=40400000000P PS=460000U PD=560000U
* device instance $8549 r0 *1 62.805,69.4 nfet_01v8
M$8549 3027 2500 167 167 nfet_01v8 L=150000U W=210000U AS=40400000000P
+ AD=21875000000P PS=560000U PD=460000U
* device instance $8550 r0 *1 63.395,69.4 nfet_01v8
M$8550 1388 878 167 167 nfet_01v8 L=150000U W=210000U AS=40400000000P
+ AD=21875000000P PS=560000U PD=460000U
* device instance $8551 r0 *1 62.84,69.8 nfet_01v8
M$8551 89 166 3027 167 nfet_01v8 L=150000U W=140000U AS=21875000000P
+ AD=16800000000P PS=460000U PD=380000U
* device instance $8552 r0 *1 63.36,69.8 nfet_01v8
M$8552 92 166 1388 167 nfet_01v8 L=150000U W=140000U AS=21875000000P
+ AD=16800000000P PS=460000U PD=380000U
* device instance $8553 r0 *1 73.74,68.61 nfet_01v8
M$8553 2467 166 106 167 nfet_01v8 L=150000U W=140000U AS=16800000000P
+ AD=21875000000P PS=380000U PD=460000U
* device instance $8554 r0 *1 74.26,68.61 nfet_01v8
M$8554 998 166 107 167 nfet_01v8 L=150000U W=140000U AS=16800000000P
+ AD=21875000000P PS=380000U PD=460000U
* device instance $8555 r0 *1 73.705,69.01 nfet_01v8
M$8555 167 2953 2467 167 nfet_01v8 L=150000U W=210000U AS=21875000000P
+ AD=40400000000P PS=460000U PD=560000U
* device instance $8556 r0 *1 74.295,69.01 nfet_01v8
M$8556 167 1533 998 167 nfet_01v8 L=150000U W=210000U AS=21875000000P
+ AD=40400000000P PS=460000U PD=560000U
* device instance $8557 r0 *1 73.705,69.4 nfet_01v8
M$8557 2953 2467 167 167 nfet_01v8 L=150000U W=210000U AS=40400000000P
+ AD=21875000000P PS=560000U PD=460000U
* device instance $8558 r0 *1 74.295,69.4 nfet_01v8
M$8558 1533 998 167 167 nfet_01v8 L=150000U W=210000U AS=40400000000P
+ AD=21875000000P PS=560000U PD=460000U
* device instance $8559 r0 *1 73.74,69.8 nfet_01v8
M$8559 105 166 2953 167 nfet_01v8 L=150000U W=140000U AS=21875000000P
+ AD=16800000000P PS=460000U PD=380000U
* device instance $8560 r0 *1 74.26,69.8 nfet_01v8
M$8560 108 166 1533 167 nfet_01v8 L=150000U W=140000U AS=21875000000P
+ AD=16800000000P PS=460000U PD=380000U
* device instance $8561 r0 *1 84.64,68.61 nfet_01v8
M$8561 2408 166 122 167 nfet_01v8 L=150000U W=140000U AS=16800000000P
+ AD=21875000000P PS=380000U PD=460000U
* device instance $8562 r0 *1 85.16,68.61 nfet_01v8
M$8562 975 166 123 167 nfet_01v8 L=150000U W=140000U AS=16800000000P
+ AD=21875000000P PS=380000U PD=460000U
* device instance $8563 r0 *1 84.605,69.01 nfet_01v8
M$8563 167 2826 2408 167 nfet_01v8 L=150000U W=210000U AS=21875000000P
+ AD=40400000000P PS=460000U PD=560000U
* device instance $8564 r0 *1 85.195,69.01 nfet_01v8
M$8564 167 1505 975 167 nfet_01v8 L=150000U W=210000U AS=21875000000P
+ AD=40400000000P PS=460000U PD=560000U
* device instance $8565 r0 *1 84.605,69.4 nfet_01v8
M$8565 2826 2408 167 167 nfet_01v8 L=150000U W=210000U AS=40400000000P
+ AD=21875000000P PS=560000U PD=460000U
* device instance $8566 r0 *1 85.195,69.4 nfet_01v8
M$8566 1505 975 167 167 nfet_01v8 L=150000U W=210000U AS=40400000000P
+ AD=21875000000P PS=560000U PD=460000U
* device instance $8567 r0 *1 84.64,69.8 nfet_01v8
M$8567 121 166 2826 167 nfet_01v8 L=150000U W=140000U AS=21875000000P
+ AD=16800000000P PS=460000U PD=380000U
* device instance $8568 r0 *1 85.16,69.8 nfet_01v8
M$8568 124 166 1505 167 nfet_01v8 L=150000U W=140000U AS=21875000000P
+ AD=16800000000P PS=460000U PD=380000U
* device instance $8569 r0 *1 10.74,68.61 nfet_01v8
M$8569 3707 166 14 167 nfet_01v8 L=150000U W=140000U AS=16800000000P
+ AD=21875000000P PS=380000U PD=460000U
* device instance $8570 r0 *1 11.26,68.61 nfet_01v8
M$8570 887 166 15 167 nfet_01v8 L=150000U W=140000U AS=16800000000P
+ AD=21875000000P PS=380000U PD=460000U
* device instance $8571 r0 *1 10.705,69.01 nfet_01v8
M$8571 167 3042 3707 167 nfet_01v8 L=150000U W=210000U AS=21875000000P
+ AD=40400000000P PS=460000U PD=560000U
* device instance $8572 r0 *1 11.295,69.01 nfet_01v8
M$8572 167 1401 887 167 nfet_01v8 L=150000U W=210000U AS=21875000000P
+ AD=40400000000P PS=460000U PD=560000U
* device instance $8573 r0 *1 10.705,69.4 nfet_01v8
M$8573 3042 3707 167 167 nfet_01v8 L=150000U W=210000U AS=40400000000P
+ AD=21875000000P PS=560000U PD=460000U
* device instance $8574 r0 *1 11.295,69.4 nfet_01v8
M$8574 1401 887 167 167 nfet_01v8 L=150000U W=210000U AS=40400000000P
+ AD=21875000000P PS=560000U PD=460000U
* device instance $8575 r0 *1 10.74,69.8 nfet_01v8
M$8575 13 166 3042 167 nfet_01v8 L=150000U W=140000U AS=21875000000P
+ AD=16800000000P PS=460000U PD=380000U
* device instance $8576 r0 *1 11.26,69.8 nfet_01v8
M$8576 16 166 1401 167 nfet_01v8 L=150000U W=140000U AS=21875000000P
+ AD=16800000000P PS=460000U PD=380000U
* device instance $8577 r0 *1 10.74,60.71 nfet_01v8
M$8577 2462 162 14 167 nfet_01v8 L=150000U W=140000U AS=16800000000P
+ AD=21875000000P PS=380000U PD=460000U
* device instance $8578 r0 *1 11.26,60.71 nfet_01v8
M$8578 908 162 15 167 nfet_01v8 L=150000U W=140000U AS=16800000000P
+ AD=21875000000P PS=380000U PD=460000U
* device instance $8579 r0 *1 10.705,61.11 nfet_01v8
M$8579 167 2942 2462 167 nfet_01v8 L=150000U W=210000U AS=21875000000P
+ AD=40400000000P PS=460000U PD=560000U
* device instance $8580 r0 *1 11.295,61.11 nfet_01v8
M$8580 167 1425 908 167 nfet_01v8 L=150000U W=210000U AS=21875000000P
+ AD=40400000000P PS=460000U PD=560000U
* device instance $8581 r0 *1 10.705,61.5 nfet_01v8
M$8581 2942 2462 167 167 nfet_01v8 L=150000U W=210000U AS=40400000000P
+ AD=21875000000P PS=560000U PD=460000U
* device instance $8582 r0 *1 11.295,61.5 nfet_01v8
M$8582 1425 908 167 167 nfet_01v8 L=150000U W=210000U AS=40400000000P
+ AD=21875000000P PS=560000U PD=460000U
* device instance $8583 r0 *1 10.74,61.9 nfet_01v8
M$8583 13 162 2942 167 nfet_01v8 L=150000U W=140000U AS=21875000000P
+ AD=16800000000P PS=460000U PD=380000U
* device instance $8584 r0 *1 11.26,61.9 nfet_01v8
M$8584 16 162 1425 167 nfet_01v8 L=150000U W=140000U AS=21875000000P
+ AD=16800000000P PS=460000U PD=380000U
* device instance $8585 r0 *1 10.74,62.29 nfet_01v8
M$8585 3713 163 13 167 nfet_01v8 L=150000U W=140000U AS=16800000000P
+ AD=21875000000P PS=380000U PD=460000U
* device instance $8586 r0 *1 11.26,62.29 nfet_01v8
M$8586 4432 163 16 167 nfet_01v8 L=150000U W=140000U AS=16800000000P
+ AD=21875000000P PS=380000U PD=460000U
* device instance $8587 r0 *1 10.705,62.69 nfet_01v8
M$8587 167 2058 3713 167 nfet_01v8 L=150000U W=210000U AS=21875000000P
+ AD=40400000000P PS=460000U PD=560000U
* device instance $8588 r0 *1 11.295,62.69 nfet_01v8
M$8588 167 770 4432 167 nfet_01v8 L=150000U W=210000U AS=21875000000P
+ AD=40400000000P PS=460000U PD=560000U
* device instance $8589 r0 *1 10.705,63.08 nfet_01v8
M$8589 2058 3713 167 167 nfet_01v8 L=150000U W=210000U AS=40400000000P
+ AD=21875000000P PS=560000U PD=460000U
* device instance $8590 r0 *1 11.295,63.08 nfet_01v8
M$8590 770 4432 167 167 nfet_01v8 L=150000U W=210000U AS=40400000000P
+ AD=21875000000P PS=560000U PD=460000U
* device instance $8591 r0 *1 10.74,63.48 nfet_01v8
M$8591 14 163 2058 167 nfet_01v8 L=150000U W=140000U AS=21875000000P
+ AD=16800000000P PS=460000U PD=380000U
* device instance $8592 r0 *1 11.26,63.48 nfet_01v8
M$8592 15 163 770 167 nfet_01v8 L=150000U W=140000U AS=21875000000P
+ AD=16800000000P PS=460000U PD=380000U
* device instance $8593 r0 *1 10.74,63.87 nfet_01v8
M$8593 2088 164 14 167 nfet_01v8 L=150000U W=140000U AS=16800000000P
+ AD=21875000000P PS=380000U PD=460000U
* device instance $8594 r0 *1 11.26,63.87 nfet_01v8
M$8594 914 164 15 167 nfet_01v8 L=150000U W=140000U AS=16800000000P
+ AD=21875000000P PS=380000U PD=460000U
* device instance $8595 r0 *1 10.705,64.27 nfet_01v8
M$8595 167 2175 2088 167 nfet_01v8 L=150000U W=210000U AS=21875000000P
+ AD=40400000000P PS=460000U PD=560000U
* device instance $8596 r0 *1 11.295,64.27 nfet_01v8
M$8596 167 1431 914 167 nfet_01v8 L=150000U W=210000U AS=21875000000P
+ AD=40400000000P PS=460000U PD=560000U
* device instance $8597 r0 *1 10.705,64.66 nfet_01v8
M$8597 2175 2088 167 167 nfet_01v8 L=150000U W=210000U AS=40400000000P
+ AD=21875000000P PS=560000U PD=460000U
* device instance $8598 r0 *1 11.295,64.66 nfet_01v8
M$8598 1431 914 167 167 nfet_01v8 L=150000U W=210000U AS=40400000000P
+ AD=21875000000P PS=560000U PD=460000U
* device instance $8599 r0 *1 10.74,65.06 nfet_01v8
M$8599 13 164 2175 167 nfet_01v8 L=150000U W=140000U AS=21875000000P
+ AD=16800000000P PS=460000U PD=380000U
* device instance $8600 r0 *1 11.26,65.06 nfet_01v8
M$8600 16 164 1431 167 nfet_01v8 L=150000U W=140000U AS=21875000000P
+ AD=16800000000P PS=460000U PD=380000U
* device instance $8601 r0 *1 10.74,65.45 nfet_01v8
M$8601 2507 165 13 167 nfet_01v8 L=150000U W=140000U AS=16800000000P
+ AD=21875000000P PS=380000U PD=460000U
* device instance $8602 r0 *1 11.26,65.45 nfet_01v8
M$8602 907 165 16 167 nfet_01v8 L=150000U W=140000U AS=16800000000P
+ AD=21875000000P PS=380000U PD=460000U
* device instance $8603 r0 *1 10.705,65.85 nfet_01v8
M$8603 167 3041 2507 167 nfet_01v8 L=150000U W=210000U AS=21875000000P
+ AD=40400000000P PS=460000U PD=560000U
* device instance $8604 r0 *1 11.295,65.85 nfet_01v8
M$8604 167 1424 907 167 nfet_01v8 L=150000U W=210000U AS=21875000000P
+ AD=40400000000P PS=460000U PD=560000U
* device instance $8605 r0 *1 10.705,66.24 nfet_01v8
M$8605 3041 2507 167 167 nfet_01v8 L=150000U W=210000U AS=40400000000P
+ AD=21875000000P PS=560000U PD=460000U
* device instance $8606 r0 *1 11.295,66.24 nfet_01v8
M$8606 1424 907 167 167 nfet_01v8 L=150000U W=210000U AS=40400000000P
+ AD=21875000000P PS=560000U PD=460000U
* device instance $8607 r0 *1 10.74,66.64 nfet_01v8
M$8607 14 165 3041 167 nfet_01v8 L=150000U W=140000U AS=21875000000P
+ AD=16800000000P PS=460000U PD=380000U
* device instance $8608 r0 *1 11.26,66.64 nfet_01v8
M$8608 15 165 1424 167 nfet_01v8 L=150000U W=140000U AS=21875000000P
+ AD=16800000000P PS=460000U PD=380000U
* device instance $8609 r0 *1 21.64,68.61 nfet_01v8
M$8609 3528 166 30 167 nfet_01v8 L=150000U W=140000U AS=16800000000P
+ AD=21875000000P PS=380000U PD=460000U
* device instance $8610 r0 *1 22.16,68.61 nfet_01v8
M$8610 934 166 31 167 nfet_01v8 L=150000U W=140000U AS=16800000000P
+ AD=21875000000P PS=380000U PD=460000U
* device instance $8611 r0 *1 21.605,69.01 nfet_01v8
M$8611 167 2989 3528 167 nfet_01v8 L=150000U W=210000U AS=21875000000P
+ AD=40400000000P PS=460000U PD=560000U
* device instance $8612 r0 *1 22.195,69.01 nfet_01v8
M$8612 167 1455 934 167 nfet_01v8 L=150000U W=210000U AS=21875000000P
+ AD=40400000000P PS=460000U PD=560000U
* device instance $8613 r0 *1 21.605,69.4 nfet_01v8
M$8613 2989 3528 167 167 nfet_01v8 L=150000U W=210000U AS=40400000000P
+ AD=21875000000P PS=560000U PD=460000U
* device instance $8614 r0 *1 22.195,69.4 nfet_01v8
M$8614 1455 934 167 167 nfet_01v8 L=150000U W=210000U AS=40400000000P
+ AD=21875000000P PS=560000U PD=460000U
* device instance $8615 r0 *1 21.64,69.8 nfet_01v8
M$8615 29 166 2989 167 nfet_01v8 L=150000U W=140000U AS=21875000000P
+ AD=16800000000P PS=460000U PD=380000U
* device instance $8616 r0 *1 22.16,69.8 nfet_01v8
M$8616 32 166 1455 167 nfet_01v8 L=150000U W=140000U AS=21875000000P
+ AD=16800000000P PS=460000U PD=380000U
* device instance $8617 r0 *1 32.54,68.61 nfet_01v8
M$8617 3541 166 46 167 nfet_01v8 L=150000U W=140000U AS=16800000000P
+ AD=21875000000P PS=380000U PD=460000U
* device instance $8618 r0 *1 33.06,68.61 nfet_01v8
M$8618 1322 166 47 167 nfet_01v8 L=150000U W=140000U AS=16800000000P
+ AD=21875000000P PS=380000U PD=460000U
* device instance $8619 r0 *1 32.505,69.01 nfet_01v8
M$8619 167 2549 3541 167 nfet_01v8 L=150000U W=210000U AS=21875000000P
+ AD=40400000000P PS=460000U PD=560000U
* device instance $8620 r0 *1 33.095,69.01 nfet_01v8
M$8620 167 1902 1322 167 nfet_01v8 L=150000U W=210000U AS=21875000000P
+ AD=40400000000P PS=460000U PD=560000U
* device instance $8621 r0 *1 32.505,69.4 nfet_01v8
M$8621 2549 3541 167 167 nfet_01v8 L=150000U W=210000U AS=40400000000P
+ AD=21875000000P PS=560000U PD=460000U
* device instance $8622 r0 *1 33.095,69.4 nfet_01v8
M$8622 1902 1322 167 167 nfet_01v8 L=150000U W=210000U AS=40400000000P
+ AD=21875000000P PS=560000U PD=460000U
* device instance $8623 r0 *1 32.54,69.8 nfet_01v8
M$8623 45 166 2549 167 nfet_01v8 L=150000U W=140000U AS=21875000000P
+ AD=16800000000P PS=460000U PD=380000U
* device instance $8624 r0 *1 33.06,69.8 nfet_01v8
M$8624 48 166 1902 167 nfet_01v8 L=150000U W=140000U AS=21875000000P
+ AD=16800000000P PS=460000U PD=380000U
* device instance $8625 r0 *1 43.44,68.61 nfet_01v8
M$8625 3492 166 62 167 nfet_01v8 L=150000U W=140000U AS=16800000000P
+ AD=21875000000P PS=380000U PD=460000U
* device instance $8626 r0 *1 43.96,68.61 nfet_01v8
M$8626 1271 166 63 167 nfet_01v8 L=150000U W=140000U AS=16800000000P
+ AD=21875000000P PS=380000U PD=460000U
* device instance $8627 r0 *1 43.405,69.01 nfet_01v8
M$8627 167 2560 3492 167 nfet_01v8 L=150000U W=210000U AS=21875000000P
+ AD=40400000000P PS=460000U PD=560000U
* device instance $8628 r0 *1 43.995,69.01 nfet_01v8
M$8628 167 1848 1271 167 nfet_01v8 L=150000U W=210000U AS=21875000000P
+ AD=40400000000P PS=460000U PD=560000U
* device instance $8629 r0 *1 43.405,69.4 nfet_01v8
M$8629 2560 3492 167 167 nfet_01v8 L=150000U W=210000U AS=40400000000P
+ AD=21875000000P PS=560000U PD=460000U
* device instance $8630 r0 *1 43.995,69.4 nfet_01v8
M$8630 1848 1271 167 167 nfet_01v8 L=150000U W=210000U AS=40400000000P
+ AD=21875000000P PS=560000U PD=460000U
* device instance $8631 r0 *1 43.44,69.8 nfet_01v8
M$8631 61 166 2560 167 nfet_01v8 L=150000U W=140000U AS=21875000000P
+ AD=16800000000P PS=460000U PD=380000U
* device instance $8632 r0 *1 43.96,69.8 nfet_01v8
M$8632 64 166 1848 167 nfet_01v8 L=150000U W=140000U AS=21875000000P
+ AD=16800000000P PS=460000U PD=380000U
* device instance $8633 r0 *1 54.34,68.61 nfet_01v8
M$8633 2280 166 78 167 nfet_01v8 L=150000U W=140000U AS=16800000000P
+ AD=21875000000P PS=380000U PD=460000U
* device instance $8634 r0 *1 54.86,68.61 nfet_01v8
M$8634 1371 166 79 167 nfet_01v8 L=150000U W=140000U AS=16800000000P
+ AD=21875000000P PS=380000U PD=460000U
* device instance $8635 r0 *1 54.305,69.01 nfet_01v8
M$8635 167 2586 2280 167 nfet_01v8 L=150000U W=210000U AS=21875000000P
+ AD=40400000000P PS=460000U PD=560000U
* device instance $8636 r0 *1 54.895,69.01 nfet_01v8
M$8636 167 1963 1371 167 nfet_01v8 L=150000U W=210000U AS=21875000000P
+ AD=40400000000P PS=460000U PD=560000U
* device instance $8637 r0 *1 54.305,69.4 nfet_01v8
M$8637 2586 2280 167 167 nfet_01v8 L=150000U W=210000U AS=40400000000P
+ AD=21875000000P PS=560000U PD=460000U
* device instance $8638 r0 *1 54.895,69.4 nfet_01v8
M$8638 1963 1371 167 167 nfet_01v8 L=150000U W=210000U AS=40400000000P
+ AD=21875000000P PS=560000U PD=460000U
* device instance $8639 r0 *1 54.34,69.8 nfet_01v8
M$8639 77 166 2586 167 nfet_01v8 L=150000U W=140000U AS=21875000000P
+ AD=16800000000P PS=460000U PD=380000U
* device instance $8640 r0 *1 54.86,69.8 nfet_01v8
M$8640 80 166 1963 167 nfet_01v8 L=150000U W=140000U AS=21875000000P
+ AD=16800000000P PS=460000U PD=380000U
* device instance $8641 r0 *1 65.24,68.61 nfet_01v8
M$8641 3130 166 94 167 nfet_01v8 L=150000U W=140000U AS=16800000000P
+ AD=21875000000P PS=380000U PD=460000U
* device instance $8642 r0 *1 65.76,68.61 nfet_01v8
M$8642 889 166 95 167 nfet_01v8 L=150000U W=140000U AS=16800000000P
+ AD=21875000000P PS=380000U PD=460000U
* device instance $8643 r0 *1 65.205,69.01 nfet_01v8
M$8643 167 3043 3130 167 nfet_01v8 L=150000U W=210000U AS=21875000000P
+ AD=40400000000P PS=460000U PD=560000U
* device instance $8644 r0 *1 65.795,69.01 nfet_01v8
M$8644 167 1403 889 167 nfet_01v8 L=150000U W=210000U AS=21875000000P
+ AD=40400000000P PS=460000U PD=560000U
* device instance $8645 r0 *1 65.205,69.4 nfet_01v8
M$8645 3043 3130 167 167 nfet_01v8 L=150000U W=210000U AS=40400000000P
+ AD=21875000000P PS=560000U PD=460000U
* device instance $8646 r0 *1 65.795,69.4 nfet_01v8
M$8646 1403 889 167 167 nfet_01v8 L=150000U W=210000U AS=40400000000P
+ AD=21875000000P PS=560000U PD=460000U
* device instance $8647 r0 *1 65.24,69.8 nfet_01v8
M$8647 93 166 3043 167 nfet_01v8 L=150000U W=140000U AS=21875000000P
+ AD=16800000000P PS=460000U PD=380000U
* device instance $8648 r0 *1 65.76,69.8 nfet_01v8
M$8648 96 166 1403 167 nfet_01v8 L=150000U W=140000U AS=21875000000P
+ AD=16800000000P PS=460000U PD=380000U
* device instance $8649 r0 *1 76.14,68.61 nfet_01v8
M$8649 3136 166 110 167 nfet_01v8 L=150000U W=140000U AS=16800000000P
+ AD=21875000000P PS=380000U PD=460000U
* device instance $8650 r0 *1 76.66,68.61 nfet_01v8
M$8650 1050 166 111 167 nfet_01v8 L=150000U W=140000U AS=16800000000P
+ AD=21875000000P PS=380000U PD=460000U
* device instance $8651 r0 *1 76.105,69.01 nfet_01v8
M$8651 167 2725 3136 167 nfet_01v8 L=150000U W=210000U AS=21875000000P
+ AD=40400000000P PS=460000U PD=560000U
* device instance $8652 r0 *1 76.695,69.01 nfet_01v8
M$8652 167 1593 1050 167 nfet_01v8 L=150000U W=210000U AS=21875000000P
+ AD=40400000000P PS=460000U PD=560000U
* device instance $8653 r0 *1 76.105,69.4 nfet_01v8
M$8653 2725 3136 167 167 nfet_01v8 L=150000U W=210000U AS=40400000000P
+ AD=21875000000P PS=560000U PD=460000U
* device instance $8654 r0 *1 76.695,69.4 nfet_01v8
M$8654 1593 1050 167 167 nfet_01v8 L=150000U W=210000U AS=40400000000P
+ AD=21875000000P PS=560000U PD=460000U
* device instance $8655 r0 *1 76.14,69.8 nfet_01v8
M$8655 109 166 2725 167 nfet_01v8 L=150000U W=140000U AS=21875000000P
+ AD=16800000000P PS=460000U PD=380000U
* device instance $8656 r0 *1 76.66,69.8 nfet_01v8
M$8656 112 166 1593 167 nfet_01v8 L=150000U W=140000U AS=21875000000P
+ AD=16800000000P PS=460000U PD=380000U
* device instance $8657 r0 *1 87.04,68.61 nfet_01v8
M$8657 2444 166 126 167 nfet_01v8 L=150000U W=140000U AS=16800000000P
+ AD=21875000000P PS=380000U PD=460000U
* device instance $8658 r0 *1 87.56,68.61 nfet_01v8
M$8658 1145 166 127 167 nfet_01v8 L=150000U W=140000U AS=16800000000P
+ AD=21875000000P PS=380000U PD=460000U
* device instance $8659 r0 *1 87.005,69.01 nfet_01v8
M$8659 167 2908 2444 167 nfet_01v8 L=150000U W=210000U AS=21875000000P
+ AD=40400000000P PS=460000U PD=560000U
* device instance $8660 r0 *1 87.595,69.01 nfet_01v8
M$8660 167 1702 1145 167 nfet_01v8 L=150000U W=210000U AS=21875000000P
+ AD=40400000000P PS=460000U PD=560000U
* device instance $8661 r0 *1 87.005,69.4 nfet_01v8
M$8661 2908 2444 167 167 nfet_01v8 L=150000U W=210000U AS=40400000000P
+ AD=21875000000P PS=560000U PD=460000U
* device instance $8662 r0 *1 87.595,69.4 nfet_01v8
M$8662 1702 1145 167 167 nfet_01v8 L=150000U W=210000U AS=40400000000P
+ AD=21875000000P PS=560000U PD=460000U
* device instance $8663 r0 *1 87.04,69.8 nfet_01v8
M$8663 125 166 2908 167 nfet_01v8 L=150000U W=140000U AS=21875000000P
+ AD=16800000000P PS=460000U PD=380000U
* device instance $8664 r0 *1 87.56,69.8 nfet_01v8
M$8664 128 166 1702 167 nfet_01v8 L=150000U W=140000U AS=21875000000P
+ AD=16800000000P PS=460000U PD=380000U
* device instance $8665 r0 *1 4.06,68.61 nfet_01v8
M$8665 3945 166 3 167 nfet_01v8 L=150000U W=140000U AS=16800000000P
+ AD=21875000000P PS=380000U PD=460000U
* device instance $8666 r0 *1 4.095,69.01 nfet_01v8
M$8666 167 4143 3945 167 nfet_01v8 L=150000U W=210000U AS=21875000000P
+ AD=51200000000P PS=460000U PD=775000U
* device instance $8667 r0 *1 4.095,69.4 nfet_01v8
M$8667 4143 3945 167 167 nfet_01v8 L=150000U W=210000U AS=51200000000P
+ AD=21875000000P PS=775000U PD=460000U
* device instance $8668 r0 *1 4.06,69.8 nfet_01v8
M$8668 4 166 4143 167 nfet_01v8 L=150000U W=140000U AS=21875000000P
+ AD=16800000000P PS=460000U PD=380000U
* device instance $8669 r0 *1 4.06,60.71 nfet_01v8
M$8669 3981 162 3 167 nfet_01v8 L=150000U W=140000U AS=16800000000P
+ AD=21875000000P PS=380000U PD=460000U
* device instance $8670 r0 *1 4.095,61.11 nfet_01v8
M$8670 167 4187 3981 167 nfet_01v8 L=150000U W=210000U AS=21875000000P
+ AD=51200000000P PS=460000U PD=775000U
* device instance $8671 r0 *1 4.095,61.5 nfet_01v8
M$8671 4187 3981 167 167 nfet_01v8 L=150000U W=210000U AS=51200000000P
+ AD=21875000000P PS=775000U PD=460000U
* device instance $8672 r0 *1 4.06,61.9 nfet_01v8
M$8672 4 162 4187 167 nfet_01v8 L=150000U W=140000U AS=21875000000P
+ AD=16800000000P PS=460000U PD=380000U
* device instance $8673 r0 *1 4.06,62.29 nfet_01v8
M$8673 4431 163 4 167 nfet_01v8 L=150000U W=140000U AS=16800000000P
+ AD=21875000000P PS=380000U PD=460000U
* device instance $8674 r0 *1 4.095,62.69 nfet_01v8
M$8674 167 3851 4431 167 nfet_01v8 L=150000U W=210000U AS=21875000000P
+ AD=51200000000P PS=460000U PD=775000U
* device instance $8675 r0 *1 4.095,63.08 nfet_01v8
M$8675 3851 4431 167 167 nfet_01v8 L=150000U W=210000U AS=51200000000P
+ AD=21875000000P PS=775000U PD=460000U
* device instance $8676 r0 *1 4.06,63.48 nfet_01v8
M$8676 3 163 3851 167 nfet_01v8 L=150000U W=140000U AS=21875000000P
+ AD=16800000000P PS=460000U PD=380000U
* device instance $8677 r0 *1 4.06,63.87 nfet_01v8
M$8677 3784 164 3 167 nfet_01v8 L=150000U W=140000U AS=16800000000P
+ AD=21875000000P PS=380000U PD=460000U
* device instance $8678 r0 *1 4.095,64.27 nfet_01v8
M$8678 167 3850 3784 167 nfet_01v8 L=150000U W=210000U AS=21875000000P
+ AD=51200000000P PS=460000U PD=775000U
* device instance $8679 r0 *1 4.095,64.66 nfet_01v8
M$8679 3850 3784 167 167 nfet_01v8 L=150000U W=210000U AS=51200000000P
+ AD=21875000000P PS=775000U PD=460000U
* device instance $8680 r0 *1 4.06,65.06 nfet_01v8
M$8680 4 164 3850 167 nfet_01v8 L=150000U W=140000U AS=21875000000P
+ AD=16800000000P PS=460000U PD=380000U
* device instance $8681 r0 *1 4.06,65.45 nfet_01v8
M$8681 3920 165 4 167 nfet_01v8 L=150000U W=140000U AS=16800000000P
+ AD=21875000000P PS=380000U PD=460000U
* device instance $8682 r0 *1 4.095,65.85 nfet_01v8
M$8682 167 4113 3920 167 nfet_01v8 L=150000U W=210000U AS=21875000000P
+ AD=51200000000P PS=460000U PD=775000U
* device instance $8683 r0 *1 4.095,66.24 nfet_01v8
M$8683 4113 3920 167 167 nfet_01v8 L=150000U W=210000U AS=51200000000P
+ AD=21875000000P PS=775000U PD=460000U
* device instance $8684 r0 *1 4.06,66.64 nfet_01v8
M$8684 3 165 4113 167 nfet_01v8 L=150000U W=140000U AS=21875000000P
+ AD=16800000000P PS=460000U PD=380000U
* device instance $8685 r0 *1 14.96,68.61 nfet_01v8
M$8685 3972 166 19 167 nfet_01v8 L=150000U W=140000U AS=16800000000P
+ AD=21875000000P PS=380000U PD=460000U
* device instance $8686 r0 *1 14.995,69.01 nfet_01v8
M$8686 167 4174 3972 167 nfet_01v8 L=150000U W=210000U AS=21875000000P
+ AD=51200000000P PS=460000U PD=775000U
* device instance $8687 r0 *1 14.995,69.4 nfet_01v8
M$8687 4174 3972 167 167 nfet_01v8 L=150000U W=210000U AS=51200000000P
+ AD=21875000000P PS=775000U PD=460000U
* device instance $8688 r0 *1 14.96,69.8 nfet_01v8
M$8688 20 166 4174 167 nfet_01v8 L=150000U W=140000U AS=21875000000P
+ AD=16800000000P PS=460000U PD=380000U
* device instance $8689 r0 *1 25.86,68.61 nfet_01v8
M$8689 4006 166 35 167 nfet_01v8 L=150000U W=140000U AS=16800000000P
+ AD=21875000000P PS=380000U PD=460000U
* device instance $8690 r0 *1 25.895,69.01 nfet_01v8
M$8690 167 4217 4006 167 nfet_01v8 L=150000U W=210000U AS=21875000000P
+ AD=51200000000P PS=460000U PD=775000U
* device instance $8691 r0 *1 25.895,69.4 nfet_01v8
M$8691 4217 4006 167 167 nfet_01v8 L=150000U W=210000U AS=51200000000P
+ AD=21875000000P PS=775000U PD=460000U
* device instance $8692 r0 *1 25.86,69.8 nfet_01v8
M$8692 36 166 4217 167 nfet_01v8 L=150000U W=140000U AS=21875000000P
+ AD=16800000000P PS=460000U PD=380000U
* device instance $8693 r0 *1 36.76,68.61 nfet_01v8
M$8693 4045 166 51 167 nfet_01v8 L=150000U W=140000U AS=16800000000P
+ AD=21875000000P PS=380000U PD=460000U
* device instance $8694 r0 *1 36.795,69.01 nfet_01v8
M$8694 167 4262 4045 167 nfet_01v8 L=150000U W=210000U AS=21875000000P
+ AD=51200000000P PS=460000U PD=775000U
* device instance $8695 r0 *1 36.795,69.4 nfet_01v8
M$8695 4262 4045 167 167 nfet_01v8 L=150000U W=210000U AS=51200000000P
+ AD=21875000000P PS=775000U PD=460000U
* device instance $8696 r0 *1 36.76,69.8 nfet_01v8
M$8696 52 166 4262 167 nfet_01v8 L=150000U W=140000U AS=21875000000P
+ AD=16800000000P PS=460000U PD=380000U
* device instance $8697 r0 *1 47.66,68.61 nfet_01v8
M$8697 3978 166 67 167 nfet_01v8 L=150000U W=140000U AS=16800000000P
+ AD=21875000000P PS=380000U PD=460000U
* device instance $8698 r0 *1 47.695,69.01 nfet_01v8
M$8698 167 4184 3978 167 nfet_01v8 L=150000U W=210000U AS=21875000000P
+ AD=51200000000P PS=460000U PD=775000U
* device instance $8699 r0 *1 47.695,69.4 nfet_01v8
M$8699 4184 3978 167 167 nfet_01v8 L=150000U W=210000U AS=51200000000P
+ AD=21875000000P PS=775000U PD=460000U
* device instance $8700 r0 *1 47.66,69.8 nfet_01v8
M$8700 68 166 4184 167 nfet_01v8 L=150000U W=140000U AS=21875000000P
+ AD=16800000000P PS=460000U PD=380000U
* device instance $8701 r0 *1 58.56,68.61 nfet_01v8
M$8701 4000 166 83 167 nfet_01v8 L=150000U W=140000U AS=16800000000P
+ AD=21875000000P PS=380000U PD=460000U
* device instance $8702 r0 *1 58.595,69.01 nfet_01v8
M$8702 167 4211 4000 167 nfet_01v8 L=150000U W=210000U AS=21875000000P
+ AD=51200000000P PS=460000U PD=775000U
* device instance $8703 r0 *1 58.595,69.4 nfet_01v8
M$8703 4211 4000 167 167 nfet_01v8 L=150000U W=210000U AS=51200000000P
+ AD=21875000000P PS=775000U PD=460000U
* device instance $8704 r0 *1 58.56,69.8 nfet_01v8
M$8704 84 166 4211 167 nfet_01v8 L=150000U W=140000U AS=21875000000P
+ AD=16800000000P PS=460000U PD=380000U
* device instance $8705 r0 *1 69.46,68.61 nfet_01v8
M$8705 3882 166 99 167 nfet_01v8 L=150000U W=140000U AS=16800000000P
+ AD=21875000000P PS=380000U PD=460000U
* device instance $8706 r0 *1 69.495,69.01 nfet_01v8
M$8706 167 4070 3882 167 nfet_01v8 L=150000U W=210000U AS=21875000000P
+ AD=51200000000P PS=460000U PD=775000U
* device instance $8707 r0 *1 69.495,69.4 nfet_01v8
M$8707 4070 3882 167 167 nfet_01v8 L=150000U W=210000U AS=51200000000P
+ AD=21875000000P PS=775000U PD=460000U
* device instance $8708 r0 *1 69.46,69.8 nfet_01v8
M$8708 100 166 4070 167 nfet_01v8 L=150000U W=140000U AS=21875000000P
+ AD=16800000000P PS=460000U PD=380000U
* device instance $8709 r0 *1 80.36,68.61 nfet_01v8
M$8709 3971 166 115 167 nfet_01v8 L=150000U W=140000U AS=16800000000P
+ AD=21875000000P PS=380000U PD=460000U
* device instance $8710 r0 *1 80.395,69.01 nfet_01v8
M$8710 167 4173 3971 167 nfet_01v8 L=150000U W=210000U AS=21875000000P
+ AD=51200000000P PS=460000U PD=775000U
* device instance $8711 r0 *1 80.395,69.4 nfet_01v8
M$8711 4173 3971 167 167 nfet_01v8 L=150000U W=210000U AS=51200000000P
+ AD=21875000000P PS=775000U PD=460000U
* device instance $8712 r0 *1 80.36,69.8 nfet_01v8
M$8712 116 166 4173 167 nfet_01v8 L=150000U W=140000U AS=21875000000P
+ AD=16800000000P PS=460000U PD=380000U
* device instance $8713 r0 *1 24.04,68.61 nfet_01v8
M$8713 308 166 34 167 nfet_01v8 L=150000U W=140000U AS=16800000000P
+ AD=21875000000P PS=380000U PD=460000U
* device instance $8714 r0 *1 24.005,69.01 nfet_01v8
M$8714 167 487 308 167 nfet_01v8 L=150000U W=210000U AS=21875000000P
+ AD=51200000000P PS=460000U PD=775000U
* device instance $8715 r0 *1 24.005,69.4 nfet_01v8
M$8715 487 308 167 167 nfet_01v8 L=150000U W=210000U AS=51200000000P
+ AD=21875000000P PS=775000U PD=460000U
* device instance $8716 r0 *1 24.04,69.8 nfet_01v8
M$8716 33 166 487 167 nfet_01v8 L=150000U W=140000U AS=21875000000P
+ AD=16800000000P PS=460000U PD=380000U
* device instance $8717 r0 *1 34.94,68.61 nfet_01v8
M$8717 271 166 50 167 nfet_01v8 L=150000U W=140000U AS=16800000000P
+ AD=21875000000P PS=380000U PD=460000U
* device instance $8718 r0 *1 34.905,69.01 nfet_01v8
M$8718 167 407 271 167 nfet_01v8 L=150000U W=210000U AS=21875000000P
+ AD=51200000000P PS=460000U PD=775000U
* device instance $8719 r0 *1 34.905,69.4 nfet_01v8
M$8719 407 271 167 167 nfet_01v8 L=150000U W=210000U AS=51200000000P
+ AD=21875000000P PS=775000U PD=460000U
* device instance $8720 r0 *1 34.94,69.8 nfet_01v8
M$8720 49 166 407 167 nfet_01v8 L=150000U W=140000U AS=21875000000P
+ AD=16800000000P PS=460000U PD=380000U
* device instance $8721 r0 *1 45.84,68.61 nfet_01v8
M$8721 3493 166 66 167 nfet_01v8 L=150000U W=140000U AS=16800000000P
+ AD=21875000000P PS=380000U PD=460000U
* device instance $8722 r0 *1 45.805,69.01 nfet_01v8
M$8722 167 456 3493 167 nfet_01v8 L=150000U W=210000U AS=21875000000P
+ AD=51200000000P PS=460000U PD=775000U
* device instance $8723 r0 *1 45.805,69.4 nfet_01v8
M$8723 456 3493 167 167 nfet_01v8 L=150000U W=210000U AS=51200000000P
+ AD=21875000000P PS=775000U PD=460000U
* device instance $8724 r0 *1 45.84,69.8 nfet_01v8
M$8724 65 166 456 167 nfet_01v8 L=150000U W=140000U AS=21875000000P
+ AD=16800000000P PS=460000U PD=380000U
* device instance $8725 r0 *1 56.74,68.61 nfet_01v8
M$8725 3133 166 82 167 nfet_01v8 L=150000U W=140000U AS=16800000000P
+ AD=21875000000P PS=380000U PD=460000U
* device instance $8726 r0 *1 56.705,69.01 nfet_01v8
M$8726 167 396 3133 167 nfet_01v8 L=150000U W=210000U AS=21875000000P
+ AD=51200000000P PS=460000U PD=775000U
* device instance $8727 r0 *1 56.705,69.4 nfet_01v8
M$8727 396 3133 167 167 nfet_01v8 L=150000U W=210000U AS=51200000000P
+ AD=21875000000P PS=775000U PD=460000U
* device instance $8728 r0 *1 56.74,69.8 nfet_01v8
M$8728 81 166 396 167 nfet_01v8 L=150000U W=140000U AS=21875000000P
+ AD=16800000000P PS=460000U PD=380000U
* device instance $8729 r0 *1 67.64,68.61 nfet_01v8
M$8729 301 166 98 167 nfet_01v8 L=150000U W=140000U AS=16800000000P
+ AD=21875000000P PS=380000U PD=460000U
* device instance $8730 r0 *1 67.605,69.01 nfet_01v8
M$8730 167 468 301 167 nfet_01v8 L=150000U W=210000U AS=21875000000P
+ AD=51200000000P PS=460000U PD=775000U
* device instance $8731 r0 *1 67.605,69.4 nfet_01v8
M$8731 468 301 167 167 nfet_01v8 L=150000U W=210000U AS=51200000000P
+ AD=21875000000P PS=775000U PD=460000U
* device instance $8732 r0 *1 67.64,69.8 nfet_01v8
M$8732 97 166 468 167 nfet_01v8 L=150000U W=140000U AS=21875000000P
+ AD=16800000000P PS=460000U PD=380000U
* device instance $8733 r0 *1 78.54,68.61 nfet_01v8
M$8733 247 166 114 167 nfet_01v8 L=150000U W=140000U AS=16800000000P
+ AD=21875000000P PS=380000U PD=460000U
* device instance $8734 r0 *1 78.505,69.01 nfet_01v8
M$8734 167 359 247 167 nfet_01v8 L=150000U W=210000U AS=21875000000P
+ AD=51200000000P PS=460000U PD=775000U
* device instance $8735 r0 *1 78.505,69.4 nfet_01v8
M$8735 359 247 167 167 nfet_01v8 L=150000U W=210000U AS=51200000000P
+ AD=21875000000P PS=775000U PD=460000U
* device instance $8736 r0 *1 78.54,69.8 nfet_01v8
M$8736 113 166 359 167 nfet_01v8 L=150000U W=140000U AS=21875000000P
+ AD=16800000000P PS=460000U PD=380000U
* device instance $8737 r0 *1 89.44,68.61 nfet_01v8
M$8737 279 166 130 167 nfet_01v8 L=150000U W=140000U AS=16800000000P
+ AD=21875000000P PS=380000U PD=460000U
* device instance $8738 r0 *1 89.405,69.01 nfet_01v8
M$8738 167 421 279 167 nfet_01v8 L=150000U W=210000U AS=21875000000P
+ AD=51200000000P PS=460000U PD=775000U
* device instance $8739 r0 *1 89.405,69.4 nfet_01v8
M$8739 421 279 167 167 nfet_01v8 L=150000U W=210000U AS=51200000000P
+ AD=21875000000P PS=775000U PD=460000U
* device instance $8740 r0 *1 89.44,69.8 nfet_01v8
M$8740 129 166 421 167 nfet_01v8 L=150000U W=140000U AS=21875000000P
+ AD=16800000000P PS=460000U PD=380000U
* device instance $8741 r0 *1 2.24,68.61 nfet_01v8
M$8741 3708 166 2 167 nfet_01v8 L=150000U W=140000U AS=16800000000P
+ AD=21875000000P PS=380000U PD=460000U
* device instance $8742 r0 *1 2.205,69.01 nfet_01v8
M$8742 167 467 3708 167 nfet_01v8 L=150000U W=210000U AS=21875000000P
+ AD=51200000000P PS=460000U PD=775000U
* device instance $8743 r0 *1 2.205,69.4 nfet_01v8
M$8743 467 3708 167 167 nfet_01v8 L=150000U W=210000U AS=51200000000P
+ AD=21875000000P PS=775000U PD=460000U
* device instance $8744 r0 *1 2.24,69.8 nfet_01v8
M$8744 1 166 467 167 nfet_01v8 L=150000U W=140000U AS=21875000000P
+ AD=16800000000P PS=460000U PD=380000U
* device instance $8745 r0 *1 13.14,68.61 nfet_01v8
M$8745 336 166 18 167 nfet_01v8 L=150000U W=140000U AS=16800000000P
+ AD=21875000000P PS=380000U PD=460000U
* device instance $8746 r0 *1 13.105,69.01 nfet_01v8
M$8746 167 539 336 167 nfet_01v8 L=150000U W=210000U AS=21875000000P
+ AD=51200000000P PS=460000U PD=775000U
* device instance $8747 r0 *1 13.105,69.4 nfet_01v8
M$8747 539 336 167 167 nfet_01v8 L=150000U W=210000U AS=51200000000P
+ AD=21875000000P PS=775000U PD=460000U
* device instance $8748 r0 *1 13.14,69.8 nfet_01v8
M$8748 17 166 539 167 nfet_01v8 L=150000U W=140000U AS=21875000000P
+ AD=16800000000P PS=460000U PD=380000U
* device instance $8749 r0 *1 91.26,2.25 nfet_01v8
M$8749 4543 133 132 167 nfet_01v8 L=150000U W=140000U AS=16800000000P
+ AD=21875000000P PS=380000U PD=460000U
* device instance $8750 r0 *1 91.295,2.65 nfet_01v8
M$8750 167 4542 4543 167 nfet_01v8 L=150000U W=210000U AS=21875000000P
+ AD=51200000000P PS=460000U PD=775000U
* device instance $8751 r0 *1 91.295,3.04 nfet_01v8
M$8751 4542 4543 167 167 nfet_01v8 L=150000U W=210000U AS=51200000000P
+ AD=21875000000P PS=775000U PD=460000U
* device instance $8752 r0 *1 91.26,3.44 nfet_01v8
M$8752 131 133 4542 167 nfet_01v8 L=150000U W=140000U AS=21875000000P
+ AD=16800000000P PS=460000U PD=380000U
* device instance $8753 r0 *1 10.74,2.25 nfet_01v8
M$8753 4553 133 13 167 nfet_01v8 L=150000U W=140000U AS=16800000000P
+ AD=21875000000P PS=380000U PD=460000U
* device instance $8754 r0 *1 11.26,2.25 nfet_01v8
M$8754 4556 133 16 167 nfet_01v8 L=150000U W=140000U AS=16800000000P
+ AD=21875000000P PS=380000U PD=460000U
* device instance $8755 r0 *1 10.705,2.65 nfet_01v8
M$8755 167 4546 4553 167 nfet_01v8 L=150000U W=210000U AS=21875000000P
+ AD=40400000000P PS=460000U PD=560000U
* device instance $8756 r0 *1 11.295,2.65 nfet_01v8
M$8756 167 4549 4556 167 nfet_01v8 L=150000U W=210000U AS=21875000000P
+ AD=40400000000P PS=460000U PD=560000U
* device instance $8757 r0 *1 10.705,3.04 nfet_01v8
M$8757 4546 4553 167 167 nfet_01v8 L=150000U W=210000U AS=40400000000P
+ AD=21875000000P PS=560000U PD=460000U
* device instance $8758 r0 *1 11.295,3.04 nfet_01v8
M$8758 4549 4556 167 167 nfet_01v8 L=150000U W=210000U AS=40400000000P
+ AD=21875000000P PS=560000U PD=460000U
* device instance $8759 r0 *1 10.74,3.44 nfet_01v8
M$8759 14 133 4546 167 nfet_01v8 L=150000U W=140000U AS=21875000000P
+ AD=16800000000P PS=460000U PD=380000U
* device instance $8760 r0 *1 11.26,3.44 nfet_01v8
M$8760 15 133 4549 167 nfet_01v8 L=150000U W=140000U AS=21875000000P
+ AD=16800000000P PS=460000U PD=380000U
* device instance $8761 r0 *1 8.34,2.25 nfet_01v8
M$8761 4552 133 9 167 nfet_01v8 L=150000U W=140000U AS=16800000000P
+ AD=21875000000P PS=380000U PD=460000U
* device instance $8762 r0 *1 8.86,2.25 nfet_01v8
M$8762 4557 133 12 167 nfet_01v8 L=150000U W=140000U AS=16800000000P
+ AD=21875000000P PS=380000U PD=460000U
* device instance $8763 r0 *1 8.305,2.65 nfet_01v8
M$8763 167 4545 4552 167 nfet_01v8 L=150000U W=210000U AS=21875000000P
+ AD=40400000000P PS=460000U PD=560000U
* device instance $8764 r0 *1 8.895,2.65 nfet_01v8
M$8764 167 4550 4557 167 nfet_01v8 L=150000U W=210000U AS=21875000000P
+ AD=40400000000P PS=460000U PD=560000U
* device instance $8765 r0 *1 8.305,3.04 nfet_01v8
M$8765 4545 4552 167 167 nfet_01v8 L=150000U W=210000U AS=40400000000P
+ AD=21875000000P PS=560000U PD=460000U
* device instance $8766 r0 *1 8.895,3.04 nfet_01v8
M$8766 4550 4557 167 167 nfet_01v8 L=150000U W=210000U AS=40400000000P
+ AD=21875000000P PS=560000U PD=460000U
* device instance $8767 r0 *1 8.34,3.44 nfet_01v8
M$8767 10 133 4545 167 nfet_01v8 L=150000U W=140000U AS=21875000000P
+ AD=16800000000P PS=460000U PD=380000U
* device instance $8768 r0 *1 8.86,3.44 nfet_01v8
M$8768 11 133 4550 167 nfet_01v8 L=150000U W=140000U AS=21875000000P
+ AD=16800000000P PS=460000U PD=380000U
* device instance $8769 r0 *1 5.94,2.25 nfet_01v8
M$8769 4551 133 5 167 nfet_01v8 L=150000U W=140000U AS=16800000000P
+ AD=21875000000P PS=380000U PD=460000U
* device instance $8770 r0 *1 6.46,2.25 nfet_01v8
M$8770 4555 133 8 167 nfet_01v8 L=150000U W=140000U AS=16800000000P
+ AD=21875000000P PS=380000U PD=460000U
* device instance $8771 r0 *1 5.905,2.65 nfet_01v8
M$8771 167 4544 4551 167 nfet_01v8 L=150000U W=210000U AS=21875000000P
+ AD=40400000000P PS=460000U PD=560000U
* device instance $8772 r0 *1 6.495,2.65 nfet_01v8
M$8772 167 4548 4555 167 nfet_01v8 L=150000U W=210000U AS=21875000000P
+ AD=40400000000P PS=460000U PD=560000U
* device instance $8773 r0 *1 5.905,3.04 nfet_01v8
M$8773 4544 4551 167 167 nfet_01v8 L=150000U W=210000U AS=40400000000P
+ AD=21875000000P PS=560000U PD=460000U
* device instance $8774 r0 *1 6.495,3.04 nfet_01v8
M$8774 4548 4555 167 167 nfet_01v8 L=150000U W=210000U AS=40400000000P
+ AD=21875000000P PS=560000U PD=460000U
* device instance $8775 r0 *1 5.94,3.44 nfet_01v8
M$8775 6 133 4544 167 nfet_01v8 L=150000U W=140000U AS=21875000000P
+ AD=16800000000P PS=460000U PD=380000U
* device instance $8776 r0 *1 6.46,3.44 nfet_01v8
M$8776 7 133 4548 167 nfet_01v8 L=150000U W=140000U AS=21875000000P
+ AD=16800000000P PS=460000U PD=380000U
* device instance $8777 r0 *1 4.06,2.25 nfet_01v8
M$8777 4554 133 4 167 nfet_01v8 L=150000U W=140000U AS=16800000000P
+ AD=21875000000P PS=380000U PD=460000U
* device instance $8778 r0 *1 4.095,2.65 nfet_01v8
M$8778 167 4547 4554 167 nfet_01v8 L=150000U W=210000U AS=21875000000P
+ AD=51200000000P PS=460000U PD=775000U
* device instance $8779 r0 *1 4.095,3.04 nfet_01v8
M$8779 4547 4554 167 167 nfet_01v8 L=150000U W=210000U AS=51200000000P
+ AD=21875000000P PS=775000U PD=460000U
* device instance $8780 r0 *1 4.06,3.44 nfet_01v8
M$8780 3 133 4547 167 nfet_01v8 L=150000U W=140000U AS=21875000000P
+ AD=16800000000P PS=460000U PD=380000U
* device instance $8781 r0 *1 21.64,2.25 nfet_01v8
M$8781 4567 133 29 167 nfet_01v8 L=150000U W=140000U AS=16800000000P
+ AD=21875000000P PS=380000U PD=460000U
* device instance $8782 r0 *1 22.16,2.25 nfet_01v8
M$8782 4570 133 32 167 nfet_01v8 L=150000U W=140000U AS=16800000000P
+ AD=21875000000P PS=380000U PD=460000U
* device instance $8783 r0 *1 21.605,2.65 nfet_01v8
M$8783 167 4560 4567 167 nfet_01v8 L=150000U W=210000U AS=21875000000P
+ AD=40400000000P PS=460000U PD=560000U
* device instance $8784 r0 *1 22.195,2.65 nfet_01v8
M$8784 167 4563 4570 167 nfet_01v8 L=150000U W=210000U AS=21875000000P
+ AD=40400000000P PS=460000U PD=560000U
* device instance $8785 r0 *1 21.605,3.04 nfet_01v8
M$8785 4560 4567 167 167 nfet_01v8 L=150000U W=210000U AS=40400000000P
+ AD=21875000000P PS=560000U PD=460000U
* device instance $8786 r0 *1 22.195,3.04 nfet_01v8
M$8786 4563 4570 167 167 nfet_01v8 L=150000U W=210000U AS=40400000000P
+ AD=21875000000P PS=560000U PD=460000U
* device instance $8787 r0 *1 21.64,3.44 nfet_01v8
M$8787 30 133 4560 167 nfet_01v8 L=150000U W=140000U AS=21875000000P
+ AD=16800000000P PS=460000U PD=380000U
* device instance $8788 r0 *1 22.16,3.44 nfet_01v8
M$8788 31 133 4563 167 nfet_01v8 L=150000U W=140000U AS=21875000000P
+ AD=16800000000P PS=460000U PD=380000U
* device instance $8789 r0 *1 19.24,2.25 nfet_01v8
M$8789 4566 133 25 167 nfet_01v8 L=150000U W=140000U AS=16800000000P
+ AD=21875000000P PS=380000U PD=460000U
* device instance $8790 r0 *1 19.76,2.25 nfet_01v8
M$8790 4571 133 28 167 nfet_01v8 L=150000U W=140000U AS=16800000000P
+ AD=21875000000P PS=380000U PD=460000U
* device instance $8791 r0 *1 19.205,2.65 nfet_01v8
M$8791 167 4559 4566 167 nfet_01v8 L=150000U W=210000U AS=21875000000P
+ AD=40400000000P PS=460000U PD=560000U
* device instance $8792 r0 *1 19.795,2.65 nfet_01v8
M$8792 167 4564 4571 167 nfet_01v8 L=150000U W=210000U AS=21875000000P
+ AD=40400000000P PS=460000U PD=560000U
* device instance $8793 r0 *1 19.205,3.04 nfet_01v8
M$8793 4559 4566 167 167 nfet_01v8 L=150000U W=210000U AS=40400000000P
+ AD=21875000000P PS=560000U PD=460000U
* device instance $8794 r0 *1 19.795,3.04 nfet_01v8
M$8794 4564 4571 167 167 nfet_01v8 L=150000U W=210000U AS=40400000000P
+ AD=21875000000P PS=560000U PD=460000U
* device instance $8795 r0 *1 19.24,3.44 nfet_01v8
M$8795 26 133 4559 167 nfet_01v8 L=150000U W=140000U AS=21875000000P
+ AD=16800000000P PS=460000U PD=380000U
* device instance $8796 r0 *1 19.76,3.44 nfet_01v8
M$8796 27 133 4564 167 nfet_01v8 L=150000U W=140000U AS=21875000000P
+ AD=16800000000P PS=460000U PD=380000U
* device instance $8797 r0 *1 16.84,2.25 nfet_01v8
M$8797 4565 133 21 167 nfet_01v8 L=150000U W=140000U AS=16800000000P
+ AD=21875000000P PS=380000U PD=460000U
* device instance $8798 r0 *1 17.36,2.25 nfet_01v8
M$8798 4569 133 24 167 nfet_01v8 L=150000U W=140000U AS=16800000000P
+ AD=21875000000P PS=380000U PD=460000U
* device instance $8799 r0 *1 16.805,2.65 nfet_01v8
M$8799 167 4558 4565 167 nfet_01v8 L=150000U W=210000U AS=21875000000P
+ AD=40400000000P PS=460000U PD=560000U
* device instance $8800 r0 *1 17.395,2.65 nfet_01v8
M$8800 167 4562 4569 167 nfet_01v8 L=150000U W=210000U AS=21875000000P
+ AD=40400000000P PS=460000U PD=560000U
* device instance $8801 r0 *1 16.805,3.04 nfet_01v8
M$8801 4558 4565 167 167 nfet_01v8 L=150000U W=210000U AS=40400000000P
+ AD=21875000000P PS=560000U PD=460000U
* device instance $8802 r0 *1 17.395,3.04 nfet_01v8
M$8802 4562 4569 167 167 nfet_01v8 L=150000U W=210000U AS=40400000000P
+ AD=21875000000P PS=560000U PD=460000U
* device instance $8803 r0 *1 16.84,3.44 nfet_01v8
M$8803 22 133 4558 167 nfet_01v8 L=150000U W=140000U AS=21875000000P
+ AD=16800000000P PS=460000U PD=380000U
* device instance $8804 r0 *1 17.36,3.44 nfet_01v8
M$8804 23 133 4562 167 nfet_01v8 L=150000U W=140000U AS=21875000000P
+ AD=16800000000P PS=460000U PD=380000U
* device instance $8805 r0 *1 14.96,2.25 nfet_01v8
M$8805 4568 133 20 167 nfet_01v8 L=150000U W=140000U AS=16800000000P
+ AD=21875000000P PS=380000U PD=460000U
* device instance $8806 r0 *1 14.995,2.65 nfet_01v8
M$8806 167 4561 4568 167 nfet_01v8 L=150000U W=210000U AS=21875000000P
+ AD=51200000000P PS=460000U PD=775000U
* device instance $8807 r0 *1 14.995,3.04 nfet_01v8
M$8807 4561 4568 167 167 nfet_01v8 L=150000U W=210000U AS=51200000000P
+ AD=21875000000P PS=775000U PD=460000U
* device instance $8808 r0 *1 14.96,3.44 nfet_01v8
M$8808 19 133 4561 167 nfet_01v8 L=150000U W=140000U AS=21875000000P
+ AD=16800000000P PS=460000U PD=380000U
* device instance $8809 r0 *1 32.54,2.25 nfet_01v8
M$8809 4581 133 45 167 nfet_01v8 L=150000U W=140000U AS=16800000000P
+ AD=21875000000P PS=380000U PD=460000U
* device instance $8810 r0 *1 33.06,2.25 nfet_01v8
M$8810 4584 133 48 167 nfet_01v8 L=150000U W=140000U AS=16800000000P
+ AD=21875000000P PS=380000U PD=460000U
* device instance $8811 r0 *1 32.505,2.65 nfet_01v8
M$8811 167 4574 4581 167 nfet_01v8 L=150000U W=210000U AS=21875000000P
+ AD=40400000000P PS=460000U PD=560000U
* device instance $8812 r0 *1 33.095,2.65 nfet_01v8
M$8812 167 4577 4584 167 nfet_01v8 L=150000U W=210000U AS=21875000000P
+ AD=40400000000P PS=460000U PD=560000U
* device instance $8813 r0 *1 32.505,3.04 nfet_01v8
M$8813 4574 4581 167 167 nfet_01v8 L=150000U W=210000U AS=40400000000P
+ AD=21875000000P PS=560000U PD=460000U
* device instance $8814 r0 *1 33.095,3.04 nfet_01v8
M$8814 4577 4584 167 167 nfet_01v8 L=150000U W=210000U AS=40400000000P
+ AD=21875000000P PS=560000U PD=460000U
* device instance $8815 r0 *1 32.54,3.44 nfet_01v8
M$8815 46 133 4574 167 nfet_01v8 L=150000U W=140000U AS=21875000000P
+ AD=16800000000P PS=460000U PD=380000U
* device instance $8816 r0 *1 33.06,3.44 nfet_01v8
M$8816 47 133 4577 167 nfet_01v8 L=150000U W=140000U AS=21875000000P
+ AD=16800000000P PS=460000U PD=380000U
* device instance $8817 r0 *1 30.14,2.25 nfet_01v8
M$8817 4580 133 41 167 nfet_01v8 L=150000U W=140000U AS=16800000000P
+ AD=21875000000P PS=380000U PD=460000U
* device instance $8818 r0 *1 30.66,2.25 nfet_01v8
M$8818 4585 133 44 167 nfet_01v8 L=150000U W=140000U AS=16800000000P
+ AD=21875000000P PS=380000U PD=460000U
* device instance $8819 r0 *1 30.105,2.65 nfet_01v8
M$8819 167 4573 4580 167 nfet_01v8 L=150000U W=210000U AS=21875000000P
+ AD=40400000000P PS=460000U PD=560000U
* device instance $8820 r0 *1 30.695,2.65 nfet_01v8
M$8820 167 4578 4585 167 nfet_01v8 L=150000U W=210000U AS=21875000000P
+ AD=40400000000P PS=460000U PD=560000U
* device instance $8821 r0 *1 30.105,3.04 nfet_01v8
M$8821 4573 4580 167 167 nfet_01v8 L=150000U W=210000U AS=40400000000P
+ AD=21875000000P PS=560000U PD=460000U
* device instance $8822 r0 *1 30.695,3.04 nfet_01v8
M$8822 4578 4585 167 167 nfet_01v8 L=150000U W=210000U AS=40400000000P
+ AD=21875000000P PS=560000U PD=460000U
* device instance $8823 r0 *1 30.14,3.44 nfet_01v8
M$8823 42 133 4573 167 nfet_01v8 L=150000U W=140000U AS=21875000000P
+ AD=16800000000P PS=460000U PD=380000U
* device instance $8824 r0 *1 30.66,3.44 nfet_01v8
M$8824 43 133 4578 167 nfet_01v8 L=150000U W=140000U AS=21875000000P
+ AD=16800000000P PS=460000U PD=380000U
* device instance $8825 r0 *1 27.74,2.25 nfet_01v8
M$8825 4579 133 37 167 nfet_01v8 L=150000U W=140000U AS=16800000000P
+ AD=21875000000P PS=380000U PD=460000U
* device instance $8826 r0 *1 28.26,2.25 nfet_01v8
M$8826 4583 133 40 167 nfet_01v8 L=150000U W=140000U AS=16800000000P
+ AD=21875000000P PS=380000U PD=460000U
* device instance $8827 r0 *1 27.705,2.65 nfet_01v8
M$8827 167 4572 4579 167 nfet_01v8 L=150000U W=210000U AS=21875000000P
+ AD=40400000000P PS=460000U PD=560000U
* device instance $8828 r0 *1 28.295,2.65 nfet_01v8
M$8828 167 4576 4583 167 nfet_01v8 L=150000U W=210000U AS=21875000000P
+ AD=40400000000P PS=460000U PD=560000U
* device instance $8829 r0 *1 27.705,3.04 nfet_01v8
M$8829 4572 4579 167 167 nfet_01v8 L=150000U W=210000U AS=40400000000P
+ AD=21875000000P PS=560000U PD=460000U
* device instance $8830 r0 *1 28.295,3.04 nfet_01v8
M$8830 4576 4583 167 167 nfet_01v8 L=150000U W=210000U AS=40400000000P
+ AD=21875000000P PS=560000U PD=460000U
* device instance $8831 r0 *1 27.74,3.44 nfet_01v8
M$8831 38 133 4572 167 nfet_01v8 L=150000U W=140000U AS=21875000000P
+ AD=16800000000P PS=460000U PD=380000U
* device instance $8832 r0 *1 28.26,3.44 nfet_01v8
M$8832 39 133 4576 167 nfet_01v8 L=150000U W=140000U AS=21875000000P
+ AD=16800000000P PS=460000U PD=380000U
* device instance $8833 r0 *1 25.86,2.25 nfet_01v8
M$8833 4582 133 36 167 nfet_01v8 L=150000U W=140000U AS=16800000000P
+ AD=21875000000P PS=380000U PD=460000U
* device instance $8834 r0 *1 25.895,2.65 nfet_01v8
M$8834 167 4575 4582 167 nfet_01v8 L=150000U W=210000U AS=21875000000P
+ AD=51200000000P PS=460000U PD=775000U
* device instance $8835 r0 *1 25.895,3.04 nfet_01v8
M$8835 4575 4582 167 167 nfet_01v8 L=150000U W=210000U AS=51200000000P
+ AD=21875000000P PS=775000U PD=460000U
* device instance $8836 r0 *1 25.86,3.44 nfet_01v8
M$8836 35 133 4575 167 nfet_01v8 L=150000U W=140000U AS=21875000000P
+ AD=16800000000P PS=460000U PD=380000U
* device instance $8837 r0 *1 43.44,2.25 nfet_01v8
M$8837 4595 133 61 167 nfet_01v8 L=150000U W=140000U AS=16800000000P
+ AD=21875000000P PS=380000U PD=460000U
* device instance $8838 r0 *1 43.96,2.25 nfet_01v8
M$8838 4598 133 64 167 nfet_01v8 L=150000U W=140000U AS=16800000000P
+ AD=21875000000P PS=380000U PD=460000U
* device instance $8839 r0 *1 43.405,2.65 nfet_01v8
M$8839 167 4588 4595 167 nfet_01v8 L=150000U W=210000U AS=21875000000P
+ AD=40400000000P PS=460000U PD=560000U
* device instance $8840 r0 *1 43.995,2.65 nfet_01v8
M$8840 167 4591 4598 167 nfet_01v8 L=150000U W=210000U AS=21875000000P
+ AD=40400000000P PS=460000U PD=560000U
* device instance $8841 r0 *1 43.405,3.04 nfet_01v8
M$8841 4588 4595 167 167 nfet_01v8 L=150000U W=210000U AS=40400000000P
+ AD=21875000000P PS=560000U PD=460000U
* device instance $8842 r0 *1 43.995,3.04 nfet_01v8
M$8842 4591 4598 167 167 nfet_01v8 L=150000U W=210000U AS=40400000000P
+ AD=21875000000P PS=560000U PD=460000U
* device instance $8843 r0 *1 43.44,3.44 nfet_01v8
M$8843 62 133 4588 167 nfet_01v8 L=150000U W=140000U AS=21875000000P
+ AD=16800000000P PS=460000U PD=380000U
* device instance $8844 r0 *1 43.96,3.44 nfet_01v8
M$8844 63 133 4591 167 nfet_01v8 L=150000U W=140000U AS=21875000000P
+ AD=16800000000P PS=460000U PD=380000U
* device instance $8845 r0 *1 41.04,2.25 nfet_01v8
M$8845 4594 133 57 167 nfet_01v8 L=150000U W=140000U AS=16800000000P
+ AD=21875000000P PS=380000U PD=460000U
* device instance $8846 r0 *1 41.56,2.25 nfet_01v8
M$8846 4599 133 60 167 nfet_01v8 L=150000U W=140000U AS=16800000000P
+ AD=21875000000P PS=380000U PD=460000U
* device instance $8847 r0 *1 41.005,2.65 nfet_01v8
M$8847 167 4587 4594 167 nfet_01v8 L=150000U W=210000U AS=21875000000P
+ AD=40400000000P PS=460000U PD=560000U
* device instance $8848 r0 *1 41.595,2.65 nfet_01v8
M$8848 167 4592 4599 167 nfet_01v8 L=150000U W=210000U AS=21875000000P
+ AD=40400000000P PS=460000U PD=560000U
* device instance $8849 r0 *1 41.005,3.04 nfet_01v8
M$8849 4587 4594 167 167 nfet_01v8 L=150000U W=210000U AS=40400000000P
+ AD=21875000000P PS=560000U PD=460000U
* device instance $8850 r0 *1 41.595,3.04 nfet_01v8
M$8850 4592 4599 167 167 nfet_01v8 L=150000U W=210000U AS=40400000000P
+ AD=21875000000P PS=560000U PD=460000U
* device instance $8851 r0 *1 41.04,3.44 nfet_01v8
M$8851 58 133 4587 167 nfet_01v8 L=150000U W=140000U AS=21875000000P
+ AD=16800000000P PS=460000U PD=380000U
* device instance $8852 r0 *1 41.56,3.44 nfet_01v8
M$8852 59 133 4592 167 nfet_01v8 L=150000U W=140000U AS=21875000000P
+ AD=16800000000P PS=460000U PD=380000U
* device instance $8853 r0 *1 38.64,2.25 nfet_01v8
M$8853 4593 133 53 167 nfet_01v8 L=150000U W=140000U AS=16800000000P
+ AD=21875000000P PS=380000U PD=460000U
* device instance $8854 r0 *1 39.16,2.25 nfet_01v8
M$8854 4597 133 56 167 nfet_01v8 L=150000U W=140000U AS=16800000000P
+ AD=21875000000P PS=380000U PD=460000U
* device instance $8855 r0 *1 38.605,2.65 nfet_01v8
M$8855 167 4586 4593 167 nfet_01v8 L=150000U W=210000U AS=21875000000P
+ AD=40400000000P PS=460000U PD=560000U
* device instance $8856 r0 *1 39.195,2.65 nfet_01v8
M$8856 167 4590 4597 167 nfet_01v8 L=150000U W=210000U AS=21875000000P
+ AD=40400000000P PS=460000U PD=560000U
* device instance $8857 r0 *1 38.605,3.04 nfet_01v8
M$8857 4586 4593 167 167 nfet_01v8 L=150000U W=210000U AS=40400000000P
+ AD=21875000000P PS=560000U PD=460000U
* device instance $8858 r0 *1 39.195,3.04 nfet_01v8
M$8858 4590 4597 167 167 nfet_01v8 L=150000U W=210000U AS=40400000000P
+ AD=21875000000P PS=560000U PD=460000U
* device instance $8859 r0 *1 38.64,3.44 nfet_01v8
M$8859 54 133 4586 167 nfet_01v8 L=150000U W=140000U AS=21875000000P
+ AD=16800000000P PS=460000U PD=380000U
* device instance $8860 r0 *1 39.16,3.44 nfet_01v8
M$8860 55 133 4590 167 nfet_01v8 L=150000U W=140000U AS=21875000000P
+ AD=16800000000P PS=460000U PD=380000U
* device instance $8861 r0 *1 36.76,2.25 nfet_01v8
M$8861 4596 133 52 167 nfet_01v8 L=150000U W=140000U AS=16800000000P
+ AD=21875000000P PS=380000U PD=460000U
* device instance $8862 r0 *1 36.795,2.65 nfet_01v8
M$8862 167 4589 4596 167 nfet_01v8 L=150000U W=210000U AS=21875000000P
+ AD=51200000000P PS=460000U PD=775000U
* device instance $8863 r0 *1 36.795,3.04 nfet_01v8
M$8863 4589 4596 167 167 nfet_01v8 L=150000U W=210000U AS=51200000000P
+ AD=21875000000P PS=775000U PD=460000U
* device instance $8864 r0 *1 36.76,3.44 nfet_01v8
M$8864 51 133 4589 167 nfet_01v8 L=150000U W=140000U AS=21875000000P
+ AD=16800000000P PS=460000U PD=380000U
* device instance $8865 r0 *1 54.34,2.25 nfet_01v8
M$8865 4609 133 77 167 nfet_01v8 L=150000U W=140000U AS=16800000000P
+ AD=21875000000P PS=380000U PD=460000U
* device instance $8866 r0 *1 54.86,2.25 nfet_01v8
M$8866 4612 133 80 167 nfet_01v8 L=150000U W=140000U AS=16800000000P
+ AD=21875000000P PS=380000U PD=460000U
* device instance $8867 r0 *1 54.305,2.65 nfet_01v8
M$8867 167 4602 4609 167 nfet_01v8 L=150000U W=210000U AS=21875000000P
+ AD=40400000000P PS=460000U PD=560000U
* device instance $8868 r0 *1 54.895,2.65 nfet_01v8
M$8868 167 4605 4612 167 nfet_01v8 L=150000U W=210000U AS=21875000000P
+ AD=40400000000P PS=460000U PD=560000U
* device instance $8869 r0 *1 54.305,3.04 nfet_01v8
M$8869 4602 4609 167 167 nfet_01v8 L=150000U W=210000U AS=40400000000P
+ AD=21875000000P PS=560000U PD=460000U
* device instance $8870 r0 *1 54.895,3.04 nfet_01v8
M$8870 4605 4612 167 167 nfet_01v8 L=150000U W=210000U AS=40400000000P
+ AD=21875000000P PS=560000U PD=460000U
* device instance $8871 r0 *1 54.34,3.44 nfet_01v8
M$8871 78 133 4602 167 nfet_01v8 L=150000U W=140000U AS=21875000000P
+ AD=16800000000P PS=460000U PD=380000U
* device instance $8872 r0 *1 54.86,3.44 nfet_01v8
M$8872 79 133 4605 167 nfet_01v8 L=150000U W=140000U AS=21875000000P
+ AD=16800000000P PS=460000U PD=380000U
* device instance $8873 r0 *1 51.94,2.25 nfet_01v8
M$8873 4608 133 73 167 nfet_01v8 L=150000U W=140000U AS=16800000000P
+ AD=21875000000P PS=380000U PD=460000U
* device instance $8874 r0 *1 52.46,2.25 nfet_01v8
M$8874 4613 133 76 167 nfet_01v8 L=150000U W=140000U AS=16800000000P
+ AD=21875000000P PS=380000U PD=460000U
* device instance $8875 r0 *1 51.905,2.65 nfet_01v8
M$8875 167 4601 4608 167 nfet_01v8 L=150000U W=210000U AS=21875000000P
+ AD=40400000000P PS=460000U PD=560000U
* device instance $8876 r0 *1 52.495,2.65 nfet_01v8
M$8876 167 4606 4613 167 nfet_01v8 L=150000U W=210000U AS=21875000000P
+ AD=40400000000P PS=460000U PD=560000U
* device instance $8877 r0 *1 51.905,3.04 nfet_01v8
M$8877 4601 4608 167 167 nfet_01v8 L=150000U W=210000U AS=40400000000P
+ AD=21875000000P PS=560000U PD=460000U
* device instance $8878 r0 *1 52.495,3.04 nfet_01v8
M$8878 4606 4613 167 167 nfet_01v8 L=150000U W=210000U AS=40400000000P
+ AD=21875000000P PS=560000U PD=460000U
* device instance $8879 r0 *1 51.94,3.44 nfet_01v8
M$8879 74 133 4601 167 nfet_01v8 L=150000U W=140000U AS=21875000000P
+ AD=16800000000P PS=460000U PD=380000U
* device instance $8880 r0 *1 52.46,3.44 nfet_01v8
M$8880 75 133 4606 167 nfet_01v8 L=150000U W=140000U AS=21875000000P
+ AD=16800000000P PS=460000U PD=380000U
* device instance $8881 r0 *1 49.54,2.25 nfet_01v8
M$8881 4607 133 69 167 nfet_01v8 L=150000U W=140000U AS=16800000000P
+ AD=21875000000P PS=380000U PD=460000U
* device instance $8882 r0 *1 50.06,2.25 nfet_01v8
M$8882 4611 133 72 167 nfet_01v8 L=150000U W=140000U AS=16800000000P
+ AD=21875000000P PS=380000U PD=460000U
* device instance $8883 r0 *1 49.505,2.65 nfet_01v8
M$8883 167 4600 4607 167 nfet_01v8 L=150000U W=210000U AS=21875000000P
+ AD=40400000000P PS=460000U PD=560000U
* device instance $8884 r0 *1 50.095,2.65 nfet_01v8
M$8884 167 4604 4611 167 nfet_01v8 L=150000U W=210000U AS=21875000000P
+ AD=40400000000P PS=460000U PD=560000U
* device instance $8885 r0 *1 49.505,3.04 nfet_01v8
M$8885 4600 4607 167 167 nfet_01v8 L=150000U W=210000U AS=40400000000P
+ AD=21875000000P PS=560000U PD=460000U
* device instance $8886 r0 *1 50.095,3.04 nfet_01v8
M$8886 4604 4611 167 167 nfet_01v8 L=150000U W=210000U AS=40400000000P
+ AD=21875000000P PS=560000U PD=460000U
* device instance $8887 r0 *1 49.54,3.44 nfet_01v8
M$8887 70 133 4600 167 nfet_01v8 L=150000U W=140000U AS=21875000000P
+ AD=16800000000P PS=460000U PD=380000U
* device instance $8888 r0 *1 50.06,3.44 nfet_01v8
M$8888 71 133 4604 167 nfet_01v8 L=150000U W=140000U AS=21875000000P
+ AD=16800000000P PS=460000U PD=380000U
* device instance $8889 r0 *1 47.66,2.25 nfet_01v8
M$8889 4610 133 68 167 nfet_01v8 L=150000U W=140000U AS=16800000000P
+ AD=21875000000P PS=380000U PD=460000U
* device instance $8890 r0 *1 47.695,2.65 nfet_01v8
M$8890 167 4603 4610 167 nfet_01v8 L=150000U W=210000U AS=21875000000P
+ AD=51200000000P PS=460000U PD=775000U
* device instance $8891 r0 *1 47.695,3.04 nfet_01v8
M$8891 4603 4610 167 167 nfet_01v8 L=150000U W=210000U AS=51200000000P
+ AD=21875000000P PS=775000U PD=460000U
* device instance $8892 r0 *1 47.66,3.44 nfet_01v8
M$8892 67 133 4603 167 nfet_01v8 L=150000U W=140000U AS=21875000000P
+ AD=16800000000P PS=460000U PD=380000U
* device instance $8893 r0 *1 65.24,2.25 nfet_01v8
M$8893 4623 133 93 167 nfet_01v8 L=150000U W=140000U AS=16800000000P
+ AD=21875000000P PS=380000U PD=460000U
* device instance $8894 r0 *1 65.76,2.25 nfet_01v8
M$8894 4626 133 96 167 nfet_01v8 L=150000U W=140000U AS=16800000000P
+ AD=21875000000P PS=380000U PD=460000U
* device instance $8895 r0 *1 65.205,2.65 nfet_01v8
M$8895 167 4616 4623 167 nfet_01v8 L=150000U W=210000U AS=21875000000P
+ AD=40400000000P PS=460000U PD=560000U
* device instance $8896 r0 *1 65.795,2.65 nfet_01v8
M$8896 167 4619 4626 167 nfet_01v8 L=150000U W=210000U AS=21875000000P
+ AD=40400000000P PS=460000U PD=560000U
* device instance $8897 r0 *1 65.205,3.04 nfet_01v8
M$8897 4616 4623 167 167 nfet_01v8 L=150000U W=210000U AS=40400000000P
+ AD=21875000000P PS=560000U PD=460000U
* device instance $8898 r0 *1 65.795,3.04 nfet_01v8
M$8898 4619 4626 167 167 nfet_01v8 L=150000U W=210000U AS=40400000000P
+ AD=21875000000P PS=560000U PD=460000U
* device instance $8899 r0 *1 65.24,3.44 nfet_01v8
M$8899 94 133 4616 167 nfet_01v8 L=150000U W=140000U AS=21875000000P
+ AD=16800000000P PS=460000U PD=380000U
* device instance $8900 r0 *1 65.76,3.44 nfet_01v8
M$8900 95 133 4619 167 nfet_01v8 L=150000U W=140000U AS=21875000000P
+ AD=16800000000P PS=460000U PD=380000U
* device instance $8901 r0 *1 62.84,2.25 nfet_01v8
M$8901 4622 133 89 167 nfet_01v8 L=150000U W=140000U AS=16800000000P
+ AD=21875000000P PS=380000U PD=460000U
* device instance $8902 r0 *1 63.36,2.25 nfet_01v8
M$8902 4627 133 92 167 nfet_01v8 L=150000U W=140000U AS=16800000000P
+ AD=21875000000P PS=380000U PD=460000U
* device instance $8903 r0 *1 62.805,2.65 nfet_01v8
M$8903 167 4615 4622 167 nfet_01v8 L=150000U W=210000U AS=21875000000P
+ AD=40400000000P PS=460000U PD=560000U
* device instance $8904 r0 *1 63.395,2.65 nfet_01v8
M$8904 167 4620 4627 167 nfet_01v8 L=150000U W=210000U AS=21875000000P
+ AD=40400000000P PS=460000U PD=560000U
* device instance $8905 r0 *1 62.805,3.04 nfet_01v8
M$8905 4615 4622 167 167 nfet_01v8 L=150000U W=210000U AS=40400000000P
+ AD=21875000000P PS=560000U PD=460000U
* device instance $8906 r0 *1 63.395,3.04 nfet_01v8
M$8906 4620 4627 167 167 nfet_01v8 L=150000U W=210000U AS=40400000000P
+ AD=21875000000P PS=560000U PD=460000U
* device instance $8907 r0 *1 62.84,3.44 nfet_01v8
M$8907 90 133 4615 167 nfet_01v8 L=150000U W=140000U AS=21875000000P
+ AD=16800000000P PS=460000U PD=380000U
* device instance $8908 r0 *1 63.36,3.44 nfet_01v8
M$8908 91 133 4620 167 nfet_01v8 L=150000U W=140000U AS=21875000000P
+ AD=16800000000P PS=460000U PD=380000U
* device instance $8909 r0 *1 60.44,2.25 nfet_01v8
M$8909 4621 133 85 167 nfet_01v8 L=150000U W=140000U AS=16800000000P
+ AD=21875000000P PS=380000U PD=460000U
* device instance $8910 r0 *1 60.96,2.25 nfet_01v8
M$8910 4625 133 88 167 nfet_01v8 L=150000U W=140000U AS=16800000000P
+ AD=21875000000P PS=380000U PD=460000U
* device instance $8911 r0 *1 60.405,2.65 nfet_01v8
M$8911 167 4614 4621 167 nfet_01v8 L=150000U W=210000U AS=21875000000P
+ AD=40400000000P PS=460000U PD=560000U
* device instance $8912 r0 *1 60.995,2.65 nfet_01v8
M$8912 167 4618 4625 167 nfet_01v8 L=150000U W=210000U AS=21875000000P
+ AD=40400000000P PS=460000U PD=560000U
* device instance $8913 r0 *1 60.405,3.04 nfet_01v8
M$8913 4614 4621 167 167 nfet_01v8 L=150000U W=210000U AS=40400000000P
+ AD=21875000000P PS=560000U PD=460000U
* device instance $8914 r0 *1 60.995,3.04 nfet_01v8
M$8914 4618 4625 167 167 nfet_01v8 L=150000U W=210000U AS=40400000000P
+ AD=21875000000P PS=560000U PD=460000U
* device instance $8915 r0 *1 60.44,3.44 nfet_01v8
M$8915 86 133 4614 167 nfet_01v8 L=150000U W=140000U AS=21875000000P
+ AD=16800000000P PS=460000U PD=380000U
* device instance $8916 r0 *1 60.96,3.44 nfet_01v8
M$8916 87 133 4618 167 nfet_01v8 L=150000U W=140000U AS=21875000000P
+ AD=16800000000P PS=460000U PD=380000U
* device instance $8917 r0 *1 58.56,2.25 nfet_01v8
M$8917 4624 133 84 167 nfet_01v8 L=150000U W=140000U AS=16800000000P
+ AD=21875000000P PS=380000U PD=460000U
* device instance $8918 r0 *1 58.595,2.65 nfet_01v8
M$8918 167 4617 4624 167 nfet_01v8 L=150000U W=210000U AS=21875000000P
+ AD=51200000000P PS=460000U PD=775000U
* device instance $8919 r0 *1 58.595,3.04 nfet_01v8
M$8919 4617 4624 167 167 nfet_01v8 L=150000U W=210000U AS=51200000000P
+ AD=21875000000P PS=775000U PD=460000U
* device instance $8920 r0 *1 58.56,3.44 nfet_01v8
M$8920 83 133 4617 167 nfet_01v8 L=150000U W=140000U AS=21875000000P
+ AD=16800000000P PS=460000U PD=380000U
* device instance $8921 r0 *1 76.14,2.25 nfet_01v8
M$8921 4637 133 109 167 nfet_01v8 L=150000U W=140000U AS=16800000000P
+ AD=21875000000P PS=380000U PD=460000U
* device instance $8922 r0 *1 76.66,2.25 nfet_01v8
M$8922 4640 133 112 167 nfet_01v8 L=150000U W=140000U AS=16800000000P
+ AD=21875000000P PS=380000U PD=460000U
* device instance $8923 r0 *1 76.105,2.65 nfet_01v8
M$8923 167 4630 4637 167 nfet_01v8 L=150000U W=210000U AS=21875000000P
+ AD=40400000000P PS=460000U PD=560000U
* device instance $8924 r0 *1 76.695,2.65 nfet_01v8
M$8924 167 4633 4640 167 nfet_01v8 L=150000U W=210000U AS=21875000000P
+ AD=40400000000P PS=460000U PD=560000U
* device instance $8925 r0 *1 76.105,3.04 nfet_01v8
M$8925 4630 4637 167 167 nfet_01v8 L=150000U W=210000U AS=40400000000P
+ AD=21875000000P PS=560000U PD=460000U
* device instance $8926 r0 *1 76.695,3.04 nfet_01v8
M$8926 4633 4640 167 167 nfet_01v8 L=150000U W=210000U AS=40400000000P
+ AD=21875000000P PS=560000U PD=460000U
* device instance $8927 r0 *1 76.14,3.44 nfet_01v8
M$8927 110 133 4630 167 nfet_01v8 L=150000U W=140000U AS=21875000000P
+ AD=16800000000P PS=460000U PD=380000U
* device instance $8928 r0 *1 76.66,3.44 nfet_01v8
M$8928 111 133 4633 167 nfet_01v8 L=150000U W=140000U AS=21875000000P
+ AD=16800000000P PS=460000U PD=380000U
* device instance $8929 r0 *1 73.74,2.25 nfet_01v8
M$8929 4636 133 105 167 nfet_01v8 L=150000U W=140000U AS=16800000000P
+ AD=21875000000P PS=380000U PD=460000U
* device instance $8930 r0 *1 74.26,2.25 nfet_01v8
M$8930 4641 133 108 167 nfet_01v8 L=150000U W=140000U AS=16800000000P
+ AD=21875000000P PS=380000U PD=460000U
* device instance $8931 r0 *1 73.705,2.65 nfet_01v8
M$8931 167 4629 4636 167 nfet_01v8 L=150000U W=210000U AS=21875000000P
+ AD=40400000000P PS=460000U PD=560000U
* device instance $8932 r0 *1 74.295,2.65 nfet_01v8
M$8932 167 4634 4641 167 nfet_01v8 L=150000U W=210000U AS=21875000000P
+ AD=40400000000P PS=460000U PD=560000U
* device instance $8933 r0 *1 73.705,3.04 nfet_01v8
M$8933 4629 4636 167 167 nfet_01v8 L=150000U W=210000U AS=40400000000P
+ AD=21875000000P PS=560000U PD=460000U
* device instance $8934 r0 *1 74.295,3.04 nfet_01v8
M$8934 4634 4641 167 167 nfet_01v8 L=150000U W=210000U AS=40400000000P
+ AD=21875000000P PS=560000U PD=460000U
* device instance $8935 r0 *1 73.74,3.44 nfet_01v8
M$8935 106 133 4629 167 nfet_01v8 L=150000U W=140000U AS=21875000000P
+ AD=16800000000P PS=460000U PD=380000U
* device instance $8936 r0 *1 74.26,3.44 nfet_01v8
M$8936 107 133 4634 167 nfet_01v8 L=150000U W=140000U AS=21875000000P
+ AD=16800000000P PS=460000U PD=380000U
* device instance $8937 r0 *1 71.34,2.25 nfet_01v8
M$8937 4635 133 101 167 nfet_01v8 L=150000U W=140000U AS=16800000000P
+ AD=21875000000P PS=380000U PD=460000U
* device instance $8938 r0 *1 71.86,2.25 nfet_01v8
M$8938 4639 133 104 167 nfet_01v8 L=150000U W=140000U AS=16800000000P
+ AD=21875000000P PS=380000U PD=460000U
* device instance $8939 r0 *1 71.305,2.65 nfet_01v8
M$8939 167 4628 4635 167 nfet_01v8 L=150000U W=210000U AS=21875000000P
+ AD=40400000000P PS=460000U PD=560000U
* device instance $8940 r0 *1 71.895,2.65 nfet_01v8
M$8940 167 4632 4639 167 nfet_01v8 L=150000U W=210000U AS=21875000000P
+ AD=40400000000P PS=460000U PD=560000U
* device instance $8941 r0 *1 71.305,3.04 nfet_01v8
M$8941 4628 4635 167 167 nfet_01v8 L=150000U W=210000U AS=40400000000P
+ AD=21875000000P PS=560000U PD=460000U
* device instance $8942 r0 *1 71.895,3.04 nfet_01v8
M$8942 4632 4639 167 167 nfet_01v8 L=150000U W=210000U AS=40400000000P
+ AD=21875000000P PS=560000U PD=460000U
* device instance $8943 r0 *1 71.34,3.44 nfet_01v8
M$8943 102 133 4628 167 nfet_01v8 L=150000U W=140000U AS=21875000000P
+ AD=16800000000P PS=460000U PD=380000U
* device instance $8944 r0 *1 71.86,3.44 nfet_01v8
M$8944 103 133 4632 167 nfet_01v8 L=150000U W=140000U AS=21875000000P
+ AD=16800000000P PS=460000U PD=380000U
* device instance $8945 r0 *1 69.46,2.25 nfet_01v8
M$8945 4638 133 100 167 nfet_01v8 L=150000U W=140000U AS=16800000000P
+ AD=21875000000P PS=380000U PD=460000U
* device instance $8946 r0 *1 69.495,2.65 nfet_01v8
M$8946 167 4631 4638 167 nfet_01v8 L=150000U W=210000U AS=21875000000P
+ AD=51200000000P PS=460000U PD=775000U
* device instance $8947 r0 *1 69.495,3.04 nfet_01v8
M$8947 4631 4638 167 167 nfet_01v8 L=150000U W=210000U AS=51200000000P
+ AD=21875000000P PS=775000U PD=460000U
* device instance $8948 r0 *1 69.46,3.44 nfet_01v8
M$8948 99 133 4631 167 nfet_01v8 L=150000U W=140000U AS=21875000000P
+ AD=16800000000P PS=460000U PD=380000U
* device instance $8949 r0 *1 87.04,2.25 nfet_01v8
M$8949 4651 133 125 167 nfet_01v8 L=150000U W=140000U AS=16800000000P
+ AD=21875000000P PS=380000U PD=460000U
* device instance $8950 r0 *1 87.56,2.25 nfet_01v8
M$8950 4654 133 128 167 nfet_01v8 L=150000U W=140000U AS=16800000000P
+ AD=21875000000P PS=380000U PD=460000U
* device instance $8951 r0 *1 87.005,2.65 nfet_01v8
M$8951 167 4644 4651 167 nfet_01v8 L=150000U W=210000U AS=21875000000P
+ AD=40400000000P PS=460000U PD=560000U
* device instance $8952 r0 *1 87.595,2.65 nfet_01v8
M$8952 167 4647 4654 167 nfet_01v8 L=150000U W=210000U AS=21875000000P
+ AD=40400000000P PS=460000U PD=560000U
* device instance $8953 r0 *1 87.005,3.04 nfet_01v8
M$8953 4644 4651 167 167 nfet_01v8 L=150000U W=210000U AS=40400000000P
+ AD=21875000000P PS=560000U PD=460000U
* device instance $8954 r0 *1 87.595,3.04 nfet_01v8
M$8954 4647 4654 167 167 nfet_01v8 L=150000U W=210000U AS=40400000000P
+ AD=21875000000P PS=560000U PD=460000U
* device instance $8955 r0 *1 87.04,3.44 nfet_01v8
M$8955 126 133 4644 167 nfet_01v8 L=150000U W=140000U AS=21875000000P
+ AD=16800000000P PS=460000U PD=380000U
* device instance $8956 r0 *1 87.56,3.44 nfet_01v8
M$8956 127 133 4647 167 nfet_01v8 L=150000U W=140000U AS=21875000000P
+ AD=16800000000P PS=460000U PD=380000U
* device instance $8957 r0 *1 84.64,2.25 nfet_01v8
M$8957 4650 133 121 167 nfet_01v8 L=150000U W=140000U AS=16800000000P
+ AD=21875000000P PS=380000U PD=460000U
* device instance $8958 r0 *1 85.16,2.25 nfet_01v8
M$8958 4655 133 124 167 nfet_01v8 L=150000U W=140000U AS=16800000000P
+ AD=21875000000P PS=380000U PD=460000U
* device instance $8959 r0 *1 84.605,2.65 nfet_01v8
M$8959 167 4643 4650 167 nfet_01v8 L=150000U W=210000U AS=21875000000P
+ AD=40400000000P PS=460000U PD=560000U
* device instance $8960 r0 *1 85.195,2.65 nfet_01v8
M$8960 167 4648 4655 167 nfet_01v8 L=150000U W=210000U AS=21875000000P
+ AD=40400000000P PS=460000U PD=560000U
* device instance $8961 r0 *1 84.605,3.04 nfet_01v8
M$8961 4643 4650 167 167 nfet_01v8 L=150000U W=210000U AS=40400000000P
+ AD=21875000000P PS=560000U PD=460000U
* device instance $8962 r0 *1 85.195,3.04 nfet_01v8
M$8962 4648 4655 167 167 nfet_01v8 L=150000U W=210000U AS=40400000000P
+ AD=21875000000P PS=560000U PD=460000U
* device instance $8963 r0 *1 84.64,3.44 nfet_01v8
M$8963 122 133 4643 167 nfet_01v8 L=150000U W=140000U AS=21875000000P
+ AD=16800000000P PS=460000U PD=380000U
* device instance $8964 r0 *1 85.16,3.44 nfet_01v8
M$8964 123 133 4648 167 nfet_01v8 L=150000U W=140000U AS=21875000000P
+ AD=16800000000P PS=460000U PD=380000U
* device instance $8965 r0 *1 82.24,2.25 nfet_01v8
M$8965 4649 133 117 167 nfet_01v8 L=150000U W=140000U AS=16800000000P
+ AD=21875000000P PS=380000U PD=460000U
* device instance $8966 r0 *1 82.76,2.25 nfet_01v8
M$8966 4653 133 120 167 nfet_01v8 L=150000U W=140000U AS=16800000000P
+ AD=21875000000P PS=380000U PD=460000U
* device instance $8967 r0 *1 82.205,2.65 nfet_01v8
M$8967 167 4642 4649 167 nfet_01v8 L=150000U W=210000U AS=21875000000P
+ AD=40400000000P PS=460000U PD=560000U
* device instance $8968 r0 *1 82.795,2.65 nfet_01v8
M$8968 167 4646 4653 167 nfet_01v8 L=150000U W=210000U AS=21875000000P
+ AD=40400000000P PS=460000U PD=560000U
* device instance $8969 r0 *1 82.205,3.04 nfet_01v8
M$8969 4642 4649 167 167 nfet_01v8 L=150000U W=210000U AS=40400000000P
+ AD=21875000000P PS=560000U PD=460000U
* device instance $8970 r0 *1 82.795,3.04 nfet_01v8
M$8970 4646 4653 167 167 nfet_01v8 L=150000U W=210000U AS=40400000000P
+ AD=21875000000P PS=560000U PD=460000U
* device instance $8971 r0 *1 82.24,3.44 nfet_01v8
M$8971 118 133 4642 167 nfet_01v8 L=150000U W=140000U AS=21875000000P
+ AD=16800000000P PS=460000U PD=380000U
* device instance $8972 r0 *1 82.76,3.44 nfet_01v8
M$8972 119 133 4646 167 nfet_01v8 L=150000U W=140000U AS=21875000000P
+ AD=16800000000P PS=460000U PD=380000U
* device instance $8973 r0 *1 80.36,2.25 nfet_01v8
M$8973 4652 133 116 167 nfet_01v8 L=150000U W=140000U AS=16800000000P
+ AD=21875000000P PS=380000U PD=460000U
* device instance $8974 r0 *1 80.395,2.65 nfet_01v8
M$8974 167 4645 4652 167 nfet_01v8 L=150000U W=210000U AS=21875000000P
+ AD=51200000000P PS=460000U PD=775000U
* device instance $8975 r0 *1 80.395,3.04 nfet_01v8
M$8975 4645 4652 167 167 nfet_01v8 L=150000U W=210000U AS=51200000000P
+ AD=21875000000P PS=775000U PD=460000U
* device instance $8976 r0 *1 80.36,3.44 nfet_01v8
M$8976 115 133 4645 167 nfet_01v8 L=150000U W=140000U AS=21875000000P
+ AD=16800000000P PS=460000U PD=380000U
.ENDS sp_cell_array

* cell replica_cell_array
* pin vpb,vpwr
* pin br[0]
* pin bl[0]
* pin bl[1]
* pin br[1]
* pin wl[0]
* pin wl[7]
* pin wl[6]
* pin wl[5]
* pin wl[4]
* pin wl[3]
* pin wl[2]
* pin wl[1]
* pin wl[0]
* pin wl[0]
* pin vgnd,vnb
.SUBCKT replica_cell_array 1 2 3 4 5 6 7 8 9 10 11 12 13 14 15 16
* net 1 vpb,vpwr
* net 2 br[0]
* net 3 bl[0]
* net 4 bl[1]
* net 5 br[1]
* net 6 wl[0]
* net 7 wl[7]
* net 8 wl[6]
* net 9 wl[5]
* net 10 wl[4]
* net 11 wl[3]
* net 12 wl[2]
* net 13 wl[1]
* net 14 wl[0]
* net 15 wl[0]
* net 16 vgnd,vnb
* cell instance $156 m90 *1 0,5.215
X$156 16 sram_sp_rowtapend_replica
* cell instance $158 r0 *1 5,5.215
X$158 16 sram_sp_rowtapend_replica
* cell instance $160 m90 *1 0,21.015
X$160 16 sram_sp_rowtapend_replica
* cell instance $162 r0 *1 5,21.015
X$162 16 sram_sp_rowtapend_replica
* cell instance $164 m90 *1 0,13.115
X$164 16 sram_sp_rowtapend_replica
* cell instance $166 r0 *1 5,13.115
X$166 16 sram_sp_rowtapend_replica
* device instance $1 r0 *1 2.24,5.41 nfet_01v8
M$1 24 7 3 16 nfet_01v8 L=150000U W=140000U AS=16800000000P AD=21875000000P
+ PS=380000U PD=460000U
* device instance $2 r0 *1 2.76,5.41 nfet_01v8
M$2 23 7 4 16 nfet_01v8 L=150000U W=140000U AS=16800000000P AD=21875000000P
+ PS=380000U PD=460000U
* device instance $3 r0 *1 2.205,5.81 nfet_01v8
M$3 16 1 24 16 nfet_01v8 L=150000U W=210000U AS=21875000000P AD=40400000000P
+ PS=460000U PD=560000U
* device instance $4 r0 *1 2.795,5.81 nfet_01v8
M$4 16 1 23 16 nfet_01v8 L=150000U W=210000U AS=21875000000P AD=40400000000P
+ PS=460000U PD=560000U
* device instance $5 r0 *1 2.205,6.2 nfet_01v8
M$5 1 24 16 16 nfet_01v8 L=150000U W=210000U AS=40400000000P AD=21875000000P
+ PS=560000U PD=460000U
* device instance $6 r0 *1 2.795,6.2 nfet_01v8
M$6 1 23 16 16 nfet_01v8 L=150000U W=210000U AS=40400000000P AD=21875000000P
+ PS=560000U PD=460000U
* device instance $7 r0 *1 2.24,6.6 nfet_01v8
M$7 2 7 1 16 nfet_01v8 L=150000U W=140000U AS=21875000000P AD=16800000000P
+ PS=460000U PD=380000U
* device instance $8 r0 *1 2.76,6.6 nfet_01v8
M$8 5 7 1 16 nfet_01v8 L=150000U W=140000U AS=21875000000P AD=16800000000P
+ PS=460000U PD=380000U
* device instance $9 r0 *1 2.24,6.99 nfet_01v8
M$9 1 8 2 16 nfet_01v8 L=150000U W=140000U AS=16800000000P AD=21875000000P
+ PS=380000U PD=460000U
* device instance $10 r0 *1 2.76,6.99 nfet_01v8
M$10 1 8 5 16 nfet_01v8 L=150000U W=140000U AS=16800000000P AD=21875000000P
+ PS=380000U PD=460000U
* device instance $11 r0 *1 2.205,7.39 nfet_01v8
M$11 16 22 1 16 nfet_01v8 L=150000U W=210000U AS=21875000000P AD=40400000000P
+ PS=460000U PD=560000U
* device instance $12 r0 *1 2.795,7.39 nfet_01v8
M$12 16 21 1 16 nfet_01v8 L=150000U W=210000U AS=21875000000P AD=40400000000P
+ PS=460000U PD=560000U
* device instance $13 r0 *1 2.205,7.78 nfet_01v8
M$13 22 1 16 16 nfet_01v8 L=150000U W=210000U AS=40400000000P AD=21875000000P
+ PS=560000U PD=460000U
* device instance $14 r0 *1 2.795,7.78 nfet_01v8
M$14 21 1 16 16 nfet_01v8 L=150000U W=210000U AS=40400000000P AD=21875000000P
+ PS=560000U PD=460000U
* device instance $15 r0 *1 2.24,8.18 nfet_01v8
M$15 3 8 22 16 nfet_01v8 L=150000U W=140000U AS=21875000000P AD=16800000000P
+ PS=460000U PD=380000U
* device instance $16 r0 *1 2.76,8.18 nfet_01v8
M$16 4 8 21 16 nfet_01v8 L=150000U W=140000U AS=21875000000P AD=16800000000P
+ PS=460000U PD=380000U
* device instance $17 r0 *1 2.24,8.57 nfet_01v8
M$17 20 9 3 16 nfet_01v8 L=150000U W=140000U AS=16800000000P AD=21875000000P
+ PS=380000U PD=460000U
* device instance $18 r0 *1 2.76,8.57 nfet_01v8
M$18 19 9 4 16 nfet_01v8 L=150000U W=140000U AS=16800000000P AD=21875000000P
+ PS=380000U PD=460000U
* device instance $19 r0 *1 2.205,8.97 nfet_01v8
M$19 16 1 20 16 nfet_01v8 L=150000U W=210000U AS=21875000000P AD=40400000000P
+ PS=460000U PD=560000U
* device instance $20 r0 *1 2.795,8.97 nfet_01v8
M$20 16 1 19 16 nfet_01v8 L=150000U W=210000U AS=21875000000P AD=40400000000P
+ PS=460000U PD=560000U
* device instance $21 r0 *1 2.205,9.36 nfet_01v8
M$21 1 20 16 16 nfet_01v8 L=150000U W=210000U AS=40400000000P AD=21875000000P
+ PS=560000U PD=460000U
* device instance $22 r0 *1 2.795,9.36 nfet_01v8
M$22 1 19 16 16 nfet_01v8 L=150000U W=210000U AS=40400000000P AD=21875000000P
+ PS=560000U PD=460000U
* device instance $23 r0 *1 2.24,9.76 nfet_01v8
M$23 2 9 1 16 nfet_01v8 L=150000U W=140000U AS=21875000000P AD=16800000000P
+ PS=460000U PD=380000U
* device instance $24 r0 *1 2.76,9.76 nfet_01v8
M$24 5 9 1 16 nfet_01v8 L=150000U W=140000U AS=21875000000P AD=16800000000P
+ PS=460000U PD=380000U
* device instance $25 r0 *1 2.24,10.15 nfet_01v8
M$25 1 10 2 16 nfet_01v8 L=150000U W=140000U AS=16800000000P AD=21875000000P
+ PS=380000U PD=460000U
* device instance $26 r0 *1 2.76,10.15 nfet_01v8
M$26 1 10 5 16 nfet_01v8 L=150000U W=140000U AS=16800000000P AD=21875000000P
+ PS=380000U PD=460000U
* device instance $27 r0 *1 2.205,10.55 nfet_01v8
M$27 16 18 1 16 nfet_01v8 L=150000U W=210000U AS=21875000000P AD=40400000000P
+ PS=460000U PD=560000U
* device instance $28 r0 *1 2.795,10.55 nfet_01v8
M$28 16 17 1 16 nfet_01v8 L=150000U W=210000U AS=21875000000P AD=40400000000P
+ PS=460000U PD=560000U
* device instance $29 r0 *1 2.205,10.94 nfet_01v8
M$29 18 1 16 16 nfet_01v8 L=150000U W=210000U AS=40400000000P AD=21875000000P
+ PS=560000U PD=460000U
* device instance $30 r0 *1 2.795,10.94 nfet_01v8
M$30 17 1 16 16 nfet_01v8 L=150000U W=210000U AS=40400000000P AD=21875000000P
+ PS=560000U PD=460000U
* device instance $31 r0 *1 2.24,11.34 nfet_01v8
M$31 3 10 18 16 nfet_01v8 L=150000U W=140000U AS=21875000000P AD=16800000000P
+ PS=460000U PD=380000U
* device instance $32 r0 *1 2.76,11.34 nfet_01v8
M$32 4 10 17 16 nfet_01v8 L=150000U W=140000U AS=21875000000P AD=16800000000P
+ PS=460000U PD=380000U
* device instance $33 r0 *1 2.24,21.21 nfet_01v8
M$33 30 15 3 16 nfet_01v8 L=150000U W=140000U AS=16800000000P AD=21875000000P
+ PS=380000U PD=460000U
* device instance $34 r0 *1 2.76,21.21 nfet_01v8
M$34 32 15 4 16 nfet_01v8 L=150000U W=140000U AS=16800000000P AD=21875000000P
+ PS=380000U PD=460000U
* device instance $35 r0 *1 2.205,21.61 nfet_01v8
M$35 16 1 30 16 nfet_01v8 L=150000U W=210000U AS=21875000000P AD=40400000000P
+ PS=460000U PD=560000U
* device instance $36 r0 *1 2.795,21.61 nfet_01v8
M$36 16 1 32 16 nfet_01v8 L=150000U W=210000U AS=21875000000P AD=40400000000P
+ PS=460000U PD=560000U
* device instance $37 r0 *1 2.205,22 nfet_01v8
M$37 1 30 16 16 nfet_01v8 L=150000U W=210000U AS=40400000000P AD=21875000000P
+ PS=560000U PD=460000U
* device instance $38 r0 *1 2.795,22 nfet_01v8
M$38 1 32 16 16 nfet_01v8 L=150000U W=210000U AS=40400000000P AD=21875000000P
+ PS=560000U PD=460000U
* device instance $39 r0 *1 2.24,22.4 nfet_01v8
M$39 2 15 1 16 nfet_01v8 L=150000U W=140000U AS=21875000000P AD=16800000000P
+ PS=460000U PD=380000U
* device instance $40 r0 *1 2.76,22.4 nfet_01v8
M$40 5 15 1 16 nfet_01v8 L=150000U W=140000U AS=21875000000P AD=16800000000P
+ PS=460000U PD=380000U
* device instance $41 r0 *1 2.24,13.31 nfet_01v8
M$41 31 11 3 16 nfet_01v8 L=150000U W=140000U AS=16800000000P AD=21875000000P
+ PS=380000U PD=460000U
* device instance $42 r0 *1 2.76,13.31 nfet_01v8
M$42 33 11 4 16 nfet_01v8 L=150000U W=140000U AS=16800000000P AD=21875000000P
+ PS=380000U PD=460000U
* device instance $43 r0 *1 2.205,13.71 nfet_01v8
M$43 16 1 31 16 nfet_01v8 L=150000U W=210000U AS=21875000000P AD=40400000000P
+ PS=460000U PD=560000U
* device instance $44 r0 *1 2.795,13.71 nfet_01v8
M$44 16 1 33 16 nfet_01v8 L=150000U W=210000U AS=21875000000P AD=40400000000P
+ PS=460000U PD=560000U
* device instance $45 r0 *1 2.205,14.1 nfet_01v8
M$45 1 31 16 16 nfet_01v8 L=150000U W=210000U AS=40400000000P AD=21875000000P
+ PS=560000U PD=460000U
* device instance $46 r0 *1 2.795,14.1 nfet_01v8
M$46 1 33 16 16 nfet_01v8 L=150000U W=210000U AS=40400000000P AD=21875000000P
+ PS=560000U PD=460000U
* device instance $47 r0 *1 2.24,14.5 nfet_01v8
M$47 2 11 1 16 nfet_01v8 L=150000U W=140000U AS=21875000000P AD=16800000000P
+ PS=460000U PD=380000U
* device instance $48 r0 *1 2.76,14.5 nfet_01v8
M$48 5 11 1 16 nfet_01v8 L=150000U W=140000U AS=21875000000P AD=16800000000P
+ PS=460000U PD=380000U
* device instance $49 r0 *1 2.24,14.89 nfet_01v8
M$49 1 12 2 16 nfet_01v8 L=150000U W=140000U AS=16800000000P AD=21875000000P
+ PS=380000U PD=460000U
* device instance $50 r0 *1 2.76,14.89 nfet_01v8
M$50 1 12 5 16 nfet_01v8 L=150000U W=140000U AS=16800000000P AD=21875000000P
+ PS=380000U PD=460000U
* device instance $51 r0 *1 2.205,15.29 nfet_01v8
M$51 16 28 1 16 nfet_01v8 L=150000U W=210000U AS=21875000000P AD=40400000000P
+ PS=460000U PD=560000U
* device instance $52 r0 *1 2.795,15.29 nfet_01v8
M$52 16 26 1 16 nfet_01v8 L=150000U W=210000U AS=21875000000P AD=40400000000P
+ PS=460000U PD=560000U
* device instance $53 r0 *1 2.205,15.68 nfet_01v8
M$53 28 1 16 16 nfet_01v8 L=150000U W=210000U AS=40400000000P AD=21875000000P
+ PS=560000U PD=460000U
* device instance $54 r0 *1 2.795,15.68 nfet_01v8
M$54 26 1 16 16 nfet_01v8 L=150000U W=210000U AS=40400000000P AD=21875000000P
+ PS=560000U PD=460000U
* device instance $55 r0 *1 2.24,16.08 nfet_01v8
M$55 3 12 28 16 nfet_01v8 L=150000U W=140000U AS=21875000000P AD=16800000000P
+ PS=460000U PD=380000U
* device instance $56 r0 *1 2.76,16.08 nfet_01v8
M$56 4 12 26 16 nfet_01v8 L=150000U W=140000U AS=21875000000P AD=16800000000P
+ PS=460000U PD=380000U
* device instance $57 r0 *1 2.24,16.47 nfet_01v8
M$57 29 13 3 16 nfet_01v8 L=150000U W=140000U AS=16800000000P AD=21875000000P
+ PS=380000U PD=460000U
* device instance $58 r0 *1 2.76,16.47 nfet_01v8
M$58 34 13 4 16 nfet_01v8 L=150000U W=140000U AS=16800000000P AD=21875000000P
+ PS=380000U PD=460000U
* device instance $59 r0 *1 2.205,16.87 nfet_01v8
M$59 16 1 29 16 nfet_01v8 L=150000U W=210000U AS=21875000000P AD=40400000000P
+ PS=460000U PD=560000U
* device instance $60 r0 *1 2.795,16.87 nfet_01v8
M$60 16 1 34 16 nfet_01v8 L=150000U W=210000U AS=21875000000P AD=40400000000P
+ PS=460000U PD=560000U
* device instance $61 r0 *1 2.205,17.26 nfet_01v8
M$61 1 29 16 16 nfet_01v8 L=150000U W=210000U AS=40400000000P AD=21875000000P
+ PS=560000U PD=460000U
* device instance $62 r0 *1 2.795,17.26 nfet_01v8
M$62 1 34 16 16 nfet_01v8 L=150000U W=210000U AS=40400000000P AD=21875000000P
+ PS=560000U PD=460000U
* device instance $63 r0 *1 2.24,17.66 nfet_01v8
M$63 2 13 1 16 nfet_01v8 L=150000U W=140000U AS=21875000000P AD=16800000000P
+ PS=460000U PD=380000U
* device instance $64 r0 *1 2.76,17.66 nfet_01v8
M$64 5 13 1 16 nfet_01v8 L=150000U W=140000U AS=21875000000P AD=16800000000P
+ PS=460000U PD=380000U
* device instance $65 r0 *1 2.24,18.05 nfet_01v8
M$65 1 14 2 16 nfet_01v8 L=150000U W=140000U AS=16800000000P AD=21875000000P
+ PS=380000U PD=460000U
* device instance $66 r0 *1 2.76,18.05 nfet_01v8
M$66 1 14 5 16 nfet_01v8 L=150000U W=140000U AS=16800000000P AD=21875000000P
+ PS=380000U PD=460000U
* device instance $67 r0 *1 2.205,18.45 nfet_01v8
M$67 16 27 1 16 nfet_01v8 L=150000U W=210000U AS=21875000000P AD=40400000000P
+ PS=460000U PD=560000U
* device instance $68 r0 *1 2.795,18.45 nfet_01v8
M$68 16 25 1 16 nfet_01v8 L=150000U W=210000U AS=21875000000P AD=40400000000P
+ PS=460000U PD=560000U
* device instance $69 r0 *1 2.205,18.84 nfet_01v8
M$69 27 1 16 16 nfet_01v8 L=150000U W=210000U AS=40400000000P AD=21875000000P
+ PS=560000U PD=460000U
* device instance $70 r0 *1 2.795,18.84 nfet_01v8
M$70 25 1 16 16 nfet_01v8 L=150000U W=210000U AS=40400000000P AD=21875000000P
+ PS=560000U PD=460000U
* device instance $71 r0 *1 2.24,19.24 nfet_01v8
M$71 3 14 27 16 nfet_01v8 L=150000U W=140000U AS=21875000000P AD=16800000000P
+ PS=460000U PD=380000U
* device instance $72 r0 *1 2.76,19.24 nfet_01v8
M$72 4 14 25 16 nfet_01v8 L=150000U W=140000U AS=21875000000P AD=16800000000P
+ PS=460000U PD=380000U
* device instance $73 r0 *1 2.24,2.25 nfet_01v8
M$73 1 6 2 16 nfet_01v8 L=150000U W=140000U AS=16800000000P AD=21875000000P
+ PS=380000U PD=460000U
* device instance $74 r0 *1 2.76,2.25 nfet_01v8
M$74 1 6 5 16 nfet_01v8 L=150000U W=140000U AS=16800000000P AD=21875000000P
+ PS=380000U PD=460000U
* device instance $75 r0 *1 2.205,2.65 nfet_01v8
M$75 16 36 1 16 nfet_01v8 L=150000U W=210000U AS=21875000000P AD=40400000000P
+ PS=460000U PD=560000U
* device instance $76 r0 *1 2.795,2.65 nfet_01v8
M$76 16 35 1 16 nfet_01v8 L=150000U W=210000U AS=21875000000P AD=40400000000P
+ PS=460000U PD=560000U
* device instance $77 r0 *1 2.205,3.04 nfet_01v8
M$77 36 1 16 16 nfet_01v8 L=150000U W=210000U AS=40400000000P AD=21875000000P
+ PS=560000U PD=460000U
* device instance $78 r0 *1 2.795,3.04 nfet_01v8
M$78 35 1 16 16 nfet_01v8 L=150000U W=210000U AS=40400000000P AD=21875000000P
+ PS=560000U PD=460000U
* device instance $79 r0 *1 2.24,3.44 nfet_01v8
M$79 3 6 36 16 nfet_01v8 L=150000U W=140000U AS=21875000000P AD=16800000000P
+ PS=460000U PD=380000U
* device instance $80 r0 *1 2.76,3.44 nfet_01v8
M$80 4 6 35 16 nfet_01v8 L=150000U W=140000U AS=21875000000P AD=16800000000P
+ PS=460000U PD=380000U
.ENDS replica_cell_array

* cell control_logic_replica_v2
* pin wrdrven
* pin saen
* pin vdd
* pin pc_b
* pin we
* pin wlen
* pin vdd
* pin rwl
* pin rstb
* pin ce
* pin rbl
* pin clk
* pin vdd
* pin vss
.SUBCKT control_logic_replica_v2 1 2 9 10 12 23 27 28 29 30 31 33 37 38
* net 1 wrdrven
* net 2 saen
* net 9 vdd
* net 10 pc_b
* net 12 we
* net 23 wlen
* net 27 vdd
* net 28 rwl
* net 29 rstb
* net 30 ce
* net 31 rbl
* net 33 clk
* net 37 vdd
* net 38 vss
* cell instance $5 m0 *1 33.12,-13.32
X$5 1 40 14 16 9 38 sr_latch
* cell instance $10 m0 *1 0.96,-13.32
X$10 2 42 8 11 9 38 sr_latch
* cell instance $14 m90 *1 70.08,-16.65
X$14 38 3 10 9 9 38 sky130_fd_sc_hs__buf_16
* cell instance $16 r0 *1 37.44,-13.32
X$16 39 3 6 7 9 38 sr_latch
* cell instance $23 r0 *1 3.36,-9.99
X$23 38 18 4 19 27 27 38 sky130_fd_sc_hs__nor2_4
* cell instance $26 r0 *1 0.96,-13.32
X$26 4 5 9 38 svt_inv_chain_22
* cell instance $28 r180 *1 39.84,-3.33
X$28 38 4 12 22 32 27 27 38 sky130_fd_sc_hs__mux2_4
* cell instance $37 r0 *1 13.92,-9.99
X$37 38 16 5 19 27 27 38 sky130_fd_sc_hs__nor2_4
* cell instance $40 m0 *1 40.8,-6.66
X$40 5 20 27 38 inv_chain_16
* cell instance $42 r0 *1 24.48,-9.99
X$42 38 5 25 27 8 27 38 sky130_fd_sc_hs__nand2_4
* cell instance $46 r0 *1 8.64,-9.99
X$46 38 6 20 19 27 27 38 sky130_fd_sc_hs__nor2_4
* cell instance $54 r0 *1 65.28,-3.33
X$54 38 7 21 37 37 38 sky130_fd_sc_hs__inv_16
* cell instance $57 m0 *1 0.96,-6.66
X$57 7 13 38 27 38 27 inv_chain_3
* cell instance $72 m0 *1 23.04,-9.99
X$72 38 12 13 9 17 9 38 sky130_fd_sc_hs__nand2_4
* cell instance $74 m0 *1 28.32,-13.32
X$74 14 17 38 9 38 9 inv_chain_2
* cell instance $86 r0 *1 19.2,-9.99
X$86 38 11 21 19 27 27 38 sky130_fd_sc_hs__nor2_4
* cell instance $95 r0 *1 0.96,-9.99
X$95 27 12 27 25 38 38 sky130_fd_sc_hs__inv_2
* cell instance $105 m0 *1 7.2,-3.33
X$105 27 13 27 26 38 38 sky130_fd_sc_hs__inv_2
* cell instance $110 r0 *1 29.76,-9.99
X$110 38 25 22 27 15 27 38 sky130_fd_sc_hs__nand2_4
* cell instance $112 m90 *1 39.36,-9.99
X$112 38 23 15 24 27 27 38 sky130_fd_sc_hs__and2_4
* cell instance $132 m0 *1 67.68,-6.66
X$132 24 41 26 18 27 38 sr_latch
* cell instance $139 r0 *1 0.96,-3.33
X$139 38 19 29 37 37 38 sky130_fd_sc_hs__inv_16
* cell instance $158 m90 *1 64.32,-3.33
X$158 38 34 21 37 37 38 sky130_fd_sc_hs__buf_16
* cell instance $170 m90 *1 75.84,-3.33
X$170 37 31 37 22 38 38 sky130_fd_sc_hs__inv_2
* cell instance $187 m90 *1 50.88,-9.99
X$187 38 24 28 27 27 38 sky130_fd_sc_hs__buf_16
* cell instance $197 m0 *1 9.6,-6.66
X$197 32 26 27 38 inv_chain_13
* cell instance $226 r0 *1 30.24,-3.33
X$226 37 30 36 37 38 35 38 sky130_fd_sc_hs__and2_2
* cell instance $236 r0 *1 10.08,0
X$236 33 36 37 38 inv_chain_12
* cell instance $237 r0 *1 33.6,0
X$237 35 34 37 38 edge_detector
.ENDS control_logic_replica_v2

* cell decoder_1
* pin predecode_2_1
* pin predecode_4_1
* pin predecode_2_0
* pin predecode_3_1
* pin predecode_4_0
* pin predecode_1_1
* pin predecode_1_0
* pin predecode_3_0
* pin predecode_0_1
* pin predecode_0_0
* pin vdd
* pin vdd
* pin vdd
* pin vdd
* pin vdd
* pin vdd
* pin vdd
* pin y[0]
* pin y[1]
* pin y[2]
* pin y[3]
* pin y[4]
* pin y[5]
* pin y[6]
* pin y[7]
* pin y[8]
* pin y[9]
* pin y[10]
* pin y[11]
* pin y[12]
* pin y[13]
* pin y[14]
* pin y[15]
* pin y[16]
* pin y[17]
* pin y[18]
* pin y[19]
* pin y[20]
* pin y[21]
* pin y[22]
* pin y[23]
* pin y[24]
* pin y[25]
* pin y[26]
* pin y[27]
* pin y[28]
* pin y[29]
* pin y[30]
* pin y[31]
* pin vdd
* pin vss
.SUBCKT decoder_1 1 2 3 4 5 6 7 8 9 10 27 28 55 56 91 156 189 190 191 192 193
+ 194 195 196 197 198 199 200 201 202 203 204 205 206 207 208 209 210 211 212
+ 213 214 215 216 217 218 219 220 221 222 223
* net 1 predecode_2_1
* net 2 predecode_4_1
* net 3 predecode_2_0
* net 4 predecode_3_1
* net 5 predecode_4_0
* net 6 predecode_1_1
* net 7 predecode_1_0
* net 8 predecode_3_0
* net 9 predecode_0_1
* net 10 predecode_0_0
* net 27 vdd
* net 28 vdd
* net 55 vdd
* net 56 vdd
* net 91 vdd
* net 156 vdd
* net 157 y_b[0]
* net 158 y_b[1]
* net 159 y_b[2]
* net 160 y_b[3]
* net 161 y_b[4]
* net 162 y_b[5]
* net 163 y_b[6]
* net 164 y_b[7]
* net 165 y_b[8]
* net 166 y_b[9]
* net 167 y_b[10]
* net 168 y_b[11]
* net 169 y_b[12]
* net 170 y_b[13]
* net 171 y_b[14]
* net 172 y_b[15]
* net 173 y_b[16]
* net 174 y_b[17]
* net 175 y_b[18]
* net 176 y_b[19]
* net 177 y_b[20]
* net 178 y_b[21]
* net 179 y_b[22]
* net 180 y_b[23]
* net 181 y_b[24]
* net 182 y_b[25]
* net 183 y_b[26]
* net 184 y_b[27]
* net 185 y_b[28]
* net 186 y_b[29]
* net 187 y_b[30]
* net 188 y_b[31]
* net 189 vdd
* net 190 y[0]
* net 191 y[1]
* net 192 y[2]
* net 193 y[3]
* net 194 y[4]
* net 195 y[5]
* net 196 y[6]
* net 197 y[7]
* net 198 y[8]
* net 199 y[9]
* net 200 y[10]
* net 201 y[11]
* net 202 y[12]
* net 203 y[13]
* net 204 y[14]
* net 205 y[15]
* net 206 y[16]
* net 207 y[17]
* net 208 y[18]
* net 209 y[19]
* net 210 y[20]
* net 211 y[21]
* net 212 y[22]
* net 213 y[23]
* net 214 y[24]
* net 215 y[25]
* net 216 y[26]
* net 217 y[27]
* net 218 y[28]
* net 219 y[29]
* net 220 y[30]
* net 221 y[31]
* net 222 vdd
* net 223 vss
* device instance $1 r0 *1 -46.825,-8.76 pfet_01v8
M$1 27 5 11 27 pfet_01v8 L=150000U W=2500000U AS=662500000000P AD=350000000000P
+ PS=5530000U PD=2780000U
* device instance $2 r0 *1 -46.395,-8.76 pfet_01v8
M$2 11 8 27 27 pfet_01v8 L=150000U W=2500000U AS=350000000000P AD=662500000000P
+ PS=2780000U PD=5530000U
* device instance $3 r0 *1 -45.245,-8.76 pfet_01v8
M$3 27 5 12 27 pfet_01v8 L=150000U W=2500000U AS=662500000000P AD=350000000000P
+ PS=5530000U PD=2780000U
* device instance $4 r0 *1 -44.815,-8.76 pfet_01v8
M$4 12 4 27 27 pfet_01v8 L=150000U W=2500000U AS=350000000000P AD=662500000000P
+ PS=2780000U PD=5530000U
* device instance $5 r0 *1 -43.665,-8.76 pfet_01v8
M$5 27 2 13 27 pfet_01v8 L=150000U W=2500000U AS=662500000000P AD=350000000000P
+ PS=5530000U PD=2780000U
* device instance $6 r0 *1 -43.235,-8.76 pfet_01v8
M$6 13 8 27 27 pfet_01v8 L=150000U W=2500000U AS=350000000000P AD=662500000000P
+ PS=2780000U PD=5530000U
* device instance $7 r0 *1 -42.085,-8.76 pfet_01v8
M$7 27 2 14 27 pfet_01v8 L=150000U W=2500000U AS=662500000000P AD=350000000000P
+ PS=5530000U PD=2780000U
* device instance $8 r0 *1 -41.655,-8.76 pfet_01v8
M$8 14 4 27 27 pfet_01v8 L=150000U W=2500000U AS=350000000000P AD=662500000000P
+ PS=2780000U PD=5530000U
* device instance $9 r0 *1 -30.45,-7.16 pfet_01v8
M$9 28 3 15 28 pfet_01v8 L=150000U W=2500000U AS=662500000000P AD=350000000000P
+ PS=5530000U PD=2780000U
* device instance $10 r0 *1 -30.02,-7.16 pfet_01v8
M$10 15 7 28 28 pfet_01v8 L=150000U W=2500000U AS=350000000000P
+ AD=350000000000P PS=2780000U PD=2780000U
* device instance $11 r0 *1 -29.59,-7.16 pfet_01v8
M$11 28 10 15 28 pfet_01v8 L=150000U W=2500000U AS=350000000000P
+ AD=662500000000P PS=2780000U PD=5530000U
* device instance $12 r0 *1 -27.29,-7.16 pfet_01v8
M$12 28 3 16 28 pfet_01v8 L=150000U W=2500000U AS=662500000000P
+ AD=350000000000P PS=5530000U PD=2780000U
* device instance $13 r0 *1 -26.86,-7.16 pfet_01v8
M$13 16 7 28 28 pfet_01v8 L=150000U W=2500000U AS=350000000000P
+ AD=350000000000P PS=2780000U PD=2780000U
* device instance $14 r0 *1 -26.43,-7.16 pfet_01v8
M$14 28 9 16 28 pfet_01v8 L=150000U W=2500000U AS=350000000000P
+ AD=662500000000P PS=2780000U PD=5530000U
* device instance $15 r0 *1 -22.55,-7.16 pfet_01v8
M$15 28 3 17 28 pfet_01v8 L=150000U W=2500000U AS=662500000000P
+ AD=350000000000P PS=5530000U PD=2780000U
* device instance $16 r0 *1 -22.12,-7.16 pfet_01v8
M$16 17 6 28 28 pfet_01v8 L=150000U W=2500000U AS=350000000000P
+ AD=350000000000P PS=2780000U PD=2780000U
* device instance $17 r0 *1 -21.69,-7.16 pfet_01v8
M$17 28 10 17 28 pfet_01v8 L=150000U W=2500000U AS=350000000000P
+ AD=662500000000P PS=2780000U PD=5530000U
* device instance $18 r0 *1 -19.39,-7.16 pfet_01v8
M$18 28 3 18 28 pfet_01v8 L=150000U W=2500000U AS=662500000000P
+ AD=350000000000P PS=5530000U PD=2780000U
* device instance $19 r0 *1 -18.96,-7.16 pfet_01v8
M$19 18 6 28 28 pfet_01v8 L=150000U W=2500000U AS=350000000000P
+ AD=350000000000P PS=2780000U PD=2780000U
* device instance $20 r0 *1 -18.53,-7.16 pfet_01v8
M$20 28 9 18 28 pfet_01v8 L=150000U W=2500000U AS=350000000000P
+ AD=662500000000P PS=2780000U PD=5530000U
* device instance $21 r0 *1 -14.65,-7.16 pfet_01v8
M$21 28 1 19 28 pfet_01v8 L=150000U W=2500000U AS=662500000000P
+ AD=350000000000P PS=5530000U PD=2780000U
* device instance $22 r0 *1 -14.22,-7.16 pfet_01v8
M$22 19 7 28 28 pfet_01v8 L=150000U W=2500000U AS=350000000000P
+ AD=350000000000P PS=2780000U PD=2780000U
* device instance $23 r0 *1 -13.79,-7.16 pfet_01v8
M$23 28 10 19 28 pfet_01v8 L=150000U W=2500000U AS=350000000000P
+ AD=662500000000P PS=2780000U PD=5530000U
* device instance $24 r0 *1 -11.49,-7.16 pfet_01v8
M$24 28 1 20 28 pfet_01v8 L=150000U W=2500000U AS=662500000000P
+ AD=350000000000P PS=5530000U PD=2780000U
* device instance $25 r0 *1 -11.06,-7.16 pfet_01v8
M$25 20 7 28 28 pfet_01v8 L=150000U W=2500000U AS=350000000000P
+ AD=350000000000P PS=2780000U PD=2780000U
* device instance $26 r0 *1 -10.63,-7.16 pfet_01v8
M$26 28 9 20 28 pfet_01v8 L=150000U W=2500000U AS=350000000000P
+ AD=662500000000P PS=2780000U PD=5530000U
* device instance $27 r0 *1 -6.75,-7.16 pfet_01v8
M$27 28 1 21 28 pfet_01v8 L=150000U W=2500000U AS=662500000000P
+ AD=350000000000P PS=5530000U PD=2780000U
* device instance $28 r0 *1 -6.32,-7.16 pfet_01v8
M$28 21 6 28 28 pfet_01v8 L=150000U W=2500000U AS=350000000000P
+ AD=350000000000P PS=2780000U PD=2780000U
* device instance $29 r0 *1 -5.89,-7.16 pfet_01v8
M$29 28 10 21 28 pfet_01v8 L=150000U W=2500000U AS=350000000000P
+ AD=662500000000P PS=2780000U PD=5530000U
* device instance $30 r0 *1 -3.59,-7.16 pfet_01v8
M$30 28 1 22 28 pfet_01v8 L=150000U W=2500000U AS=662500000000P
+ AD=350000000000P PS=5530000U PD=2780000U
* device instance $31 r0 *1 -3.16,-7.16 pfet_01v8
M$31 22 6 28 28 pfet_01v8 L=150000U W=2500000U AS=350000000000P
+ AD=350000000000P PS=2780000U PD=2780000U
* device instance $32 r0 *1 -2.73,-7.16 pfet_01v8
M$32 28 9 22 28 pfet_01v8 L=150000U W=2500000U AS=350000000000P
+ AD=662500000000P PS=2780000U PD=5530000U
* device instance $33 r0 *1 -62.625,10.225 pfet_01v8
M$33 91 58 59 91 pfet_01v8 L=150000U W=2650000U AS=702250000000P
+ AD=371000000000P PS=5830000U PD=2930000U
* device instance $34 r0 *1 -62.195,10.225 pfet_01v8
M$34 59 47 91 91 pfet_01v8 L=150000U W=2650000U AS=371000000000P
+ AD=702250000000P PS=2930000U PD=5830000U
* device instance $35 r0 *1 -61.045,10.225 pfet_01v8
M$35 91 58 60 91 pfet_01v8 L=150000U W=2650000U AS=702250000000P
+ AD=371000000000P PS=5830000U PD=2930000U
* device instance $36 r0 *1 -60.615,10.225 pfet_01v8
M$36 60 48 91 91 pfet_01v8 L=150000U W=2650000U AS=371000000000P
+ AD=702250000000P PS=2930000U PD=5830000U
* device instance $37 r0 *1 -59.465,10.225 pfet_01v8
M$37 91 58 61 91 pfet_01v8 L=150000U W=2650000U AS=702250000000P
+ AD=371000000000P PS=5830000U PD=2930000U
* device instance $38 r0 *1 -59.035,10.225 pfet_01v8
M$38 61 49 91 91 pfet_01v8 L=150000U W=2650000U AS=371000000000P
+ AD=702250000000P PS=2930000U PD=5830000U
* device instance $39 r0 *1 -57.885,10.225 pfet_01v8
M$39 91 58 62 91 pfet_01v8 L=150000U W=2650000U AS=702250000000P
+ AD=371000000000P PS=5830000U PD=2930000U
* device instance $40 r0 *1 -57.455,10.225 pfet_01v8
M$40 62 50 91 91 pfet_01v8 L=150000U W=2650000U AS=371000000000P
+ AD=702250000000P PS=2930000U PD=5830000U
* device instance $41 r0 *1 -54.725,10.225 pfet_01v8
M$41 91 58 63 91 pfet_01v8 L=150000U W=2650000U AS=702250000000P
+ AD=371000000000P PS=5830000U PD=2930000U
* device instance $42 r0 *1 -54.295,10.225 pfet_01v8
M$42 63 51 91 91 pfet_01v8 L=150000U W=2650000U AS=371000000000P
+ AD=702250000000P PS=2930000U PD=5830000U
* device instance $43 r0 *1 -53.145,10.225 pfet_01v8
M$43 91 58 64 91 pfet_01v8 L=150000U W=2650000U AS=702250000000P
+ AD=371000000000P PS=5830000U PD=2930000U
* device instance $44 r0 *1 -52.715,10.225 pfet_01v8
M$44 64 52 91 91 pfet_01v8 L=150000U W=2650000U AS=371000000000P
+ AD=702250000000P PS=2930000U PD=5830000U
* device instance $45 r0 *1 -51.565,10.225 pfet_01v8
M$45 91 58 65 91 pfet_01v8 L=150000U W=2650000U AS=702250000000P
+ AD=371000000000P PS=5830000U PD=2930000U
* device instance $46 r0 *1 -51.135,10.225 pfet_01v8
M$46 65 53 91 91 pfet_01v8 L=150000U W=2650000U AS=371000000000P
+ AD=702250000000P PS=2930000U PD=5830000U
* device instance $47 r0 *1 -49.985,10.225 pfet_01v8
M$47 91 58 66 91 pfet_01v8 L=150000U W=2650000U AS=702250000000P
+ AD=371000000000P PS=5830000U PD=2930000U
* device instance $48 r0 *1 -49.555,10.225 pfet_01v8
M$48 66 54 91 91 pfet_01v8 L=150000U W=2650000U AS=371000000000P
+ AD=702250000000P PS=2930000U PD=5830000U
* device instance $49 r0 *1 -46.825,-2.47 pfet_01v8
M$49 58 11 55 55 pfet_01v8 L=150000U W=7800000U AS=1.5795e+12P AD=1.5795e+12P
+ PS=12510000U PD=12510000U
* device instance $51 r0 *1 -46.825,10.225 pfet_01v8
M$51 91 57 67 91 pfet_01v8 L=150000U W=2650000U AS=702250000000P
+ AD=371000000000P PS=5830000U PD=2930000U
* device instance $52 r0 *1 -46.395,10.225 pfet_01v8
M$52 67 47 91 91 pfet_01v8 L=150000U W=2650000U AS=371000000000P
+ AD=702250000000P PS=2930000U PD=5830000U
* device instance $53 r0 *1 -45.245,10.225 pfet_01v8
M$53 91 57 68 91 pfet_01v8 L=150000U W=2650000U AS=702250000000P
+ AD=371000000000P PS=5830000U PD=2930000U
* device instance $54 r0 *1 -44.815,10.225 pfet_01v8
M$54 68 48 91 91 pfet_01v8 L=150000U W=2650000U AS=371000000000P
+ AD=702250000000P PS=2930000U PD=5830000U
* device instance $55 r0 *1 -45.245,-2.47 pfet_01v8
M$55 57 12 55 55 pfet_01v8 L=150000U W=7800000U AS=1.5795e+12P AD=1.5795e+12P
+ PS=12510000U PD=12510000U
* device instance $57 r0 *1 -43.665,-2.47 pfet_01v8
M$57 45 13 55 55 pfet_01v8 L=150000U W=7800000U AS=1.5795e+12P AD=1.5795e+12P
+ PS=12510000U PD=12510000U
* device instance $59 r0 *1 -43.665,10.225 pfet_01v8
M$59 91 57 69 91 pfet_01v8 L=150000U W=2650000U AS=702250000000P
+ AD=371000000000P PS=5830000U PD=2930000U
* device instance $60 r0 *1 -43.235,10.225 pfet_01v8
M$60 69 49 91 91 pfet_01v8 L=150000U W=2650000U AS=371000000000P
+ AD=702250000000P PS=2930000U PD=5830000U
* device instance $61 r0 *1 -42.085,10.225 pfet_01v8
M$61 91 57 70 91 pfet_01v8 L=150000U W=2650000U AS=702250000000P
+ AD=371000000000P PS=5830000U PD=2930000U
* device instance $62 r0 *1 -41.655,10.225 pfet_01v8
M$62 70 50 91 91 pfet_01v8 L=150000U W=2650000U AS=371000000000P
+ AD=702250000000P PS=2930000U PD=5830000U
* device instance $63 r0 *1 -42.085,-2.47 pfet_01v8
M$63 46 14 55 55 pfet_01v8 L=150000U W=7800000U AS=1.5795e+12P AD=1.5795e+12P
+ PS=12510000U PD=12510000U
* device instance $65 r0 *1 -38.925,10.225 pfet_01v8
M$65 91 57 71 91 pfet_01v8 L=150000U W=2650000U AS=702250000000P
+ AD=371000000000P PS=5830000U PD=2930000U
* device instance $66 r0 *1 -38.495,10.225 pfet_01v8
M$66 71 51 91 91 pfet_01v8 L=150000U W=2650000U AS=371000000000P
+ AD=702250000000P PS=2930000U PD=5830000U
* device instance $67 r0 *1 -37.345,10.225 pfet_01v8
M$67 91 57 72 91 pfet_01v8 L=150000U W=2650000U AS=702250000000P
+ AD=371000000000P PS=5830000U PD=2930000U
* device instance $68 r0 *1 -36.915,10.225 pfet_01v8
M$68 72 52 91 91 pfet_01v8 L=150000U W=2650000U AS=371000000000P
+ AD=702250000000P PS=2930000U PD=5830000U
* device instance $69 r0 *1 -35.765,10.225 pfet_01v8
M$69 91 57 73 91 pfet_01v8 L=150000U W=2650000U AS=702250000000P
+ AD=371000000000P PS=5830000U PD=2930000U
* device instance $70 r0 *1 -35.335,10.225 pfet_01v8
M$70 73 53 91 91 pfet_01v8 L=150000U W=2650000U AS=371000000000P
+ AD=702250000000P PS=2930000U PD=5830000U
* device instance $71 r0 *1 -34.185,10.225 pfet_01v8
M$71 91 57 74 91 pfet_01v8 L=150000U W=2650000U AS=702250000000P
+ AD=371000000000P PS=5830000U PD=2930000U
* device instance $72 r0 *1 -33.755,10.225 pfet_01v8
M$72 74 54 91 91 pfet_01v8 L=150000U W=2650000U AS=371000000000P
+ AD=702250000000P PS=2930000U PD=5830000U
* device instance $73 r0 *1 -31.025,10.225 pfet_01v8
M$73 91 45 75 91 pfet_01v8 L=150000U W=2650000U AS=702250000000P
+ AD=371000000000P PS=5830000U PD=2930000U
* device instance $74 r0 *1 -30.595,10.225 pfet_01v8
M$74 75 47 91 91 pfet_01v8 L=150000U W=2650000U AS=371000000000P
+ AD=702250000000P PS=2930000U PD=5830000U
* device instance $75 r0 *1 -30.235,-1.895 pfet_01v8
M$75 47 15 56 56 pfet_01v8 L=150000U W=5500000U AS=1.11375e+12P AD=1.11375e+12P
+ PS=9060000U PD=9060000U
* device instance $77 r0 *1 -29.445,10.225 pfet_01v8
M$77 91 45 76 91 pfet_01v8 L=150000U W=2650000U AS=702250000000P
+ AD=371000000000P PS=5830000U PD=2930000U
* device instance $78 r0 *1 -29.015,10.225 pfet_01v8
M$78 76 48 91 91 pfet_01v8 L=150000U W=2650000U AS=371000000000P
+ AD=702250000000P PS=2930000U PD=5830000U
* device instance $79 r0 *1 -27.865,10.225 pfet_01v8
M$79 91 45 77 91 pfet_01v8 L=150000U W=2650000U AS=702250000000P
+ AD=371000000000P PS=5830000U PD=2930000U
* device instance $80 r0 *1 -27.435,10.225 pfet_01v8
M$80 77 49 91 91 pfet_01v8 L=150000U W=2650000U AS=371000000000P
+ AD=702250000000P PS=2930000U PD=5830000U
* device instance $81 r0 *1 -27.075,-1.895 pfet_01v8
M$81 48 16 56 56 pfet_01v8 L=150000U W=5500000U AS=1.11375e+12P AD=1.11375e+12P
+ PS=9060000U PD=9060000U
* device instance $83 r0 *1 -26.285,10.225 pfet_01v8
M$83 91 45 78 91 pfet_01v8 L=150000U W=2650000U AS=702250000000P
+ AD=371000000000P PS=5830000U PD=2930000U
* device instance $84 r0 *1 -25.855,10.225 pfet_01v8
M$84 78 50 91 91 pfet_01v8 L=150000U W=2650000U AS=371000000000P
+ AD=702250000000P PS=2930000U PD=5830000U
* device instance $85 r0 *1 -23.125,10.225 pfet_01v8
M$85 91 45 79 91 pfet_01v8 L=150000U W=2650000U AS=702250000000P
+ AD=371000000000P PS=5830000U PD=2930000U
* device instance $86 r0 *1 -22.695,10.225 pfet_01v8
M$86 79 51 91 91 pfet_01v8 L=150000U W=2650000U AS=371000000000P
+ AD=702250000000P PS=2930000U PD=5830000U
* device instance $87 r0 *1 -22.335,-1.895 pfet_01v8
M$87 49 17 56 56 pfet_01v8 L=150000U W=5500000U AS=1.11375e+12P AD=1.11375e+12P
+ PS=9060000U PD=9060000U
* device instance $89 r0 *1 -21.545,10.225 pfet_01v8
M$89 91 45 80 91 pfet_01v8 L=150000U W=2650000U AS=702250000000P
+ AD=371000000000P PS=5830000U PD=2930000U
* device instance $90 r0 *1 -21.115,10.225 pfet_01v8
M$90 80 52 91 91 pfet_01v8 L=150000U W=2650000U AS=371000000000P
+ AD=702250000000P PS=2930000U PD=5830000U
* device instance $91 r0 *1 -19.965,10.225 pfet_01v8
M$91 91 45 81 91 pfet_01v8 L=150000U W=2650000U AS=702250000000P
+ AD=371000000000P PS=5830000U PD=2930000U
* device instance $92 r0 *1 -19.535,10.225 pfet_01v8
M$92 81 53 91 91 pfet_01v8 L=150000U W=2650000U AS=371000000000P
+ AD=702250000000P PS=2930000U PD=5830000U
* device instance $93 r0 *1 -19.175,-1.895 pfet_01v8
M$93 50 18 56 56 pfet_01v8 L=150000U W=5500000U AS=1.11375e+12P AD=1.11375e+12P
+ PS=9060000U PD=9060000U
* device instance $95 r0 *1 -18.385,10.225 pfet_01v8
M$95 91 45 82 91 pfet_01v8 L=150000U W=2650000U AS=702250000000P
+ AD=371000000000P PS=5830000U PD=2930000U
* device instance $96 r0 *1 -17.955,10.225 pfet_01v8
M$96 82 54 91 91 pfet_01v8 L=150000U W=2650000U AS=371000000000P
+ AD=702250000000P PS=2930000U PD=5830000U
* device instance $97 r0 *1 -15.225,10.225 pfet_01v8
M$97 91 46 83 91 pfet_01v8 L=150000U W=2650000U AS=702250000000P
+ AD=371000000000P PS=5830000U PD=2930000U
* device instance $98 r0 *1 -14.795,10.225 pfet_01v8
M$98 83 47 91 91 pfet_01v8 L=150000U W=2650000U AS=371000000000P
+ AD=702250000000P PS=2930000U PD=5830000U
* device instance $99 r0 *1 -14.435,-1.895 pfet_01v8
M$99 51 19 56 56 pfet_01v8 L=150000U W=5500000U AS=1.11375e+12P AD=1.11375e+12P
+ PS=9060000U PD=9060000U
* device instance $101 r0 *1 -13.645,10.225 pfet_01v8
M$101 91 46 84 91 pfet_01v8 L=150000U W=2650000U AS=702250000000P
+ AD=371000000000P PS=5830000U PD=2930000U
* device instance $102 r0 *1 -13.215,10.225 pfet_01v8
M$102 84 48 91 91 pfet_01v8 L=150000U W=2650000U AS=371000000000P
+ AD=702250000000P PS=2930000U PD=5830000U
* device instance $103 r0 *1 -12.065,10.225 pfet_01v8
M$103 91 46 85 91 pfet_01v8 L=150000U W=2650000U AS=702250000000P
+ AD=371000000000P PS=5830000U PD=2930000U
* device instance $104 r0 *1 -11.635,10.225 pfet_01v8
M$104 85 49 91 91 pfet_01v8 L=150000U W=2650000U AS=371000000000P
+ AD=702250000000P PS=2930000U PD=5830000U
* device instance $105 r0 *1 -11.275,-1.895 pfet_01v8
M$105 52 20 56 56 pfet_01v8 L=150000U W=5500000U AS=1.11375e+12P
+ AD=1.11375e+12P PS=9060000U PD=9060000U
* device instance $107 r0 *1 -10.485,10.225 pfet_01v8
M$107 91 46 86 91 pfet_01v8 L=150000U W=2650000U AS=702250000000P
+ AD=371000000000P PS=5830000U PD=2930000U
* device instance $108 r0 *1 -10.055,10.225 pfet_01v8
M$108 86 50 91 91 pfet_01v8 L=150000U W=2650000U AS=371000000000P
+ AD=702250000000P PS=2930000U PD=5830000U
* device instance $109 r0 *1 -7.325,10.225 pfet_01v8
M$109 91 46 87 91 pfet_01v8 L=150000U W=2650000U AS=702250000000P
+ AD=371000000000P PS=5830000U PD=2930000U
* device instance $110 r0 *1 -6.895,10.225 pfet_01v8
M$110 87 51 91 91 pfet_01v8 L=150000U W=2650000U AS=371000000000P
+ AD=702250000000P PS=2930000U PD=5830000U
* device instance $111 r0 *1 -6.535,-1.895 pfet_01v8
M$111 53 21 56 56 pfet_01v8 L=150000U W=5500000U AS=1.11375e+12P
+ AD=1.11375e+12P PS=9060000U PD=9060000U
* device instance $113 r0 *1 -5.745,10.225 pfet_01v8
M$113 91 46 88 91 pfet_01v8 L=150000U W=2650000U AS=702250000000P
+ AD=371000000000P PS=5830000U PD=2930000U
* device instance $114 r0 *1 -5.315,10.225 pfet_01v8
M$114 88 52 91 91 pfet_01v8 L=150000U W=2650000U AS=371000000000P
+ AD=702250000000P PS=2930000U PD=5830000U
* device instance $115 r0 *1 -4.165,10.225 pfet_01v8
M$115 91 46 89 91 pfet_01v8 L=150000U W=2650000U AS=702250000000P
+ AD=371000000000P PS=5830000U PD=2930000U
* device instance $116 r0 *1 -3.735,10.225 pfet_01v8
M$116 89 53 91 91 pfet_01v8 L=150000U W=2650000U AS=371000000000P
+ AD=702250000000P PS=2930000U PD=5830000U
* device instance $117 r0 *1 -3.375,-1.895 pfet_01v8
M$117 54 22 56 56 pfet_01v8 L=150000U W=5500000U AS=1.11375e+12P
+ AD=1.11375e+12P PS=9060000U PD=9060000U
* device instance $119 r0 *1 -2.585,10.225 pfet_01v8
M$119 91 46 90 91 pfet_01v8 L=150000U W=2650000U AS=702250000000P
+ AD=371000000000P PS=5830000U PD=2930000U
* device instance $120 r0 *1 -2.155,10.225 pfet_01v8
M$120 90 54 91 91 pfet_01v8 L=150000U W=2650000U AS=371000000000P
+ AD=702250000000P PS=2930000U PD=5830000U
* device instance $121 r0 *1 -62.625,15.69 pfet_01v8
M$121 124 59 156 156 pfet_01v8 L=150000U W=5800000U AS=1.1745e+12P
+ AD=1.1745e+12P PS=9510000U PD=9510000U
* device instance $123 r0 *1 -61.045,15.69 pfet_01v8
M$123 125 60 156 156 pfet_01v8 L=150000U W=5800000U AS=1.1745e+12P
+ AD=1.1745e+12P PS=9510000U PD=9510000U
* device instance $125 r0 *1 -59.465,15.69 pfet_01v8
M$125 126 61 156 156 pfet_01v8 L=150000U W=5800000U AS=1.1745e+12P
+ AD=1.1745e+12P PS=9510000U PD=9510000U
* device instance $127 r0 *1 -57.885,15.69 pfet_01v8
M$127 127 62 156 156 pfet_01v8 L=150000U W=5800000U AS=1.1745e+12P
+ AD=1.1745e+12P PS=9510000U PD=9510000U
* device instance $129 r0 *1 -54.725,15.69 pfet_01v8
M$129 128 63 156 156 pfet_01v8 L=150000U W=5800000U AS=1.1745e+12P
+ AD=1.1745e+12P PS=9510000U PD=9510000U
* device instance $131 r0 *1 -53.145,15.69 pfet_01v8
M$131 129 64 156 156 pfet_01v8 L=150000U W=5800000U AS=1.1745e+12P
+ AD=1.1745e+12P PS=9510000U PD=9510000U
* device instance $133 r0 *1 -51.565,15.69 pfet_01v8
M$133 130 65 156 156 pfet_01v8 L=150000U W=5800000U AS=1.1745e+12P
+ AD=1.1745e+12P PS=9510000U PD=9510000U
* device instance $135 r0 *1 -49.985,15.69 pfet_01v8
M$135 131 66 156 156 pfet_01v8 L=150000U W=5800000U AS=1.1745e+12P
+ AD=1.1745e+12P PS=9510000U PD=9510000U
* device instance $137 r0 *1 -46.825,15.69 pfet_01v8
M$137 132 67 156 156 pfet_01v8 L=150000U W=5800000U AS=1.1745e+12P
+ AD=1.1745e+12P PS=9510000U PD=9510000U
* device instance $139 r0 *1 -45.245,15.69 pfet_01v8
M$139 133 68 156 156 pfet_01v8 L=150000U W=5800000U AS=1.1745e+12P
+ AD=1.1745e+12P PS=9510000U PD=9510000U
* device instance $141 r0 *1 -43.665,15.69 pfet_01v8
M$141 134 69 156 156 pfet_01v8 L=150000U W=5800000U AS=1.1745e+12P
+ AD=1.1745e+12P PS=9510000U PD=9510000U
* device instance $143 r0 *1 -42.085,15.69 pfet_01v8
M$143 135 70 156 156 pfet_01v8 L=150000U W=5800000U AS=1.1745e+12P
+ AD=1.1745e+12P PS=9510000U PD=9510000U
* device instance $145 r0 *1 -38.925,15.69 pfet_01v8
M$145 136 71 156 156 pfet_01v8 L=150000U W=5800000U AS=1.1745e+12P
+ AD=1.1745e+12P PS=9510000U PD=9510000U
* device instance $147 r0 *1 -37.345,15.69 pfet_01v8
M$147 137 72 156 156 pfet_01v8 L=150000U W=5800000U AS=1.1745e+12P
+ AD=1.1745e+12P PS=9510000U PD=9510000U
* device instance $149 r0 *1 -35.765,15.69 pfet_01v8
M$149 138 73 156 156 pfet_01v8 L=150000U W=5800000U AS=1.1745e+12P
+ AD=1.1745e+12P PS=9510000U PD=9510000U
* device instance $151 r0 *1 -34.185,15.69 pfet_01v8
M$151 139 74 156 156 pfet_01v8 L=150000U W=5800000U AS=1.1745e+12P
+ AD=1.1745e+12P PS=9510000U PD=9510000U
* device instance $153 r0 *1 -31.025,15.69 pfet_01v8
M$153 140 75 156 156 pfet_01v8 L=150000U W=5800000U AS=1.1745e+12P
+ AD=1.1745e+12P PS=9510000U PD=9510000U
* device instance $155 r0 *1 -29.445,15.69 pfet_01v8
M$155 141 76 156 156 pfet_01v8 L=150000U W=5800000U AS=1.1745e+12P
+ AD=1.1745e+12P PS=9510000U PD=9510000U
* device instance $157 r0 *1 -27.865,15.69 pfet_01v8
M$157 142 77 156 156 pfet_01v8 L=150000U W=5800000U AS=1.1745e+12P
+ AD=1.1745e+12P PS=9510000U PD=9510000U
* device instance $159 r0 *1 -26.285,15.69 pfet_01v8
M$159 143 78 156 156 pfet_01v8 L=150000U W=5800000U AS=1.1745e+12P
+ AD=1.1745e+12P PS=9510000U PD=9510000U
* device instance $161 r0 *1 -23.125,15.69 pfet_01v8
M$161 144 79 156 156 pfet_01v8 L=150000U W=5800000U AS=1.1745e+12P
+ AD=1.1745e+12P PS=9510000U PD=9510000U
* device instance $163 r0 *1 -21.545,15.69 pfet_01v8
M$163 145 80 156 156 pfet_01v8 L=150000U W=5800000U AS=1.1745e+12P
+ AD=1.1745e+12P PS=9510000U PD=9510000U
* device instance $165 r0 *1 -19.965,15.69 pfet_01v8
M$165 146 81 156 156 pfet_01v8 L=150000U W=5800000U AS=1.1745e+12P
+ AD=1.1745e+12P PS=9510000U PD=9510000U
* device instance $167 r0 *1 -18.385,15.69 pfet_01v8
M$167 147 82 156 156 pfet_01v8 L=150000U W=5800000U AS=1.1745e+12P
+ AD=1.1745e+12P PS=9510000U PD=9510000U
* device instance $169 r0 *1 -15.225,15.69 pfet_01v8
M$169 148 83 156 156 pfet_01v8 L=150000U W=5800000U AS=1.1745e+12P
+ AD=1.1745e+12P PS=9510000U PD=9510000U
* device instance $171 r0 *1 -13.645,15.69 pfet_01v8
M$171 149 84 156 156 pfet_01v8 L=150000U W=5800000U AS=1.1745e+12P
+ AD=1.1745e+12P PS=9510000U PD=9510000U
* device instance $173 r0 *1 -12.065,15.69 pfet_01v8
M$173 150 85 156 156 pfet_01v8 L=150000U W=5800000U AS=1.1745e+12P
+ AD=1.1745e+12P PS=9510000U PD=9510000U
* device instance $175 r0 *1 -10.485,15.69 pfet_01v8
M$175 151 86 156 156 pfet_01v8 L=150000U W=5800000U AS=1.1745e+12P
+ AD=1.1745e+12P PS=9510000U PD=9510000U
* device instance $177 r0 *1 -7.325,15.69 pfet_01v8
M$177 152 87 156 156 pfet_01v8 L=150000U W=5800000U AS=1.1745e+12P
+ AD=1.1745e+12P PS=9510000U PD=9510000U
* device instance $179 r0 *1 -5.745,15.69 pfet_01v8
M$179 153 88 156 156 pfet_01v8 L=150000U W=5800000U AS=1.1745e+12P
+ AD=1.1745e+12P PS=9510000U PD=9510000U
* device instance $181 r0 *1 -4.165,15.69 pfet_01v8
M$181 154 89 156 156 pfet_01v8 L=150000U W=5800000U AS=1.1745e+12P
+ AD=1.1745e+12P PS=9510000U PD=9510000U
* device instance $183 r0 *1 -2.585,15.69 pfet_01v8
M$183 155 90 156 156 pfet_01v8 L=150000U W=5800000U AS=1.1745e+12P
+ AD=1.1745e+12P PS=9510000U PD=9510000U
* device instance $185 r0 *1 -62.59,22.5 pfet_01v8
M$185 189 124 157 189 pfet_01v8 L=150000U W=13300000U AS=1.9495e+12P
+ AD=1.9495e+12P PS=19570000U PD=19570000U
* device instance $204 r0 *1 -61.01,22.5 pfet_01v8
M$204 189 125 158 189 pfet_01v8 L=150000U W=13300000U AS=1.9495e+12P
+ AD=1.9495e+12P PS=19570000U PD=19570000U
* device instance $223 r0 *1 -59.43,22.5 pfet_01v8
M$223 189 126 159 189 pfet_01v8 L=150000U W=13300000U AS=1.9495e+12P
+ AD=1.9495e+12P PS=19570000U PD=19570000U
* device instance $242 r0 *1 -57.85,22.5 pfet_01v8
M$242 189 127 160 189 pfet_01v8 L=150000U W=13300000U AS=1.9495e+12P
+ AD=1.9495e+12P PS=19570000U PD=19570000U
* device instance $261 r0 *1 -54.69,22.5 pfet_01v8
M$261 189 128 161 189 pfet_01v8 L=150000U W=13300000U AS=1.9495e+12P
+ AD=1.9495e+12P PS=19570000U PD=19570000U
* device instance $280 r0 *1 -53.11,22.5 pfet_01v8
M$280 189 129 162 189 pfet_01v8 L=150000U W=13300000U AS=1.9495e+12P
+ AD=1.9495e+12P PS=19570000U PD=19570000U
* device instance $299 r0 *1 -51.53,22.5 pfet_01v8
M$299 189 130 163 189 pfet_01v8 L=150000U W=13300000U AS=1.9495e+12P
+ AD=1.9495e+12P PS=19570000U PD=19570000U
* device instance $318 r0 *1 -49.95,22.5 pfet_01v8
M$318 189 131 164 189 pfet_01v8 L=150000U W=13300000U AS=1.9495e+12P
+ AD=1.9495e+12P PS=19570000U PD=19570000U
* device instance $337 r0 *1 -46.79,22.5 pfet_01v8
M$337 189 132 165 189 pfet_01v8 L=150000U W=13300000U AS=1.9495e+12P
+ AD=1.9495e+12P PS=19570000U PD=19570000U
* device instance $356 r0 *1 -45.21,22.5 pfet_01v8
M$356 189 133 166 189 pfet_01v8 L=150000U W=13300000U AS=1.9495e+12P
+ AD=1.9495e+12P PS=19570000U PD=19570000U
* device instance $375 r0 *1 -43.63,22.5 pfet_01v8
M$375 189 134 167 189 pfet_01v8 L=150000U W=13300000U AS=1.9495e+12P
+ AD=1.9495e+12P PS=19570000U PD=19570000U
* device instance $394 r0 *1 -42.05,22.5 pfet_01v8
M$394 189 135 168 189 pfet_01v8 L=150000U W=13300000U AS=1.9495e+12P
+ AD=1.9495e+12P PS=19570000U PD=19570000U
* device instance $413 r0 *1 -38.89,22.5 pfet_01v8
M$413 189 136 169 189 pfet_01v8 L=150000U W=13300000U AS=1.9495e+12P
+ AD=1.9495e+12P PS=19570000U PD=19570000U
* device instance $432 r0 *1 -37.31,22.5 pfet_01v8
M$432 189 137 170 189 pfet_01v8 L=150000U W=13300000U AS=1.9495e+12P
+ AD=1.9495e+12P PS=19570000U PD=19570000U
* device instance $451 r0 *1 -35.73,22.5 pfet_01v8
M$451 189 138 171 189 pfet_01v8 L=150000U W=13300000U AS=1.9495e+12P
+ AD=1.9495e+12P PS=19570000U PD=19570000U
* device instance $470 r0 *1 -34.15,22.5 pfet_01v8
M$470 189 139 172 189 pfet_01v8 L=150000U W=13300000U AS=1.9495e+12P
+ AD=1.9495e+12P PS=19570000U PD=19570000U
* device instance $489 r0 *1 -30.99,22.5 pfet_01v8
M$489 189 140 173 189 pfet_01v8 L=150000U W=13300000U AS=1.9495e+12P
+ AD=1.9495e+12P PS=19570000U PD=19570000U
* device instance $508 r0 *1 -29.41,22.5 pfet_01v8
M$508 189 141 174 189 pfet_01v8 L=150000U W=13300000U AS=1.9495e+12P
+ AD=1.9495e+12P PS=19570000U PD=19570000U
* device instance $527 r0 *1 -27.83,22.5 pfet_01v8
M$527 189 142 175 189 pfet_01v8 L=150000U W=13300000U AS=1.9495e+12P
+ AD=1.9495e+12P PS=19570000U PD=19570000U
* device instance $546 r0 *1 -26.25,22.5 pfet_01v8
M$546 189 143 176 189 pfet_01v8 L=150000U W=13300000U AS=1.9495e+12P
+ AD=1.9495e+12P PS=19570000U PD=19570000U
* device instance $565 r0 *1 -23.09,22.5 pfet_01v8
M$565 189 144 177 189 pfet_01v8 L=150000U W=13300000U AS=1.9495e+12P
+ AD=1.9495e+12P PS=19570000U PD=19570000U
* device instance $584 r0 *1 -21.51,22.5 pfet_01v8
M$584 189 145 178 189 pfet_01v8 L=150000U W=13300000U AS=1.9495e+12P
+ AD=1.9495e+12P PS=19570000U PD=19570000U
* device instance $603 r0 *1 -19.93,22.5 pfet_01v8
M$603 189 146 179 189 pfet_01v8 L=150000U W=13300000U AS=1.9495e+12P
+ AD=1.9495e+12P PS=19570000U PD=19570000U
* device instance $622 r0 *1 -18.35,22.5 pfet_01v8
M$622 189 147 180 189 pfet_01v8 L=150000U W=13300000U AS=1.9495e+12P
+ AD=1.9495e+12P PS=19570000U PD=19570000U
* device instance $641 r0 *1 -15.19,22.5 pfet_01v8
M$641 189 148 181 189 pfet_01v8 L=150000U W=13300000U AS=1.9495e+12P
+ AD=1.9495e+12P PS=19570000U PD=19570000U
* device instance $660 r0 *1 -13.61,22.5 pfet_01v8
M$660 189 149 182 189 pfet_01v8 L=150000U W=13300000U AS=1.9495e+12P
+ AD=1.9495e+12P PS=19570000U PD=19570000U
* device instance $679 r0 *1 -12.03,22.5 pfet_01v8
M$679 189 150 183 189 pfet_01v8 L=150000U W=13300000U AS=1.9495e+12P
+ AD=1.9495e+12P PS=19570000U PD=19570000U
* device instance $698 r0 *1 -10.45,22.5 pfet_01v8
M$698 189 151 184 189 pfet_01v8 L=150000U W=13300000U AS=1.9495e+12P
+ AD=1.9495e+12P PS=19570000U PD=19570000U
* device instance $717 r0 *1 -7.29,22.5 pfet_01v8
M$717 189 152 185 189 pfet_01v8 L=150000U W=13300000U AS=1.9495e+12P
+ AD=1.9495e+12P PS=19570000U PD=19570000U
* device instance $736 r0 *1 -5.71,22.5 pfet_01v8
M$736 189 153 186 189 pfet_01v8 L=150000U W=13300000U AS=1.9495e+12P
+ AD=1.9495e+12P PS=19570000U PD=19570000U
* device instance $755 r0 *1 -4.13,22.5 pfet_01v8
M$755 189 154 187 189 pfet_01v8 L=150000U W=13300000U AS=1.9495e+12P
+ AD=1.9495e+12P PS=19570000U PD=19570000U
* device instance $774 r0 *1 -2.55,22.5 pfet_01v8
M$774 189 155 188 189 pfet_01v8 L=150000U W=13300000U AS=1.9495e+12P
+ AD=1.9495e+12P PS=19570000U PD=19570000U
* device instance $793 r0 *1 -62.59,40.01 pfet_01v8
M$793 190 157 222 222 pfet_01v8 L=150000U W=30800000U AS=4.3995e+12P
+ AD=4.3995e+12P PS=44070000U PD=44070000U
* device instance $837 r0 *1 -59.43,40.01 pfet_01v8
M$837 192 159 222 222 pfet_01v8 L=150000U W=30800000U AS=4.3995e+12P
+ AD=4.3995e+12P PS=44070000U PD=44070000U
* device instance $881 r0 *1 -57.85,40.01 pfet_01v8
M$881 193 160 222 222 pfet_01v8 L=150000U W=30800000U AS=4.3995e+12P
+ AD=4.3995e+12P PS=44070000U PD=44070000U
* device instance $925 r0 *1 -53.11,40.01 pfet_01v8
M$925 195 162 222 222 pfet_01v8 L=150000U W=30800000U AS=4.3995e+12P
+ AD=4.3995e+12P PS=44070000U PD=44070000U
* device instance $969 r0 *1 -51.53,40.01 pfet_01v8
M$969 196 163 222 222 pfet_01v8 L=150000U W=30800000U AS=4.3995e+12P
+ AD=4.3995e+12P PS=44070000U PD=44070000U
* device instance $1013 r0 *1 -49.95,40.01 pfet_01v8
M$1013 197 164 222 222 pfet_01v8 L=150000U W=30800000U AS=4.3995e+12P
+ AD=4.3995e+12P PS=44070000U PD=44070000U
* device instance $1057 r0 *1 -46.79,40.01 pfet_01v8
M$1057 198 165 222 222 pfet_01v8 L=150000U W=30800000U AS=4.3995e+12P
+ AD=4.3995e+12P PS=44070000U PD=44070000U
* device instance $1101 r0 *1 -45.21,40.01 pfet_01v8
M$1101 199 166 222 222 pfet_01v8 L=150000U W=30800000U AS=4.3995e+12P
+ AD=4.3995e+12P PS=44070000U PD=44070000U
* device instance $1145 r0 *1 -42.05,40.01 pfet_01v8
M$1145 201 168 222 222 pfet_01v8 L=150000U W=30800000U AS=4.3995e+12P
+ AD=4.3995e+12P PS=44070000U PD=44070000U
* device instance $1189 r0 *1 -37.31,40.01 pfet_01v8
M$1189 203 170 222 222 pfet_01v8 L=150000U W=30800000U AS=4.3995e+12P
+ AD=4.3995e+12P PS=44070000U PD=44070000U
* device instance $1233 r0 *1 -35.73,40.01 pfet_01v8
M$1233 204 171 222 222 pfet_01v8 L=150000U W=30800000U AS=4.3995e+12P
+ AD=4.3995e+12P PS=44070000U PD=44070000U
* device instance $1277 r0 *1 -34.15,40.01 pfet_01v8
M$1277 205 172 222 222 pfet_01v8 L=150000U W=30800000U AS=4.3995e+12P
+ AD=4.3995e+12P PS=44070000U PD=44070000U
* device instance $1321 r0 *1 -30.99,40.01 pfet_01v8
M$1321 206 173 222 222 pfet_01v8 L=150000U W=30800000U AS=4.3995e+12P
+ AD=4.3995e+12P PS=44070000U PD=44070000U
* device instance $1365 r0 *1 -29.41,40.01 pfet_01v8
M$1365 207 174 222 222 pfet_01v8 L=150000U W=30800000U AS=4.3995e+12P
+ AD=4.3995e+12P PS=44070000U PD=44070000U
* device instance $1409 r0 *1 -26.25,40.01 pfet_01v8
M$1409 209 176 222 222 pfet_01v8 L=150000U W=30800000U AS=4.3995e+12P
+ AD=4.3995e+12P PS=44070000U PD=44070000U
* device instance $1453 r0 *1 -23.09,40.01 pfet_01v8
M$1453 210 177 222 222 pfet_01v8 L=150000U W=30800000U AS=4.3995e+12P
+ AD=4.3995e+12P PS=44070000U PD=44070000U
* device instance $1497 r0 *1 -19.93,40.01 pfet_01v8
M$1497 212 179 222 222 pfet_01v8 L=150000U W=30800000U AS=4.3995e+12P
+ AD=4.3995e+12P PS=44070000U PD=44070000U
* device instance $1541 r0 *1 -15.19,40.01 pfet_01v8
M$1541 214 181 222 222 pfet_01v8 L=150000U W=30800000U AS=4.3995e+12P
+ AD=4.3995e+12P PS=44070000U PD=44070000U
* device instance $1585 r0 *1 -13.61,40.01 pfet_01v8
M$1585 215 182 222 222 pfet_01v8 L=150000U W=30800000U AS=4.3995e+12P
+ AD=4.3995e+12P PS=44070000U PD=44070000U
* device instance $1629 r0 *1 -10.45,40.01 pfet_01v8
M$1629 217 184 222 222 pfet_01v8 L=150000U W=30800000U AS=4.3995e+12P
+ AD=4.3995e+12P PS=44070000U PD=44070000U
* device instance $1673 r0 *1 -7.29,40.01 pfet_01v8
M$1673 218 185 222 222 pfet_01v8 L=150000U W=30800000U AS=4.3995e+12P
+ AD=4.3995e+12P PS=44070000U PD=44070000U
* device instance $1717 r0 *1 -5.71,40.01 pfet_01v8
M$1717 219 186 222 222 pfet_01v8 L=150000U W=30800000U AS=4.3995e+12P
+ AD=4.3995e+12P PS=44070000U PD=44070000U
* device instance $1761 r0 *1 -4.13,40.01 pfet_01v8
M$1761 220 187 222 222 pfet_01v8 L=150000U W=30800000U AS=4.3995e+12P
+ AD=4.3995e+12P PS=44070000U PD=44070000U
* device instance $1805 r0 *1 -2.55,40.01 pfet_01v8
M$1805 221 188 222 222 pfet_01v8 L=150000U W=30800000U AS=4.3995e+12P
+ AD=4.3995e+12P PS=44070000U PD=44070000U
* device instance $1849 r0 *1 -61.01,40.01 pfet_01v8
M$1849 191 158 222 222 pfet_01v8 L=150000U W=30800000U AS=4.3995e+12P
+ AD=4.3995e+12P PS=44070000U PD=44070000U
* device instance $1893 r0 *1 -54.69,40.01 pfet_01v8
M$1893 194 161 222 222 pfet_01v8 L=150000U W=30800000U AS=4.3995e+12P
+ AD=4.3995e+12P PS=44070000U PD=44070000U
* device instance $1937 r0 *1 -43.63,40.01 pfet_01v8
M$1937 200 167 222 222 pfet_01v8 L=150000U W=30800000U AS=4.3995e+12P
+ AD=4.3995e+12P PS=44070000U PD=44070000U
* device instance $1981 r0 *1 -38.89,40.01 pfet_01v8
M$1981 202 169 222 222 pfet_01v8 L=150000U W=30800000U AS=4.3995e+12P
+ AD=4.3995e+12P PS=44070000U PD=44070000U
* device instance $2025 r0 *1 -27.83,40.01 pfet_01v8
M$2025 208 175 222 222 pfet_01v8 L=150000U W=30800000U AS=4.3995e+12P
+ AD=4.3995e+12P PS=44070000U PD=44070000U
* device instance $2069 r0 *1 -21.51,40.01 pfet_01v8
M$2069 211 178 222 222 pfet_01v8 L=150000U W=30800000U AS=4.3995e+12P
+ AD=4.3995e+12P PS=44070000U PD=44070000U
* device instance $2113 r0 *1 -18.35,40.01 pfet_01v8
M$2113 213 180 222 222 pfet_01v8 L=150000U W=30800000U AS=4.3995e+12P
+ AD=4.3995e+12P PS=44070000U PD=44070000U
* device instance $2157 r0 *1 -12.03,40.01 pfet_01v8
M$2157 216 183 222 222 pfet_01v8 L=150000U W=30800000U AS=4.3995e+12P
+ AD=4.3995e+12P PS=44070000U PD=44070000U
* device instance $2201 r0 *1 -46.825,-11.53 nfet_01v8
M$2201 23 5 11 223 nfet_01v8 L=150000U W=2000000U AS=530000000000P
+ AD=280000000000P PS=4530000U PD=2280000U
* device instance $2202 r0 *1 -46.395,-11.53 nfet_01v8
M$2202 223 8 23 223 nfet_01v8 L=150000U W=2000000U AS=280000000000P
+ AD=530000000000P PS=2280000U PD=4530000U
* device instance $2203 r0 *1 -45.245,-11.53 nfet_01v8
M$2203 24 5 12 223 nfet_01v8 L=150000U W=2000000U AS=530000000000P
+ AD=280000000000P PS=4530000U PD=2280000U
* device instance $2204 r0 *1 -44.815,-11.53 nfet_01v8
M$2204 223 4 24 223 nfet_01v8 L=150000U W=2000000U AS=280000000000P
+ AD=530000000000P PS=2280000U PD=4530000U
* device instance $2205 r0 *1 -43.665,-11.53 nfet_01v8
M$2205 25 2 13 223 nfet_01v8 L=150000U W=2000000U AS=530000000000P
+ AD=280000000000P PS=4530000U PD=2280000U
* device instance $2206 r0 *1 -43.235,-11.53 nfet_01v8
M$2206 223 8 25 223 nfet_01v8 L=150000U W=2000000U AS=280000000000P
+ AD=530000000000P PS=2280000U PD=4530000U
* device instance $2207 r0 *1 -42.085,-11.53 nfet_01v8
M$2207 26 2 14 223 nfet_01v8 L=150000U W=2000000U AS=530000000000P
+ AD=280000000000P PS=4530000U PD=2280000U
* device instance $2208 r0 *1 -41.655,-11.53 nfet_01v8
M$2208 223 4 26 223 nfet_01v8 L=150000U W=2000000U AS=280000000000P
+ AD=530000000000P PS=2280000U PD=4530000U
* device instance $2209 r0 *1 -30.45,-10.43 nfet_01v8
M$2209 43 3 15 223 nfet_01v8 L=150000U W=3000000U AS=795000000000P
+ AD=420000000000P PS=6530000U PD=3280000U
* device instance $2210 r0 *1 -30.02,-10.43 nfet_01v8
M$2210 44 7 43 223 nfet_01v8 L=150000U W=3000000U AS=420000000000P
+ AD=420000000000P PS=3280000U PD=3280000U
* device instance $2211 r0 *1 -29.59,-10.43 nfet_01v8
M$2211 223 10 44 223 nfet_01v8 L=150000U W=3000000U AS=420000000000P
+ AD=795000000000P PS=3280000U PD=6530000U
* device instance $2212 r0 *1 -27.29,-10.43 nfet_01v8
M$2212 42 3 16 223 nfet_01v8 L=150000U W=3000000U AS=795000000000P
+ AD=420000000000P PS=6530000U PD=3280000U
* device instance $2213 r0 *1 -26.86,-10.43 nfet_01v8
M$2213 41 7 42 223 nfet_01v8 L=150000U W=3000000U AS=420000000000P
+ AD=420000000000P PS=3280000U PD=3280000U
* device instance $2214 r0 *1 -26.43,-10.43 nfet_01v8
M$2214 223 9 41 223 nfet_01v8 L=150000U W=3000000U AS=420000000000P
+ AD=795000000000P PS=3280000U PD=6530000U
* device instance $2215 r0 *1 -22.55,-10.43 nfet_01v8
M$2215 39 3 17 223 nfet_01v8 L=150000U W=3000000U AS=795000000000P
+ AD=420000000000P PS=6530000U PD=3280000U
* device instance $2216 r0 *1 -22.12,-10.43 nfet_01v8
M$2216 40 6 39 223 nfet_01v8 L=150000U W=3000000U AS=420000000000P
+ AD=420000000000P PS=3280000U PD=3280000U
* device instance $2217 r0 *1 -21.69,-10.43 nfet_01v8
M$2217 223 10 40 223 nfet_01v8 L=150000U W=3000000U AS=420000000000P
+ AD=795000000000P PS=3280000U PD=6530000U
* device instance $2218 r0 *1 -19.39,-10.43 nfet_01v8
M$2218 38 3 18 223 nfet_01v8 L=150000U W=3000000U AS=795000000000P
+ AD=420000000000P PS=6530000U PD=3280000U
* device instance $2219 r0 *1 -18.96,-10.43 nfet_01v8
M$2219 37 6 38 223 nfet_01v8 L=150000U W=3000000U AS=420000000000P
+ AD=420000000000P PS=3280000U PD=3280000U
* device instance $2220 r0 *1 -18.53,-10.43 nfet_01v8
M$2220 223 9 37 223 nfet_01v8 L=150000U W=3000000U AS=420000000000P
+ AD=795000000000P PS=3280000U PD=6530000U
* device instance $2221 r0 *1 -14.65,-10.43 nfet_01v8
M$2221 35 1 19 223 nfet_01v8 L=150000U W=3000000U AS=795000000000P
+ AD=420000000000P PS=6530000U PD=3280000U
* device instance $2222 r0 *1 -14.22,-10.43 nfet_01v8
M$2222 36 7 35 223 nfet_01v8 L=150000U W=3000000U AS=420000000000P
+ AD=420000000000P PS=3280000U PD=3280000U
* device instance $2223 r0 *1 -13.79,-10.43 nfet_01v8
M$2223 223 10 36 223 nfet_01v8 L=150000U W=3000000U AS=420000000000P
+ AD=795000000000P PS=3280000U PD=6530000U
* device instance $2224 r0 *1 -11.49,-10.43 nfet_01v8
M$2224 34 1 20 223 nfet_01v8 L=150000U W=3000000U AS=795000000000P
+ AD=420000000000P PS=6530000U PD=3280000U
* device instance $2225 r0 *1 -11.06,-10.43 nfet_01v8
M$2225 33 7 34 223 nfet_01v8 L=150000U W=3000000U AS=420000000000P
+ AD=420000000000P PS=3280000U PD=3280000U
* device instance $2226 r0 *1 -10.63,-10.43 nfet_01v8
M$2226 223 9 33 223 nfet_01v8 L=150000U W=3000000U AS=420000000000P
+ AD=795000000000P PS=3280000U PD=6530000U
* device instance $2227 r0 *1 -6.75,-10.43 nfet_01v8
M$2227 31 1 21 223 nfet_01v8 L=150000U W=3000000U AS=795000000000P
+ AD=420000000000P PS=6530000U PD=3280000U
* device instance $2228 r0 *1 -6.32,-10.43 nfet_01v8
M$2228 32 6 31 223 nfet_01v8 L=150000U W=3000000U AS=420000000000P
+ AD=420000000000P PS=3280000U PD=3280000U
* device instance $2229 r0 *1 -5.89,-10.43 nfet_01v8
M$2229 223 10 32 223 nfet_01v8 L=150000U W=3000000U AS=420000000000P
+ AD=795000000000P PS=3280000U PD=6530000U
* device instance $2230 r0 *1 -3.59,-10.43 nfet_01v8
M$2230 29 1 22 223 nfet_01v8 L=150000U W=3000000U AS=795000000000P
+ AD=420000000000P PS=6530000U PD=3280000U
* device instance $2231 r0 *1 -3.16,-10.43 nfet_01v8
M$2231 30 6 29 223 nfet_01v8 L=150000U W=3000000U AS=420000000000P
+ AD=420000000000P PS=3280000U PD=3280000U
* device instance $2232 r0 *1 -2.73,-10.43 nfet_01v8
M$2232 223 9 30 223 nfet_01v8 L=150000U W=3000000U AS=420000000000P
+ AD=795000000000P PS=3280000U PD=6530000U
* device instance $2233 r0 *1 -62.625,7.33 nfet_01v8
M$2233 92 58 59 223 nfet_01v8 L=150000U W=2100000U AS=556500000000P
+ AD=294000000000P PS=4730000U PD=2380000U
* device instance $2234 r0 *1 -62.195,7.33 nfet_01v8
M$2234 223 47 92 223 nfet_01v8 L=150000U W=2100000U AS=294000000000P
+ AD=556500000000P PS=2380000U PD=4730000U
* device instance $2235 r0 *1 -61.045,7.33 nfet_01v8
M$2235 94 58 60 223 nfet_01v8 L=150000U W=2100000U AS=556500000000P
+ AD=294000000000P PS=4730000U PD=2380000U
* device instance $2236 r0 *1 -60.615,7.33 nfet_01v8
M$2236 223 48 94 223 nfet_01v8 L=150000U W=2100000U AS=294000000000P
+ AD=556500000000P PS=2380000U PD=4730000U
* device instance $2237 r0 *1 -59.465,7.33 nfet_01v8
M$2237 96 58 61 223 nfet_01v8 L=150000U W=2100000U AS=556500000000P
+ AD=294000000000P PS=4730000U PD=2380000U
* device instance $2238 r0 *1 -59.035,7.33 nfet_01v8
M$2238 223 49 96 223 nfet_01v8 L=150000U W=2100000U AS=294000000000P
+ AD=556500000000P PS=2380000U PD=4730000U
* device instance $2239 r0 *1 -57.885,7.33 nfet_01v8
M$2239 98 58 62 223 nfet_01v8 L=150000U W=2100000U AS=556500000000P
+ AD=294000000000P PS=4730000U PD=2380000U
* device instance $2240 r0 *1 -57.455,7.33 nfet_01v8
M$2240 223 50 98 223 nfet_01v8 L=150000U W=2100000U AS=294000000000P
+ AD=556500000000P PS=2380000U PD=4730000U
* device instance $2241 r0 *1 -54.725,7.33 nfet_01v8
M$2241 100 58 63 223 nfet_01v8 L=150000U W=2100000U AS=556500000000P
+ AD=294000000000P PS=4730000U PD=2380000U
* device instance $2242 r0 *1 -54.295,7.33 nfet_01v8
M$2242 223 51 100 223 nfet_01v8 L=150000U W=2100000U AS=294000000000P
+ AD=556500000000P PS=2380000U PD=4730000U
* device instance $2243 r0 *1 -53.145,7.33 nfet_01v8
M$2243 101 58 64 223 nfet_01v8 L=150000U W=2100000U AS=556500000000P
+ AD=294000000000P PS=4730000U PD=2380000U
* device instance $2244 r0 *1 -52.715,7.33 nfet_01v8
M$2244 223 52 101 223 nfet_01v8 L=150000U W=2100000U AS=294000000000P
+ AD=556500000000P PS=2380000U PD=4730000U
* device instance $2245 r0 *1 -51.565,7.33 nfet_01v8
M$2245 103 58 65 223 nfet_01v8 L=150000U W=2100000U AS=556500000000P
+ AD=294000000000P PS=4730000U PD=2380000U
* device instance $2246 r0 *1 -51.135,7.33 nfet_01v8
M$2246 223 53 103 223 nfet_01v8 L=150000U W=2100000U AS=294000000000P
+ AD=556500000000P PS=2380000U PD=4730000U
* device instance $2247 r0 *1 -49.985,7.33 nfet_01v8
M$2247 105 58 66 223 nfet_01v8 L=150000U W=2100000U AS=556500000000P
+ AD=294000000000P PS=4730000U PD=2380000U
* device instance $2248 r0 *1 -49.555,7.33 nfet_01v8
M$2248 223 54 105 223 nfet_01v8 L=150000U W=2100000U AS=294000000000P
+ AD=556500000000P PS=2380000U PD=4730000U
* device instance $2249 r0 *1 -46.825,-5.715 nfet_01v8
M$2249 58 11 223 223 nfet_01v8 L=150000U W=3100000U AS=627750000000P
+ AD=627750000000P PS=5460000U PD=5460000U
* device instance $2251 r0 *1 -46.825,7.33 nfet_01v8
M$2251 107 57 67 223 nfet_01v8 L=150000U W=2100000U AS=556500000000P
+ AD=294000000000P PS=4730000U PD=2380000U
* device instance $2252 r0 *1 -46.395,7.33 nfet_01v8
M$2252 223 47 107 223 nfet_01v8 L=150000U W=2100000U AS=294000000000P
+ AD=556500000000P PS=2380000U PD=4730000U
* device instance $2253 r0 *1 -45.245,7.33 nfet_01v8
M$2253 109 57 68 223 nfet_01v8 L=150000U W=2100000U AS=556500000000P
+ AD=294000000000P PS=4730000U PD=2380000U
* device instance $2254 r0 *1 -44.815,7.33 nfet_01v8
M$2254 223 48 109 223 nfet_01v8 L=150000U W=2100000U AS=294000000000P
+ AD=556500000000P PS=2380000U PD=4730000U
* device instance $2255 r0 *1 -45.245,-5.715 nfet_01v8
M$2255 57 12 223 223 nfet_01v8 L=150000U W=3100000U AS=627750000000P
+ AD=627750000000P PS=5460000U PD=5460000U
* device instance $2257 r0 *1 -43.665,7.33 nfet_01v8
M$2257 111 57 69 223 nfet_01v8 L=150000U W=2100000U AS=556500000000P
+ AD=294000000000P PS=4730000U PD=2380000U
* device instance $2258 r0 *1 -43.235,7.33 nfet_01v8
M$2258 223 49 111 223 nfet_01v8 L=150000U W=2100000U AS=294000000000P
+ AD=556500000000P PS=2380000U PD=4730000U
* device instance $2259 r0 *1 -43.665,-5.715 nfet_01v8
M$2259 45 13 223 223 nfet_01v8 L=150000U W=3100000U AS=627750000000P
+ AD=627750000000P PS=5460000U PD=5460000U
* device instance $2261 r0 *1 -42.085,7.33 nfet_01v8
M$2261 113 57 70 223 nfet_01v8 L=150000U W=2100000U AS=556500000000P
+ AD=294000000000P PS=4730000U PD=2380000U
* device instance $2262 r0 *1 -41.655,7.33 nfet_01v8
M$2262 223 50 113 223 nfet_01v8 L=150000U W=2100000U AS=294000000000P
+ AD=556500000000P PS=2380000U PD=4730000U
* device instance $2263 r0 *1 -42.085,-5.715 nfet_01v8
M$2263 46 14 223 223 nfet_01v8 L=150000U W=3100000U AS=627750000000P
+ AD=627750000000P PS=5460000U PD=5460000U
* device instance $2265 r0 *1 -38.925,7.33 nfet_01v8
M$2265 115 57 71 223 nfet_01v8 L=150000U W=2100000U AS=556500000000P
+ AD=294000000000P PS=4730000U PD=2380000U
* device instance $2266 r0 *1 -38.495,7.33 nfet_01v8
M$2266 223 51 115 223 nfet_01v8 L=150000U W=2100000U AS=294000000000P
+ AD=556500000000P PS=2380000U PD=4730000U
* device instance $2267 r0 *1 -37.345,7.33 nfet_01v8
M$2267 117 57 72 223 nfet_01v8 L=150000U W=2100000U AS=556500000000P
+ AD=294000000000P PS=4730000U PD=2380000U
* device instance $2268 r0 *1 -36.915,7.33 nfet_01v8
M$2268 223 52 117 223 nfet_01v8 L=150000U W=2100000U AS=294000000000P
+ AD=556500000000P PS=2380000U PD=4730000U
* device instance $2269 r0 *1 -35.765,7.33 nfet_01v8
M$2269 118 57 73 223 nfet_01v8 L=150000U W=2100000U AS=556500000000P
+ AD=294000000000P PS=4730000U PD=2380000U
* device instance $2270 r0 *1 -35.335,7.33 nfet_01v8
M$2270 223 53 118 223 nfet_01v8 L=150000U W=2100000U AS=294000000000P
+ AD=556500000000P PS=2380000U PD=4730000U
* device instance $2271 r0 *1 -34.185,7.33 nfet_01v8
M$2271 120 57 74 223 nfet_01v8 L=150000U W=2100000U AS=556500000000P
+ AD=294000000000P PS=4730000U PD=2380000U
* device instance $2272 r0 *1 -33.755,7.33 nfet_01v8
M$2272 223 54 120 223 nfet_01v8 L=150000U W=2100000U AS=294000000000P
+ AD=556500000000P PS=2380000U PD=4730000U
* device instance $2273 r0 *1 -31.025,7.33 nfet_01v8
M$2273 122 45 75 223 nfet_01v8 L=150000U W=2100000U AS=556500000000P
+ AD=294000000000P PS=4730000U PD=2380000U
* device instance $2274 r0 *1 -30.595,7.33 nfet_01v8
M$2274 223 47 122 223 nfet_01v8 L=150000U W=2100000U AS=294000000000P
+ AD=556500000000P PS=2380000U PD=4730000U
* device instance $2275 r0 *1 -30.235,-4.34 nfet_01v8
M$2275 47 15 223 223 nfet_01v8 L=150000U W=2200000U AS=445500000000P
+ AD=445500000000P PS=4110000U PD=4110000U
* device instance $2277 r0 *1 -29.445,7.33 nfet_01v8
M$2277 123 45 76 223 nfet_01v8 L=150000U W=2100000U AS=556500000000P
+ AD=294000000000P PS=4730000U PD=2380000U
* device instance $2278 r0 *1 -29.015,7.33 nfet_01v8
M$2278 223 48 123 223 nfet_01v8 L=150000U W=2100000U AS=294000000000P
+ AD=556500000000P PS=2380000U PD=4730000U
* device instance $2279 r0 *1 -27.865,7.33 nfet_01v8
M$2279 121 45 77 223 nfet_01v8 L=150000U W=2100000U AS=556500000000P
+ AD=294000000000P PS=4730000U PD=2380000U
* device instance $2280 r0 *1 -27.435,7.33 nfet_01v8
M$2280 223 49 121 223 nfet_01v8 L=150000U W=2100000U AS=294000000000P
+ AD=556500000000P PS=2380000U PD=4730000U
* device instance $2281 r0 *1 -27.075,-4.34 nfet_01v8
M$2281 48 16 223 223 nfet_01v8 L=150000U W=2200000U AS=445500000000P
+ AD=445500000000P PS=4110000U PD=4110000U
* device instance $2283 r0 *1 -26.285,7.33 nfet_01v8
M$2283 119 45 78 223 nfet_01v8 L=150000U W=2100000U AS=556500000000P
+ AD=294000000000P PS=4730000U PD=2380000U
* device instance $2284 r0 *1 -25.855,7.33 nfet_01v8
M$2284 223 50 119 223 nfet_01v8 L=150000U W=2100000U AS=294000000000P
+ AD=556500000000P PS=2380000U PD=4730000U
* device instance $2285 r0 *1 -23.125,7.33 nfet_01v8
M$2285 116 45 79 223 nfet_01v8 L=150000U W=2100000U AS=556500000000P
+ AD=294000000000P PS=4730000U PD=2380000U
* device instance $2286 r0 *1 -22.695,7.33 nfet_01v8
M$2286 223 51 116 223 nfet_01v8 L=150000U W=2100000U AS=294000000000P
+ AD=556500000000P PS=2380000U PD=4730000U
* device instance $2287 r0 *1 -22.335,-4.34 nfet_01v8
M$2287 49 17 223 223 nfet_01v8 L=150000U W=2200000U AS=445500000000P
+ AD=445500000000P PS=4110000U PD=4110000U
* device instance $2289 r0 *1 -21.545,7.33 nfet_01v8
M$2289 114 45 80 223 nfet_01v8 L=150000U W=2100000U AS=556500000000P
+ AD=294000000000P PS=4730000U PD=2380000U
* device instance $2290 r0 *1 -21.115,7.33 nfet_01v8
M$2290 223 52 114 223 nfet_01v8 L=150000U W=2100000U AS=294000000000P
+ AD=556500000000P PS=2380000U PD=4730000U
* device instance $2291 r0 *1 -19.965,7.33 nfet_01v8
M$2291 112 45 81 223 nfet_01v8 L=150000U W=2100000U AS=556500000000P
+ AD=294000000000P PS=4730000U PD=2380000U
* device instance $2292 r0 *1 -19.535,7.33 nfet_01v8
M$2292 223 53 112 223 nfet_01v8 L=150000U W=2100000U AS=294000000000P
+ AD=556500000000P PS=2380000U PD=4730000U
* device instance $2293 r0 *1 -19.175,-4.34 nfet_01v8
M$2293 50 18 223 223 nfet_01v8 L=150000U W=2200000U AS=445500000000P
+ AD=445500000000P PS=4110000U PD=4110000U
* device instance $2295 r0 *1 -18.385,7.33 nfet_01v8
M$2295 110 45 82 223 nfet_01v8 L=150000U W=2100000U AS=556500000000P
+ AD=294000000000P PS=4730000U PD=2380000U
* device instance $2296 r0 *1 -17.955,7.33 nfet_01v8
M$2296 223 54 110 223 nfet_01v8 L=150000U W=2100000U AS=294000000000P
+ AD=556500000000P PS=2380000U PD=4730000U
* device instance $2297 r0 *1 -15.225,7.33 nfet_01v8
M$2297 108 46 83 223 nfet_01v8 L=150000U W=2100000U AS=556500000000P
+ AD=294000000000P PS=4730000U PD=2380000U
* device instance $2298 r0 *1 -14.795,7.33 nfet_01v8
M$2298 223 47 108 223 nfet_01v8 L=150000U W=2100000U AS=294000000000P
+ AD=556500000000P PS=2380000U PD=4730000U
* device instance $2299 r0 *1 -14.435,-4.34 nfet_01v8
M$2299 51 19 223 223 nfet_01v8 L=150000U W=2200000U AS=445500000000P
+ AD=445500000000P PS=4110000U PD=4110000U
* device instance $2301 r0 *1 -13.645,7.33 nfet_01v8
M$2301 106 46 84 223 nfet_01v8 L=150000U W=2100000U AS=556500000000P
+ AD=294000000000P PS=4730000U PD=2380000U
* device instance $2302 r0 *1 -13.215,7.33 nfet_01v8
M$2302 223 48 106 223 nfet_01v8 L=150000U W=2100000U AS=294000000000P
+ AD=556500000000P PS=2380000U PD=4730000U
* device instance $2303 r0 *1 -12.065,7.33 nfet_01v8
M$2303 104 46 85 223 nfet_01v8 L=150000U W=2100000U AS=556500000000P
+ AD=294000000000P PS=4730000U PD=2380000U
* device instance $2304 r0 *1 -11.635,7.33 nfet_01v8
M$2304 223 49 104 223 nfet_01v8 L=150000U W=2100000U AS=294000000000P
+ AD=556500000000P PS=2380000U PD=4730000U
* device instance $2305 r0 *1 -11.275,-4.34 nfet_01v8
M$2305 52 20 223 223 nfet_01v8 L=150000U W=2200000U AS=445500000000P
+ AD=445500000000P PS=4110000U PD=4110000U
* device instance $2307 r0 *1 -10.485,7.33 nfet_01v8
M$2307 102 46 86 223 nfet_01v8 L=150000U W=2100000U AS=556500000000P
+ AD=294000000000P PS=4730000U PD=2380000U
* device instance $2308 r0 *1 -10.055,7.33 nfet_01v8
M$2308 223 50 102 223 nfet_01v8 L=150000U W=2100000U AS=294000000000P
+ AD=556500000000P PS=2380000U PD=4730000U
* device instance $2309 r0 *1 -7.325,7.33 nfet_01v8
M$2309 99 46 87 223 nfet_01v8 L=150000U W=2100000U AS=556500000000P
+ AD=294000000000P PS=4730000U PD=2380000U
* device instance $2310 r0 *1 -6.895,7.33 nfet_01v8
M$2310 223 51 99 223 nfet_01v8 L=150000U W=2100000U AS=294000000000P
+ AD=556500000000P PS=2380000U PD=4730000U
* device instance $2311 r0 *1 -6.535,-4.34 nfet_01v8
M$2311 53 21 223 223 nfet_01v8 L=150000U W=2200000U AS=445500000000P
+ AD=445500000000P PS=4110000U PD=4110000U
* device instance $2313 r0 *1 -5.745,7.33 nfet_01v8
M$2313 97 46 88 223 nfet_01v8 L=150000U W=2100000U AS=556500000000P
+ AD=294000000000P PS=4730000U PD=2380000U
* device instance $2314 r0 *1 -5.315,7.33 nfet_01v8
M$2314 223 52 97 223 nfet_01v8 L=150000U W=2100000U AS=294000000000P
+ AD=556500000000P PS=2380000U PD=4730000U
* device instance $2315 r0 *1 -4.165,7.33 nfet_01v8
M$2315 95 46 89 223 nfet_01v8 L=150000U W=2100000U AS=556500000000P
+ AD=294000000000P PS=4730000U PD=2380000U
* device instance $2316 r0 *1 -3.735,7.33 nfet_01v8
M$2316 223 53 95 223 nfet_01v8 L=150000U W=2100000U AS=294000000000P
+ AD=556500000000P PS=2380000U PD=4730000U
* device instance $2317 r0 *1 -3.375,-4.34 nfet_01v8
M$2317 54 22 223 223 nfet_01v8 L=150000U W=2200000U AS=445500000000P
+ AD=445500000000P PS=4110000U PD=4110000U
* device instance $2319 r0 *1 -2.585,7.33 nfet_01v8
M$2319 93 46 90 223 nfet_01v8 L=150000U W=2100000U AS=556500000000P
+ AD=294000000000P PS=4730000U PD=2380000U
* device instance $2320 r0 *1 -2.155,7.33 nfet_01v8
M$2320 223 54 93 223 nfet_01v8 L=150000U W=2100000U AS=294000000000P
+ AD=556500000000P PS=2380000U PD=4730000U
* device instance $2321 r0 *1 -62.625,13.145 nfet_01v8
M$2321 124 59 223 223 nfet_01v8 L=150000U W=2300000U AS=465750000000P
+ AD=465750000000P PS=4260000U PD=4260000U
* device instance $2323 r0 *1 -61.045,13.145 nfet_01v8
M$2323 125 60 223 223 nfet_01v8 L=150000U W=2300000U AS=465750000000P
+ AD=465750000000P PS=4260000U PD=4260000U
* device instance $2325 r0 *1 -59.465,13.145 nfet_01v8
M$2325 126 61 223 223 nfet_01v8 L=150000U W=2300000U AS=465750000000P
+ AD=465750000000P PS=4260000U PD=4260000U
* device instance $2327 r0 *1 -57.885,13.145 nfet_01v8
M$2327 127 62 223 223 nfet_01v8 L=150000U W=2300000U AS=465750000000P
+ AD=465750000000P PS=4260000U PD=4260000U
* device instance $2329 r0 *1 -54.725,13.145 nfet_01v8
M$2329 128 63 223 223 nfet_01v8 L=150000U W=2300000U AS=465750000000P
+ AD=465750000000P PS=4260000U PD=4260000U
* device instance $2331 r0 *1 -53.145,13.145 nfet_01v8
M$2331 129 64 223 223 nfet_01v8 L=150000U W=2300000U AS=465750000000P
+ AD=465750000000P PS=4260000U PD=4260000U
* device instance $2333 r0 *1 -51.565,13.145 nfet_01v8
M$2333 130 65 223 223 nfet_01v8 L=150000U W=2300000U AS=465750000000P
+ AD=465750000000P PS=4260000U PD=4260000U
* device instance $2335 r0 *1 -49.985,13.145 nfet_01v8
M$2335 131 66 223 223 nfet_01v8 L=150000U W=2300000U AS=465750000000P
+ AD=465750000000P PS=4260000U PD=4260000U
* device instance $2337 r0 *1 -46.825,13.145 nfet_01v8
M$2337 132 67 223 223 nfet_01v8 L=150000U W=2300000U AS=465750000000P
+ AD=465750000000P PS=4260000U PD=4260000U
* device instance $2339 r0 *1 -45.245,13.145 nfet_01v8
M$2339 133 68 223 223 nfet_01v8 L=150000U W=2300000U AS=465750000000P
+ AD=465750000000P PS=4260000U PD=4260000U
* device instance $2341 r0 *1 -43.665,13.145 nfet_01v8
M$2341 134 69 223 223 nfet_01v8 L=150000U W=2300000U AS=465750000000P
+ AD=465750000000P PS=4260000U PD=4260000U
* device instance $2343 r0 *1 -42.085,13.145 nfet_01v8
M$2343 135 70 223 223 nfet_01v8 L=150000U W=2300000U AS=465750000000P
+ AD=465750000000P PS=4260000U PD=4260000U
* device instance $2345 r0 *1 -38.925,13.145 nfet_01v8
M$2345 136 71 223 223 nfet_01v8 L=150000U W=2300000U AS=465750000000P
+ AD=465750000000P PS=4260000U PD=4260000U
* device instance $2347 r0 *1 -37.345,13.145 nfet_01v8
M$2347 137 72 223 223 nfet_01v8 L=150000U W=2300000U AS=465750000000P
+ AD=465750000000P PS=4260000U PD=4260000U
* device instance $2349 r0 *1 -35.765,13.145 nfet_01v8
M$2349 138 73 223 223 nfet_01v8 L=150000U W=2300000U AS=465750000000P
+ AD=465750000000P PS=4260000U PD=4260000U
* device instance $2351 r0 *1 -34.185,13.145 nfet_01v8
M$2351 139 74 223 223 nfet_01v8 L=150000U W=2300000U AS=465750000000P
+ AD=465750000000P PS=4260000U PD=4260000U
* device instance $2353 r0 *1 -31.025,13.145 nfet_01v8
M$2353 140 75 223 223 nfet_01v8 L=150000U W=2300000U AS=465750000000P
+ AD=465750000000P PS=4260000U PD=4260000U
* device instance $2355 r0 *1 -29.445,13.145 nfet_01v8
M$2355 141 76 223 223 nfet_01v8 L=150000U W=2300000U AS=465750000000P
+ AD=465750000000P PS=4260000U PD=4260000U
* device instance $2357 r0 *1 -27.865,13.145 nfet_01v8
M$2357 142 77 223 223 nfet_01v8 L=150000U W=2300000U AS=465750000000P
+ AD=465750000000P PS=4260000U PD=4260000U
* device instance $2359 r0 *1 -26.285,13.145 nfet_01v8
M$2359 143 78 223 223 nfet_01v8 L=150000U W=2300000U AS=465750000000P
+ AD=465750000000P PS=4260000U PD=4260000U
* device instance $2361 r0 *1 -23.125,13.145 nfet_01v8
M$2361 144 79 223 223 nfet_01v8 L=150000U W=2300000U AS=465750000000P
+ AD=465750000000P PS=4260000U PD=4260000U
* device instance $2363 r0 *1 -21.545,13.145 nfet_01v8
M$2363 145 80 223 223 nfet_01v8 L=150000U W=2300000U AS=465750000000P
+ AD=465750000000P PS=4260000U PD=4260000U
* device instance $2365 r0 *1 -19.965,13.145 nfet_01v8
M$2365 146 81 223 223 nfet_01v8 L=150000U W=2300000U AS=465750000000P
+ AD=465750000000P PS=4260000U PD=4260000U
* device instance $2367 r0 *1 -18.385,13.145 nfet_01v8
M$2367 147 82 223 223 nfet_01v8 L=150000U W=2300000U AS=465750000000P
+ AD=465750000000P PS=4260000U PD=4260000U
* device instance $2369 r0 *1 -15.225,13.145 nfet_01v8
M$2369 148 83 223 223 nfet_01v8 L=150000U W=2300000U AS=465750000000P
+ AD=465750000000P PS=4260000U PD=4260000U
* device instance $2371 r0 *1 -13.645,13.145 nfet_01v8
M$2371 149 84 223 223 nfet_01v8 L=150000U W=2300000U AS=465750000000P
+ AD=465750000000P PS=4260000U PD=4260000U
* device instance $2373 r0 *1 -12.065,13.145 nfet_01v8
M$2373 150 85 223 223 nfet_01v8 L=150000U W=2300000U AS=465750000000P
+ AD=465750000000P PS=4260000U PD=4260000U
* device instance $2375 r0 *1 -10.485,13.145 nfet_01v8
M$2375 151 86 223 223 nfet_01v8 L=150000U W=2300000U AS=465750000000P
+ AD=465750000000P PS=4260000U PD=4260000U
* device instance $2377 r0 *1 -7.325,13.145 nfet_01v8
M$2377 152 87 223 223 nfet_01v8 L=150000U W=2300000U AS=465750000000P
+ AD=465750000000P PS=4260000U PD=4260000U
* device instance $2379 r0 *1 -5.745,13.145 nfet_01v8
M$2379 153 88 223 223 nfet_01v8 L=150000U W=2300000U AS=465750000000P
+ AD=465750000000P PS=4260000U PD=4260000U
* device instance $2381 r0 *1 -4.165,13.145 nfet_01v8
M$2381 154 89 223 223 nfet_01v8 L=150000U W=2300000U AS=465750000000P
+ AD=465750000000P PS=4260000U PD=4260000U
* device instance $2383 r0 *1 -2.585,13.145 nfet_01v8
M$2383 155 90 223 223 nfet_01v8 L=150000U W=2300000U AS=465750000000P
+ AD=465750000000P PS=4260000U PD=4260000U
* device instance $2385 r0 *1 -62.59,18.285 nfet_01v8
M$2385 157 124 223 223 nfet_01v8 L=150000U W=5600000U AS=871500000000P
+ AD=871500000000P PS=8790000U PD=8790000U
* device instance $2393 r0 *1 -61.01,18.285 nfet_01v8
M$2393 158 125 223 223 nfet_01v8 L=150000U W=5600000U AS=871500000000P
+ AD=871500000000P PS=8790000U PD=8790000U
* device instance $2401 r0 *1 -59.43,18.285 nfet_01v8
M$2401 159 126 223 223 nfet_01v8 L=150000U W=5600000U AS=871500000000P
+ AD=871500000000P PS=8790000U PD=8790000U
* device instance $2409 r0 *1 -57.85,18.285 nfet_01v8
M$2409 160 127 223 223 nfet_01v8 L=150000U W=5600000U AS=871500000000P
+ AD=871500000000P PS=8790000U PD=8790000U
* device instance $2417 r0 *1 -54.69,18.285 nfet_01v8
M$2417 161 128 223 223 nfet_01v8 L=150000U W=5600000U AS=871500000000P
+ AD=871500000000P PS=8790000U PD=8790000U
* device instance $2425 r0 *1 -53.11,18.285 nfet_01v8
M$2425 162 129 223 223 nfet_01v8 L=150000U W=5600000U AS=871500000000P
+ AD=871500000000P PS=8790000U PD=8790000U
* device instance $2433 r0 *1 -51.53,18.285 nfet_01v8
M$2433 163 130 223 223 nfet_01v8 L=150000U W=5600000U AS=871500000000P
+ AD=871500000000P PS=8790000U PD=8790000U
* device instance $2441 r0 *1 -49.95,18.285 nfet_01v8
M$2441 164 131 223 223 nfet_01v8 L=150000U W=5600000U AS=871500000000P
+ AD=871500000000P PS=8790000U PD=8790000U
* device instance $2449 r0 *1 -46.79,18.285 nfet_01v8
M$2449 165 132 223 223 nfet_01v8 L=150000U W=5600000U AS=871500000000P
+ AD=871500000000P PS=8790000U PD=8790000U
* device instance $2457 r0 *1 -45.21,18.285 nfet_01v8
M$2457 166 133 223 223 nfet_01v8 L=150000U W=5600000U AS=871500000000P
+ AD=871500000000P PS=8790000U PD=8790000U
* device instance $2465 r0 *1 -43.63,18.285 nfet_01v8
M$2465 167 134 223 223 nfet_01v8 L=150000U W=5600000U AS=871500000000P
+ AD=871500000000P PS=8790000U PD=8790000U
* device instance $2473 r0 *1 -42.05,18.285 nfet_01v8
M$2473 168 135 223 223 nfet_01v8 L=150000U W=5600000U AS=871500000000P
+ AD=871500000000P PS=8790000U PD=8790000U
* device instance $2481 r0 *1 -38.89,18.285 nfet_01v8
M$2481 169 136 223 223 nfet_01v8 L=150000U W=5600000U AS=871500000000P
+ AD=871500000000P PS=8790000U PD=8790000U
* device instance $2489 r0 *1 -37.31,18.285 nfet_01v8
M$2489 170 137 223 223 nfet_01v8 L=150000U W=5600000U AS=871500000000P
+ AD=871500000000P PS=8790000U PD=8790000U
* device instance $2497 r0 *1 -35.73,18.285 nfet_01v8
M$2497 171 138 223 223 nfet_01v8 L=150000U W=5600000U AS=871500000000P
+ AD=871500000000P PS=8790000U PD=8790000U
* device instance $2505 r0 *1 -34.15,18.285 nfet_01v8
M$2505 172 139 223 223 nfet_01v8 L=150000U W=5600000U AS=871500000000P
+ AD=871500000000P PS=8790000U PD=8790000U
* device instance $2513 r0 *1 -30.99,18.285 nfet_01v8
M$2513 173 140 223 223 nfet_01v8 L=150000U W=5600000U AS=871500000000P
+ AD=871500000000P PS=8790000U PD=8790000U
* device instance $2521 r0 *1 -29.41,18.285 nfet_01v8
M$2521 174 141 223 223 nfet_01v8 L=150000U W=5600000U AS=871500000000P
+ AD=871500000000P PS=8790000U PD=8790000U
* device instance $2529 r0 *1 -27.83,18.285 nfet_01v8
M$2529 175 142 223 223 nfet_01v8 L=150000U W=5600000U AS=871500000000P
+ AD=871500000000P PS=8790000U PD=8790000U
* device instance $2537 r0 *1 -26.25,18.285 nfet_01v8
M$2537 176 143 223 223 nfet_01v8 L=150000U W=5600000U AS=871500000000P
+ AD=871500000000P PS=8790000U PD=8790000U
* device instance $2545 r0 *1 -23.09,18.285 nfet_01v8
M$2545 177 144 223 223 nfet_01v8 L=150000U W=5600000U AS=871500000000P
+ AD=871500000000P PS=8790000U PD=8790000U
* device instance $2553 r0 *1 -21.51,18.285 nfet_01v8
M$2553 178 145 223 223 nfet_01v8 L=150000U W=5600000U AS=871500000000P
+ AD=871500000000P PS=8790000U PD=8790000U
* device instance $2561 r0 *1 -19.93,18.285 nfet_01v8
M$2561 179 146 223 223 nfet_01v8 L=150000U W=5600000U AS=871500000000P
+ AD=871500000000P PS=8790000U PD=8790000U
* device instance $2569 r0 *1 -18.35,18.285 nfet_01v8
M$2569 180 147 223 223 nfet_01v8 L=150000U W=5600000U AS=871500000000P
+ AD=871500000000P PS=8790000U PD=8790000U
* device instance $2577 r0 *1 -15.19,18.285 nfet_01v8
M$2577 181 148 223 223 nfet_01v8 L=150000U W=5600000U AS=871500000000P
+ AD=871500000000P PS=8790000U PD=8790000U
* device instance $2585 r0 *1 -13.61,18.285 nfet_01v8
M$2585 182 149 223 223 nfet_01v8 L=150000U W=5600000U AS=871500000000P
+ AD=871500000000P PS=8790000U PD=8790000U
* device instance $2593 r0 *1 -12.03,18.285 nfet_01v8
M$2593 183 150 223 223 nfet_01v8 L=150000U W=5600000U AS=871500000000P
+ AD=871500000000P PS=8790000U PD=8790000U
* device instance $2601 r0 *1 -10.45,18.285 nfet_01v8
M$2601 184 151 223 223 nfet_01v8 L=150000U W=5600000U AS=871500000000P
+ AD=871500000000P PS=8790000U PD=8790000U
* device instance $2609 r0 *1 -7.29,18.285 nfet_01v8
M$2609 185 152 223 223 nfet_01v8 L=150000U W=5600000U AS=871500000000P
+ AD=871500000000P PS=8790000U PD=8790000U
* device instance $2617 r0 *1 -5.71,18.285 nfet_01v8
M$2617 186 153 223 223 nfet_01v8 L=150000U W=5600000U AS=871500000000P
+ AD=871500000000P PS=8790000U PD=8790000U
* device instance $2625 r0 *1 -4.13,18.285 nfet_01v8
M$2625 187 154 223 223 nfet_01v8 L=150000U W=5600000U AS=871500000000P
+ AD=871500000000P PS=8790000U PD=8790000U
* device instance $2633 r0 *1 -2.55,18.285 nfet_01v8
M$2633 188 155 223 223 nfet_01v8 L=150000U W=5600000U AS=871500000000P
+ AD=871500000000P PS=8790000U PD=8790000U
* device instance $2641 r0 *1 -62.59,31.925 nfet_01v8
M$2641 223 157 190 223 nfet_01v8 L=150000U W=11900000U AS=1.7535e+12P
+ AD=1.7535e+12P PS=17610000U PD=17610000U
* device instance $2658 r0 *1 -61.01,31.925 nfet_01v8
M$2658 223 158 191 223 nfet_01v8 L=150000U W=11900000U AS=1.7535e+12P
+ AD=1.7535e+12P PS=17610000U PD=17610000U
* device instance $2675 r0 *1 -59.43,31.925 nfet_01v8
M$2675 223 159 192 223 nfet_01v8 L=150000U W=11900000U AS=1.7535e+12P
+ AD=1.7535e+12P PS=17610000U PD=17610000U
* device instance $2692 r0 *1 -57.85,31.925 nfet_01v8
M$2692 223 160 193 223 nfet_01v8 L=150000U W=11900000U AS=1.7535e+12P
+ AD=1.7535e+12P PS=17610000U PD=17610000U
* device instance $2709 r0 *1 -54.69,31.925 nfet_01v8
M$2709 223 161 194 223 nfet_01v8 L=150000U W=11900000U AS=1.7535e+12P
+ AD=1.7535e+12P PS=17610000U PD=17610000U
* device instance $2726 r0 *1 -53.11,31.925 nfet_01v8
M$2726 223 162 195 223 nfet_01v8 L=150000U W=11900000U AS=1.7535e+12P
+ AD=1.7535e+12P PS=17610000U PD=17610000U
* device instance $2743 r0 *1 -51.53,31.925 nfet_01v8
M$2743 223 163 196 223 nfet_01v8 L=150000U W=11900000U AS=1.7535e+12P
+ AD=1.7535e+12P PS=17610000U PD=17610000U
* device instance $2760 r0 *1 -49.95,31.925 nfet_01v8
M$2760 223 164 197 223 nfet_01v8 L=150000U W=11900000U AS=1.7535e+12P
+ AD=1.7535e+12P PS=17610000U PD=17610000U
* device instance $2777 r0 *1 -45.21,31.925 nfet_01v8
M$2777 223 166 199 223 nfet_01v8 L=150000U W=11900000U AS=1.7535e+12P
+ AD=1.7535e+12P PS=17610000U PD=17610000U
* device instance $2794 r0 *1 -43.63,31.925 nfet_01v8
M$2794 223 167 200 223 nfet_01v8 L=150000U W=11900000U AS=1.7535e+12P
+ AD=1.7535e+12P PS=17610000U PD=17610000U
* device instance $2811 r0 *1 -42.05,31.925 nfet_01v8
M$2811 223 168 201 223 nfet_01v8 L=150000U W=11900000U AS=1.7535e+12P
+ AD=1.7535e+12P PS=17610000U PD=17610000U
* device instance $2828 r0 *1 -38.89,31.925 nfet_01v8
M$2828 223 169 202 223 nfet_01v8 L=150000U W=11900000U AS=1.7535e+12P
+ AD=1.7535e+12P PS=17610000U PD=17610000U
* device instance $2845 r0 *1 -37.31,31.925 nfet_01v8
M$2845 223 170 203 223 nfet_01v8 L=150000U W=11900000U AS=1.7535e+12P
+ AD=1.7535e+12P PS=17610000U PD=17610000U
* device instance $2862 r0 *1 -34.15,31.925 nfet_01v8
M$2862 223 172 205 223 nfet_01v8 L=150000U W=11900000U AS=1.7535e+12P
+ AD=1.7535e+12P PS=17610000U PD=17610000U
* device instance $2879 r0 *1 -30.99,31.925 nfet_01v8
M$2879 223 173 206 223 nfet_01v8 L=150000U W=11900000U AS=1.7535e+12P
+ AD=1.7535e+12P PS=17610000U PD=17610000U
* device instance $2896 r0 *1 -29.41,31.925 nfet_01v8
M$2896 223 174 207 223 nfet_01v8 L=150000U W=11900000U AS=1.7535e+12P
+ AD=1.7535e+12P PS=17610000U PD=17610000U
* device instance $2913 r0 *1 -27.83,31.925 nfet_01v8
M$2913 223 175 208 223 nfet_01v8 L=150000U W=11900000U AS=1.7535e+12P
+ AD=1.7535e+12P PS=17610000U PD=17610000U
* device instance $2930 r0 *1 -26.25,31.925 nfet_01v8
M$2930 223 176 209 223 nfet_01v8 L=150000U W=11900000U AS=1.7535e+12P
+ AD=1.7535e+12P PS=17610000U PD=17610000U
* device instance $2947 r0 *1 -23.09,31.925 nfet_01v8
M$2947 223 177 210 223 nfet_01v8 L=150000U W=11900000U AS=1.7535e+12P
+ AD=1.7535e+12P PS=17610000U PD=17610000U
* device instance $2964 r0 *1 -21.51,31.925 nfet_01v8
M$2964 223 178 211 223 nfet_01v8 L=150000U W=11900000U AS=1.7535e+12P
+ AD=1.7535e+12P PS=17610000U PD=17610000U
* device instance $2981 r0 *1 -19.93,31.925 nfet_01v8
M$2981 223 179 212 223 nfet_01v8 L=150000U W=11900000U AS=1.7535e+12P
+ AD=1.7535e+12P PS=17610000U PD=17610000U
* device instance $2998 r0 *1 -18.35,31.925 nfet_01v8
M$2998 223 180 213 223 nfet_01v8 L=150000U W=11900000U AS=1.7535e+12P
+ AD=1.7535e+12P PS=17610000U PD=17610000U
* device instance $3015 r0 *1 -15.19,31.925 nfet_01v8
M$3015 223 181 214 223 nfet_01v8 L=150000U W=11900000U AS=1.7535e+12P
+ AD=1.7535e+12P PS=17610000U PD=17610000U
* device instance $3032 r0 *1 -13.61,31.925 nfet_01v8
M$3032 223 182 215 223 nfet_01v8 L=150000U W=11900000U AS=1.7535e+12P
+ AD=1.7535e+12P PS=17610000U PD=17610000U
* device instance $3049 r0 *1 -12.03,31.925 nfet_01v8
M$3049 223 183 216 223 nfet_01v8 L=150000U W=11900000U AS=1.7535e+12P
+ AD=1.7535e+12P PS=17610000U PD=17610000U
* device instance $3066 r0 *1 -7.29,31.925 nfet_01v8
M$3066 223 185 218 223 nfet_01v8 L=150000U W=11900000U AS=1.7535e+12P
+ AD=1.7535e+12P PS=17610000U PD=17610000U
* device instance $3083 r0 *1 -5.71,31.925 nfet_01v8
M$3083 223 186 219 223 nfet_01v8 L=150000U W=11900000U AS=1.7535e+12P
+ AD=1.7535e+12P PS=17610000U PD=17610000U
* device instance $3100 r0 *1 -2.55,31.925 nfet_01v8
M$3100 223 188 221 223 nfet_01v8 L=150000U W=11900000U AS=1.7535e+12P
+ AD=1.7535e+12P PS=17610000U PD=17610000U
* device instance $3117 r0 *1 -46.79,31.925 nfet_01v8
M$3117 223 165 198 223 nfet_01v8 L=150000U W=11900000U AS=1.7535e+12P
+ AD=1.7535e+12P PS=17610000U PD=17610000U
* device instance $3134 r0 *1 -35.73,31.925 nfet_01v8
M$3134 223 171 204 223 nfet_01v8 L=150000U W=11900000U AS=1.7535e+12P
+ AD=1.7535e+12P PS=17610000U PD=17610000U
* device instance $3151 r0 *1 -10.45,31.925 nfet_01v8
M$3151 223 184 217 223 nfet_01v8 L=150000U W=11900000U AS=1.7535e+12P
+ AD=1.7535e+12P PS=17610000U PD=17610000U
* device instance $3168 r0 *1 -4.13,31.925 nfet_01v8
M$3168 223 187 220 223 nfet_01v8 L=150000U W=11900000U AS=1.7535e+12P
+ AD=1.7535e+12P PS=17610000U PD=17610000U
.ENDS decoder_1

* cell column_mos
* pin vss
* pin vdd
* pin bl
* pin vss
* pin
* pin VNB
.SUBCKT column_mos 1 2 3 4 5 6
* net 1 vss
* net 2 vdd
* net 3 bl
* net 4 vss
* net 6 VNB
* device instance $1 r270 *1 0.6,5.875 pfet_01v8
M$1 3 2 2 5 pfet_01v8 L=150000U W=3050000U AS=808250000000P AD=808250000000P
+ PS=6630000U PD=6630000U
* device instance $2 r270 *1 0.6,2.345 nfet_01v8
M$2 3 1 1 6 nfet_01v8 L=150000U W=2150000U AS=569750000000P AD=569750000000P
+ PS=4830000U PD=4830000U
* device instance $3 r90 *1 0.6,0.4 nfet_01v8
M$3 4 3 4 6 nfet_01v8 L=150000U W=800000U AS=212000000000P AD=212000000000P
+ PS=2130000U PD=2130000U
.ENDS column_mos

* cell inv_chain_2
* pin dout
* pin din
* pin vss
* pin vdd
* pin VNB
* pin
.SUBCKT inv_chain_2 1 2 3 4 6 7
* net 1 dout
* net 2 din
* net 3 vss
* net 4 vdd
* net 6 VNB
* cell instance $1 r0 *1 1.44,-3.33
X$1 7 5 4 3 1 6 sky130_fd_sc_hs__inv_4
* cell instance $2 r0 *1 0,-3.33
X$2 7 2 4 5 3 6 sky130_fd_sc_hs__inv_2
.ENDS inv_chain_2

* cell inv_chain_3
* pin din
* pin dout
* pin vss
* pin vdd
* pin VNB
* pin
.SUBCKT inv_chain_3 1 2 3 4 7 8
* net 1 din
* net 2 dout
* net 3 vss
* net 4 vdd
* net 7 VNB
* cell instance $1 r0 *1 0,-3.33
X$1 8 1 4 5 3 7 sky130_fd_sc_hs__inv_2
* cell instance $2 r0 *1 2.88,-3.33
X$2 8 6 4 3 2 7 sky130_fd_sc_hs__inv_4
* cell instance $3 r0 *1 1.44,-3.33
X$3 8 5 4 6 3 7 sky130_fd_sc_hs__inv_2
.ENDS inv_chain_3

* cell sky130_fd_sc_hs__mux2_4
* pin vgnd
* pin x
* pin s
* pin a0
* pin a1
* pin vpb
* pin vpwr
* pin vnb
.SUBCKT sky130_fd_sc_hs__mux2_4 1 4 7 8 9 11 12 14
* net 1 vgnd
* net 4 x
* net 7 s
* net 8 a0
* net 9 a1
* net 11 vpb
* net 12 vpwr
* net 14 vnb
* device instance $1 r0 *1 0.505,2.34 pfet_01v8
M$1 12 7 3 11 pfet_01v8 L=150000U W=1000000U AS=295000000000P AD=218600000000P
+ PS=2590000U PD=1520000U
* device instance $2 r0 *1 3.535,2.455 pfet_01v8
M$2 13 7 12 11 pfet_01v8 L=150000U W=2000000U AS=428012500000P AD=403850000000P
+ PS=3075000U PD=2900000U
* device instance $4 r0 *1 4.605,2.455 pfet_01v8
M$4 10 3 12 11 pfet_01v8 L=150000U W=2000000U AS=403850000000P AD=567700000000P
+ PS=2900000U PD=4320000U
* device instance $6 r0 *1 1.055,2.4 pfet_01v8
M$6 12 2 4 11 pfet_01v8 L=150000U W=4480000U AS=1.13255e+12P AD=1.0766625e+12P
+ PS=6910000U PD=6845000U
* device instance $10 r0 *1 6.725,2.46 pfet_01v8
M$10 13 8 2 11 pfet_01v8 L=150000U W=2000000U AS=480000000000P AD=305000000000P
+ PS=3960000U PD=2610000U
* device instance $12 r0 *1 7.635,2.46 pfet_01v8
M$12 10 9 2 11 pfet_01v8 L=150000U W=2000000U AS=305000000000P AD=495000000000P
+ PS=2610000U PD=3990000U
* device instance $14 r0 *1 6.71,0.69 nfet_01v8_lvt
M$14 6 8 2 14 nfet_01v8_lvt L=150000U W=1280000U AS=595200000000P
+ AD=201600000000P PS=3780000U PD=1910000U
* device instance $16 r0 *1 7.64,0.69 nfet_01v8_lvt
M$16 5 9 2 14 nfet_01v8_lvt L=150000U W=1280000U AS=204800000000P
+ AD=310400000000P PS=1920000U PD=2890000U
* device instance $18 r0 *1 0.65,0.81 nfet_01v8_lvt
M$18 3 7 1 14 nfet_01v8_lvt L=150000U W=640000U AS=146900000000P
+ AD=182400000000P PS=1160000U PD=1850000U
* device instance $19 r0 *1 1.22,0.76 nfet_01v8_lvt
M$19 4 2 1 14 nfet_01v8_lvt L=150000U W=2960000U AS=531700000000P
+ AD=617725000000P PS=4420000U PD=4715000U
* device instance $23 r0 *1 3.47,0.915 nfet_01v8_lvt
M$23 5 7 1 14 nfet_01v8_lvt L=150000U W=1280000U AS=344925000000P
+ AD=268800000000P PS=2445000U PD=2120000U
* device instance $25 r0 *1 4.61,0.915 nfet_01v8_lvt
M$25 6 3 1 14 nfet_01v8_lvt L=150000U W=1280000U AS=526000000000P
+ AD=179200000000P PS=3770000U PD=1840000U
.ENDS sky130_fd_sc_hs__mux2_4

* cell sky130_fd_sc_hs__and2_2
* pin vpb
* pin b
* pin a
* pin vpwr
* pin vgnd
* pin x
* pin vnb
.SUBCKT sky130_fd_sc_hs__and2_2 1 2 3 4 5 7 9
* net 1 vpb
* net 2 b
* net 3 a
* net 4 vpwr
* net 5 vgnd
* net 7 x
* net 9 vnb
* device instance $1 r0 *1 0.5,2.46 pfet_01v8
M$1 6 3 4 1 pfet_01v8 L=150000U W=1000000U AS=290000000000P AD=150000000000P
+ PS=2580000U PD=1300000U
* device instance $2 r0 *1 0.95,2.46 pfet_01v8
M$2 6 2 4 1 pfet_01v8 L=150000U W=1000000U AS=193400000000P AD=150000000000P
+ PS=1475000U PD=1300000U
* device instance $3 r0 *1 1.455,2.4 pfet_01v8
M$3 7 6 4 1 pfet_01v8 L=150000U W=2240000U AS=361400000000P AD=487200000000P
+ PS=2895000U PD=4230000U
* device instance $5 r0 *1 0.515,0.74 nfet_01v8_lvt
M$5 8 3 6 9 nfet_01v8_lvt L=150000U W=740000U AS=210900000000P AD=88800000000P
+ PS=2050000U PD=980000U
* device instance $6 r0 *1 0.905,0.74 nfet_01v8_lvt
M$6 5 2 8 9 nfet_01v8_lvt L=150000U W=740000U AS=88800000000P AD=133200000000P
+ PS=980000U PD=1100000U
* device instance $7 r0 *1 1.415,0.74 nfet_01v8_lvt
M$7 7 6 5 9 nfet_01v8_lvt L=150000U W=1480000U AS=236800000000P
+ AD=358900000000P PS=2120000U PD=3190000U
.ENDS sky130_fd_sc_hs__and2_2

* cell svt_inv_chain_22
* pin din
* pin dout
* pin vdd
* pin vss
.SUBCKT svt_inv_chain_22 1 2 3 25
* net 1 din
* net 2 dout
* net 3 vdd
* net 25 vss
* cell instance $1 r0 *1 0,-3.33
X$1 3 1 3 4 25 25 sramgen_svt_inv_2
* cell instance $2 r0 *1 33.12,-3.33
X$2 3 24 3 25 2 25 sramgen_svt_inv_4
* cell instance $3 r0 *1 1.44,-3.33
X$3 3 4 3 5 25 25 sramgen_svt_inv_2
* cell instance $4 r0 *1 2.88,-3.33
X$4 3 5 3 6 25 25 sramgen_svt_inv_2
* cell instance $5 r0 *1 4.32,-3.33
X$5 3 6 3 7 25 25 sramgen_svt_inv_2
* cell instance $6 r0 *1 5.76,-3.33
X$6 3 7 3 8 25 25 sramgen_svt_inv_2
* cell instance $7 r0 *1 7.2,-3.33
X$7 3 8 3 9 25 25 sramgen_svt_inv_2
* cell instance $8 r0 *1 8.64,-3.33
X$8 3 9 3 10 25 25 sramgen_svt_inv_2
* cell instance $10 r0 *1 11.04,-3.33
X$10 3 10 3 11 25 25 sramgen_svt_inv_2
* cell instance $11 r0 *1 12.48,-3.33
X$11 3 11 3 12 25 25 sramgen_svt_inv_2
* cell instance $12 r0 *1 13.92,-3.33
X$12 3 12 3 13 25 25 sramgen_svt_inv_2
* cell instance $13 r0 *1 15.36,-3.33
X$13 3 13 3 14 25 25 sramgen_svt_inv_2
* cell instance $14 r0 *1 16.8,-3.33
X$14 3 14 3 15 25 25 sramgen_svt_inv_2
* cell instance $15 r0 *1 18.24,-3.33
X$15 3 15 3 16 25 25 sramgen_svt_inv_2
* cell instance $16 r0 *1 19.68,-3.33
X$16 3 16 3 17 25 25 sramgen_svt_inv_2
* cell instance $18 r0 *1 22.08,-3.33
X$18 3 17 3 18 25 25 sramgen_svt_inv_2
* cell instance $19 r0 *1 23.52,-3.33
X$19 3 18 3 19 25 25 sramgen_svt_inv_2
* cell instance $20 r0 *1 24.96,-3.33
X$20 3 19 3 20 25 25 sramgen_svt_inv_2
* cell instance $21 r0 *1 26.4,-3.33
X$21 3 20 3 21 25 25 sramgen_svt_inv_2
* cell instance $22 r0 *1 27.84,-3.33
X$22 3 21 3 22 25 25 sramgen_svt_inv_2
* cell instance $23 r0 *1 29.28,-3.33
X$23 3 22 3 23 25 25 sramgen_svt_inv_2
* cell instance $24 r0 *1 30.72,-3.33
X$24 3 23 3 24 25 25 sramgen_svt_inv_2
.ENDS svt_inv_chain_22

* cell sky130_fd_sc_hs__nand2_4
* pin vgnd
* pin b
* pin a
* pin vpwr
* pin y
* pin vpb
* pin vnb
.SUBCKT sky130_fd_sc_hs__nand2_4 1 2 4 5 6 7 8
* net 1 vgnd
* net 2 b
* net 4 a
* net 5 vpwr
* net 6 y
* net 7 vpb
* net 8 vnb
* device instance $1 r0 *1 0.51,2.4 pfet_01v8
M$1 6 2 5 7 pfet_01v8 L=150000U W=2240000U AS=957600000000P AD=817600000000P
+ PS=5070000U PD=3700000U
* device instance $3 r0 *1 2.27,2.4 pfet_01v8
M$3 6 4 5 7 pfet_01v8 L=150000U W=2240000U AS=949200000000P AD=1.1396e+12P
+ PS=3935000U PD=5395000U
* device instance $5 r0 *1 0.495,0.74 nfet_01v8_lvt
M$5 1 2 3 8 nfet_01v8_lvt L=150000U W=2960000U AS=521700000000P
+ AD=429200000000P PS=5110000U PD=4120000U
* device instance $9 r0 *1 2.255,0.74 nfet_01v8_lvt
M$9 6 4 3 8 nfet_01v8_lvt L=150000U W=2960000U AS=516150000000P
+ AD=641950000000P PS=4355000U PD=5435000U
.ENDS sky130_fd_sc_hs__nand2_4

* cell sky130_fd_sc_hs__nor2_4
* pin vgnd
* pin y
* pin a
* pin b
* pin vpb
* pin vpwr
* pin vnb
.SUBCKT sky130_fd_sc_hs__nor2_4 1 2 3 4 6 7 8
* net 1 vgnd
* net 2 y
* net 3 a
* net 4 b
* net 6 vpb
* net 7 vpwr
* net 8 vnb
* device instance $1 r0 *1 0.505,2.4 pfet_01v8
M$1 7 3 5 6 pfet_01v8 L=150000U W=4480000U AS=834400000000P AD=672000000000P
+ PS=7090000U PD=5680000U
* device instance $5 r0 *1 2.305,2.4 pfet_01v8
M$5 2 4 5 6 pfet_01v8 L=150000U W=4480000U AS=728000000000P AD=957600000000P
+ PS=5780000U PD=7310000U
* device instance $9 r0 *1 0.52,0.74 nfet_01v8_lvt
M$9 2 3 1 8 nfet_01v8_lvt L=150000U W=1480000U AS=651200000000P
+ AD=543900000000P PS=3980000U PD=2950000U
* device instance $11 r0 *1 2.29,0.74 nfet_01v8_lvt
M$11 2 4 1 8 nfet_01v8_lvt L=150000U W=1480000U AS=233100000000P AD=1.1248e+12P
+ PS=2110000U PD=5260000U
.ENDS sky130_fd_sc_hs__nor2_4

* cell inv_chain_13
* pin dout
* pin din
* pin vdd
* pin vss
.SUBCKT inv_chain_13 1 2 3 16
* net 1 dout
* net 2 din
* net 3 vdd
* net 16 vss
* cell instance $1 r0 *1 18.24,-3.33
X$1 3 15 3 16 1 16 sky130_fd_sc_hs__inv_4
* cell instance $2 r0 *1 0,-3.33
X$2 3 2 3 4 16 16 sky130_fd_sc_hs__inv_2
* cell instance $3 r0 *1 1.44,-3.33
X$3 3 4 3 5 16 16 sky130_fd_sc_hs__inv_2
* cell instance $4 r0 *1 2.88,-3.33
X$4 3 5 3 6 16 16 sky130_fd_sc_hs__inv_2
* cell instance $5 r0 *1 4.32,-3.33
X$5 3 6 3 7 16 16 sky130_fd_sc_hs__inv_2
* cell instance $6 r0 *1 5.76,-3.33
X$6 3 7 3 8 16 16 sky130_fd_sc_hs__inv_2
* cell instance $7 r0 *1 7.2,-3.33
X$7 3 8 3 9 16 16 sky130_fd_sc_hs__inv_2
* cell instance $8 r0 *1 8.64,-3.33
X$8 3 9 3 10 16 16 sky130_fd_sc_hs__inv_2
* cell instance $10 r0 *1 11.04,-3.33
X$10 3 10 3 11 16 16 sky130_fd_sc_hs__inv_2
* cell instance $11 r0 *1 12.48,-3.33
X$11 3 11 3 12 16 16 sky130_fd_sc_hs__inv_2
* cell instance $12 r0 *1 13.92,-3.33
X$12 3 12 3 13 16 16 sky130_fd_sc_hs__inv_2
* cell instance $13 r0 *1 15.36,-3.33
X$13 3 13 3 14 16 16 sky130_fd_sc_hs__inv_2
* cell instance $14 r0 *1 16.8,-3.33
X$14 3 14 3 15 16 16 sky130_fd_sc_hs__inv_2
.ENDS inv_chain_13

* cell inv_chain_12
* pin din
* pin dout
* pin vdd
* pin vss
.SUBCKT inv_chain_12 1 2 3 15
* net 1 din
* net 2 dout
* net 3 vdd
* net 15 vss
* cell instance $1 r0 *1 0,-3.33
X$1 3 1 3 4 15 15 sky130_fd_sc_hs__inv_2
* cell instance $2 r0 *1 16.8,-3.33
X$2 3 14 3 15 2 15 sky130_fd_sc_hs__inv_4
* cell instance $3 r0 *1 1.44,-3.33
X$3 3 4 3 5 15 15 sky130_fd_sc_hs__inv_2
* cell instance $4 r0 *1 2.88,-3.33
X$4 3 5 3 6 15 15 sky130_fd_sc_hs__inv_2
* cell instance $5 r0 *1 4.32,-3.33
X$5 3 6 3 7 15 15 sky130_fd_sc_hs__inv_2
* cell instance $6 r0 *1 5.76,-3.33
X$6 3 7 3 8 15 15 sky130_fd_sc_hs__inv_2
* cell instance $7 r0 *1 7.2,-3.33
X$7 3 8 3 9 15 15 sky130_fd_sc_hs__inv_2
* cell instance $8 r0 *1 8.64,-3.33
X$8 3 9 3 10 15 15 sky130_fd_sc_hs__inv_2
* cell instance $10 r0 *1 11.04,-3.33
X$10 3 10 3 11 15 15 sky130_fd_sc_hs__inv_2
* cell instance $11 r0 *1 12.48,-3.33
X$11 3 11 3 12 15 15 sky130_fd_sc_hs__inv_2
* cell instance $12 r0 *1 13.92,-3.33
X$12 3 12 3 13 15 15 sky130_fd_sc_hs__inv_2
* cell instance $13 r0 *1 15.36,-3.33
X$13 3 13 3 14 15 15 sky130_fd_sc_hs__inv_2
.ENDS inv_chain_12

* cell sky130_fd_sc_hs__inv_16
* pin vgnd
* pin y
* pin a
* pin vpwr
* pin vpb
* pin vnb
.SUBCKT sky130_fd_sc_hs__inv_16 1 2 3 4 5 6
* net 1 vgnd
* net 2 y
* net 3 a
* net 4 vpwr
* net 5 vpb
* net 6 vnb
* device instance $1 r0 *1 0.505,2.4 pfet_01v8
M$1 2 3 4 5 pfet_01v8 L=150000U W=17920000U AS=3.0744e+12P AD=3.0744e+12P
+ PS=24530000U PD=24530000U
* device instance $17 r0 *1 0.565,0.74 nfet_01v8_lvt
M$17 2 3 1 6 nfet_01v8_lvt L=150000U W=11840000U AS=1.9647e+12P AD=1.9647e+12P
+ PS=17890000U PD=17890000U
.ENDS sky130_fd_sc_hs__inv_16

* cell sr_latch
* pin q
* pin qb
* pin sb
* pin rb
* pin vdd
* pin vss
.SUBCKT sr_latch 1 2 3 4 7 8
* net 1 q
* net 2 qb
* net 3 sb
* net 4 rb
* net 7 vdd
* net 8 vss
* cell instance $1 r0 *1 18.24,-3.33
X$1 7 6 7 1 8 8 sky130_fd_sc_hs__inv_2
* cell instance $2 r0 *1 19.68,-3.33
X$2 7 5 7 2 8 8 sky130_fd_sc_hs__inv_2
* cell instance $3 r0 *1 0,-3.33
X$3 8 3 6 5 7 7 8 sky130_fd_sc_hs__nand2_8
* cell instance $4 m90 *1 17.28,-3.33
X$4 8 4 5 6 7 7 8 sky130_fd_sc_hs__nand2_8
.ENDS sr_latch

* cell sky130_fd_sc_hs__buf_16
* pin vgnd
* pin a
* pin x
* pin vpwr
* pin vpb
* pin vnb
.SUBCKT sky130_fd_sc_hs__buf_16 1 2 3 5 6 7
* net 1 vgnd
* net 2 a
* net 3 x
* net 5 vpwr
* net 6 vpb
* net 7 vnb
* device instance $1 r0 *1 0.505,2.4 pfet_01v8
M$1 3 4 5 6 pfet_01v8 L=150000U W=17920000U AS=2.8784e+12P AD=2.744e+12P
+ PS=24180000U PD=22820000U
* device instance $17 r0 *1 7.805,2.4 pfet_01v8
M$17 4 2 5 6 pfet_01v8 L=150000U W=6720000U AS=1.036e+12P AD=1.1704e+12P
+ PS=8570000U PD=9930000U
* device instance $23 r0 *1 0.51,0.74 nfet_01v8_lvt
M$23 3 4 1 7 nfet_01v8_lvt L=150000U W=11840000U AS=1.9203e+12P AD=1.813e+12P
+ PS=17770000U PD=16740000U
* device instance $39 r0 *1 7.81,0.74 nfet_01v8_lvt
M$39 4 2 1 7 nfet_01v8_lvt L=150000U W=4440000U AS=660450000000P
+ AD=767750000000P PS=6225000U PD=7255000U
.ENDS sky130_fd_sc_hs__buf_16

* cell inv_chain_16
* pin din
* pin dout
* pin vdd
* pin vss
.SUBCKT inv_chain_16 1 2 3 19
* net 1 din
* net 2 dout
* net 3 vdd
* net 19 vss
* cell instance $1 r0 *1 0,-3.33
X$1 3 1 3 4 19 19 sky130_fd_sc_hs__inv_2
* cell instance $2 r0 *1 23.52,-3.33
X$2 3 18 3 19 2 19 sky130_fd_sc_hs__inv_4
* cell instance $3 r0 *1 1.44,-3.33
X$3 3 4 3 5 19 19 sky130_fd_sc_hs__inv_2
* cell instance $4 r0 *1 2.88,-3.33
X$4 3 5 3 6 19 19 sky130_fd_sc_hs__inv_2
* cell instance $5 r0 *1 4.32,-3.33
X$5 3 6 3 7 19 19 sky130_fd_sc_hs__inv_2
* cell instance $6 r0 *1 5.76,-3.33
X$6 3 7 3 8 19 19 sky130_fd_sc_hs__inv_2
* cell instance $7 r0 *1 7.2,-3.33
X$7 3 8 3 9 19 19 sky130_fd_sc_hs__inv_2
* cell instance $8 r0 *1 8.64,-3.33
X$8 3 9 3 10 19 19 sky130_fd_sc_hs__inv_2
* cell instance $10 r0 *1 11.04,-3.33
X$10 3 10 3 11 19 19 sky130_fd_sc_hs__inv_2
* cell instance $11 r0 *1 12.48,-3.33
X$11 3 11 3 12 19 19 sky130_fd_sc_hs__inv_2
* cell instance $12 r0 *1 13.92,-3.33
X$12 3 12 3 13 19 19 sky130_fd_sc_hs__inv_2
* cell instance $13 r0 *1 15.36,-3.33
X$13 3 13 3 14 19 19 sky130_fd_sc_hs__inv_2
* cell instance $14 r0 *1 16.8,-3.33
X$14 3 14 3 15 19 19 sky130_fd_sc_hs__inv_2
* cell instance $15 r0 *1 18.24,-3.33
X$15 3 15 3 16 19 19 sky130_fd_sc_hs__inv_2
* cell instance $16 r0 *1 19.68,-3.33
X$16 3 16 3 17 19 19 sky130_fd_sc_hs__inv_2
* cell instance $18 r0 *1 22.08,-3.33
X$18 3 17 3 18 19 19 sky130_fd_sc_hs__inv_2
.ENDS inv_chain_16

* cell edge_detector
* pin din
* pin dout
* pin vdd
* pin vss
.SUBCKT edge_detector 1 2 4 5
* net 1 din
* net 2 dout
* net 4 vdd
* net 5 vss
* cell instance $1 r0 *1 0,0
X$1 3 1 4 5 inv_chain_9
* cell instance $4 m90 *1 19.2,-3.33
X$4 5 2 3 1 4 4 5 sky130_fd_sc_hs__and2_4
.ENDS edge_detector

* cell sky130_fd_sc_hs__dfrbp_2
* pin vgnd
* pin q
* pin d
* pin q_n
* pin reset_b
* pin clk
* pin vpb
* pin vpwr
* pin vnb
.SUBCKT sky130_fd_sc_hs__dfrbp_2 1 4 5 10 15 17 20 21 24
* net 1 vgnd
* net 4 q
* net 5 d
* net 10 q_n
* net 15 reset_b
* net 17 clk
* net 20 vpb
* net 21 vpwr
* net 24 vnb
* device instance $1 r0 *1 0.62,2.17 pfet_01v8
M$1 7 5 21 20 pfet_01v8 L=150000U W=420000U AS=144900000000P AD=63000000000P
+ PS=1530000U PD=720000U
* device instance $2 r0 *1 1.07,2.17 pfet_01v8
M$2 7 15 21 20 pfet_01v8 L=150000U W=420000U AS=385725000000P AD=63000000000P
+ PS=2700000U PD=720000U
* device instance $3 r0 *1 1.58,2.46 pfet_01v8
M$3 2 16 21 20 pfet_01v8 L=150000U W=1000000U AS=385725000000P AD=295000000000P
+ PS=2700000U PD=2590000U
* device instance $4 r0 *1 5.845,2.4 pfet_01v8
M$4 21 3 19 20 pfet_01v8 L=150000U W=1120000U AS=330400000000P AD=372225000000P
+ PS=2830000U PD=1805000U
* device instance $5 r0 *1 6.645,2.4 pfet_01v8
M$5 3 17 21 20 pfet_01v8 L=150000U W=1120000U AS=372225000000P AD=330400000000P
+ PS=1805000U PD=2830000U
* device instance $6 r0 *1 12.915,2.4 pfet_01v8
M$6 4 11 21 20 pfet_01v8 L=150000U W=2240000U AS=554400000000P AD=554400000000P
+ PS=4350000U PD=4350000U
* device instance $8 r0 *1 2.575,2.635 pfet_01v8
M$8 21 15 16 20 pfet_01v8 L=150000U W=420000U AS=117600000000P AD=141475000000P
+ PS=1400000U PD=1120000U
* device instance $9 r0 *1 3.34,2.635 pfet_01v8
M$9 22 2 21 20 pfet_01v8 L=150000U W=420000U AS=141475000000P AD=50400000000P
+ PS=1120000U PD=660000U
* device instance $10 r0 *1 3.73,2.635 pfet_01v8
M$10 16 3 22 20 pfet_01v8 L=150000U W=420000U AS=50400000000P AD=63000000000P
+ PS=660000U PD=720000U
* device instance $11 r0 *1 4.18,2.635 pfet_01v8
M$11 7 19 16 20 pfet_01v8 L=150000U W=420000U AS=63000000000P AD=279300000000P
+ PS=720000U PD=2170000U
* device instance $12 r0 *1 8.7,2.155 pfet_01v8
M$12 23 19 9 20 pfet_01v8 L=150000U W=420000U AS=188150000000P AD=56700000000P
+ PS=1530000U PD=690000U
* device instance $13 r0 *1 9.12,2.155 pfet_01v8
M$13 21 18 23 20 pfet_01v8 L=150000U W=420000U AS=56700000000P AD=142600000000P
+ PS=690000U PD=1155000U
* device instance $14 r0 *1 9.77,2.155 pfet_01v8
M$14 18 15 21 20 pfet_01v8 L=150000U W=420000U AS=142600000000P AD=63000000000P
+ PS=1155000U PD=720000U
* device instance $15 r0 *1 10.22,2.155 pfet_01v8
M$15 18 9 21 20 pfet_01v8 L=150000U W=420000U AS=181325000000P AD=63000000000P
+ PS=1505000U PD=720000U
* device instance $16 r0 *1 11.74,2.26 pfet_01v8
M$16 11 9 21 20 pfet_01v8 L=150000U W=1000000U AS=210200000000P
+ AD=390000000000P PS=1505000U PD=2780000U
* device instance $17 r0 *1 10.755,2.32 pfet_01v8
M$17 10 9 21 20 pfet_01v8 L=150000U W=2240000U AS=349325000000P
+ AD=378200000000P PS=2925000U PD=2925000U
* device instance $19 r0 *1 8.02,2.445 pfet_01v8
M$19 9 3 2 20 pfet_01v8 L=150000U W=1000000U AS=280000000000P AD=188150000000P
+ PS=2560000U PD=1530000U
* device instance $20 r0 *1 3.835,1.37 nfet_01v8_lvt
M$20 16 3 7 24 nfet_01v8_lvt L=150000U W=420000U AS=145600000000P
+ AD=58800000000P PS=1630000U PD=700000U
* device instance $21 r0 *1 4.265,1.37 nfet_01v8_lvt
M$21 6 19 16 24 nfet_01v8_lvt L=150000U W=420000U AS=58800000000P
+ AD=218400000000P PS=700000U PD=1880000U
* device instance $22 r0 *1 5.475,0.86 nfet_01v8_lvt
M$22 19 3 1 24 nfet_01v8_lvt L=150000U W=740000U AS=398300000000P
+ AD=199800000000P PS=2005000U PD=2020000U
* device instance $23 r0 *1 6.58,0.86 nfet_01v8_lvt
M$23 3 17 1 24 nfet_01v8_lvt L=150000U W=740000U AS=398300000000P
+ AD=210900000000P PS=2005000U PD=2050000U
* device instance $24 r0 *1 13.01,0.74 nfet_01v8_lvt
M$24 4 11 1 24 nfet_01v8_lvt L=150000U W=1480000U AS=303400000000P
+ AD=303400000000P PS=3040000U PD=3040000U
* device instance $26 r0 *1 7.855,0.955 nfet_01v8_lvt
M$26 8 3 9 24 nfet_01v8_lvt L=150000U W=420000U AS=108250000000P
+ AD=119700000000P PS=1065000U PD=1410000U
* device instance $27 r0 *1 8.33,0.795 nfet_01v8_lvt
M$27 9 19 2 24 nfet_01v8_lvt L=150000U W=740000U AS=312550000000P
+ AD=108250000000P PS=2620000U PD=1065000U
* device instance $28 r0 *1 12.05,0.69 nfet_01v8_lvt
M$28 11 9 1 24 nfet_01v8_lvt L=150000U W=640000U AS=116500000000P
+ AD=172800000000P PS=1065000U PD=1820000U
* device instance $29 r0 *1 11.145,0.74 nfet_01v8_lvt
M$29 10 9 1 24 nfet_01v8_lvt L=150000U W=1480000U AS=314500000000P
+ AD=220100000000P PS=3070000U PD=2085000U
* device instance $31 r0 *1 0.705,0.58 nfet_01v8_lvt
M$31 12 5 7 24 nfet_01v8_lvt L=150000U W=420000U AS=117600000000P
+ AD=50400000000P PS=1400000U PD=660000U
* device instance $32 r0 *1 1.095,0.58 nfet_01v8_lvt
M$32 1 15 12 24 nfet_01v8_lvt L=150000U W=420000U AS=50400000000P
+ AD=113500000000P PS=660000U PD=1090000U
* device instance $33 r0 *1 1.595,0.74 nfet_01v8_lvt
M$33 2 16 1 24 nfet_01v8_lvt L=150000U W=740000U AS=113500000000P
+ AD=210900000000P PS=1090000U PD=2050000U
* device instance $34 r0 *1 9.365,0.58 nfet_01v8_lvt
M$34 1 18 8 24 nfet_01v8_lvt L=150000U W=420000U AS=115500000000P
+ AD=58800000000P PS=1390000U PD=700000U
* device instance $35 r0 *1 9.795,0.58 nfet_01v8_lvt
M$35 13 15 1 24 nfet_01v8_lvt L=150000U W=420000U AS=58800000000P
+ AD=44100000000P PS=700000U PD=630000U
* device instance $36 r0 *1 10.155,0.58 nfet_01v8_lvt
M$36 18 9 13 24 nfet_01v8_lvt L=150000U W=420000U AS=44100000000P
+ AD=119700000000P PS=630000U PD=1410000U
* device instance $37 r0 *1 2.605,0.615 nfet_01v8_lvt
M$37 14 15 1 24 nfet_01v8_lvt L=150000U W=420000U AS=128100000000P
+ AD=50400000000P PS=1450000U PD=660000U
* device instance $38 r0 *1 2.995,0.615 nfet_01v8_lvt
M$38 6 2 14 24 nfet_01v8_lvt L=150000U W=420000U AS=50400000000P
+ AD=128100000000P PS=660000U PD=1450000U
.ENDS sky130_fd_sc_hs__dfrbp_2

* cell folded_inv
* pin a
* pin vss
* pin vdd
* pin y
* pin vss
* pin vdd
* pin
* pin VNB
.SUBCKT folded_inv 1 2 3 4 5 6 7 8
* net 1 a
* net 2 vss
* net 3 vdd
* net 4 y
* net 5 vss
* net 6 vdd
* net 8 VNB
* device instance $1 r0 *1 1.62,0.34 pfet_01v8
M$1 4 1 3 7 pfet_01v8 L=150000U W=1000000U AS=265000000000P AD=140000000000P
+ PS=2530000U PD=1280000U
* device instance $2 r0 *1 1.62,0.77 pfet_01v8
M$2 6 1 4 7 pfet_01v8 L=150000U W=1000000U AS=140000000000P AD=265000000000P
+ PS=1280000U PD=2530000U
* device instance $3 r0 *1 0.3,0.34 nfet_01v8
M$3 4 1 2 8 nfet_01v8 L=150000U W=600000U AS=159000000000P AD=84000000000P
+ PS=1730000U PD=880000U
* device instance $4 r0 *1 0.3,0.77 nfet_01v8
M$4 5 1 4 8 nfet_01v8 L=150000U W=600000U AS=84000000000P AD=159000000000P
+ PS=880000U PD=1730000U
.ENDS folded_inv

* cell tristate_inv
* pin din
* pin dout
* pin vss
* pin vdd
* pin en
* pin en_b
* pin VNB
* pin
.SUBCKT tristate_inv 1 2 3 4 5 6 7 8
* net 1 din
* net 2 dout
* net 3 vss
* net 4 vdd
* net 5 en
* net 6 en_b
* net 7 VNB
* device instance $1 m90 *1 2.545,0.34 pfet_01v8
M$1 9 1 4 8 pfet_01v8 L=150000U W=1350000U AS=357750000000P AD=189000000000P
+ PS=3230000U PD=1630000U
* device instance $2 m90 *1 2.545,0.77 pfet_01v8
M$2 2 6 9 8 pfet_01v8 L=150000U W=1350000U AS=189000000000P AD=357750000000P
+ PS=1630000U PD=3230000U
* device instance $3 r0 *1 0.675,0.34 nfet_01v8
M$3 10 1 3 7 nfet_01v8 L=150000U W=1350000U AS=357750000000P AD=189000000000P
+ PS=3230000U PD=1630000U
* device instance $4 r0 *1 0.675,0.77 nfet_01v8
M$4 2 5 10 7 nfet_01v8 L=150000U W=1350000U AS=189000000000P AD=357750000000P
+ PS=1630000U PD=3230000U
.ENDS tristate_inv

* cell sram_sp_horiz_wlstrap_p2
* pin vgnd,vnb
* pin VNB
.SUBCKT sram_sp_horiz_wlstrap_p2 1 2
* net 1 vgnd,vnb
* net 2 VNB
* device instance $1 r0 *1 0.65,-0.75 nfet_01v8
M$1 1 1 1 2 nfet_01v8 L=150000U W=420000U AS=111300000000P AD=111300000000P
+ PS=1370000U PD=1370000U
.ENDS sram_sp_horiz_wlstrap_p2

* cell sram_sp_rowtapend_replica
* pin VNB
.SUBCKT sram_sp_rowtapend_replica 1
* net 1 VNB
* device instance $1 r0 *1 0.73,-0.75 nfet_01v8
M$1 1 1 1 1 nfet_01v8 L=150000U W=420000U AS=111300000000P AD=111300000000P
+ PS=1370000U PD=1370000U
.ENDS sram_sp_rowtapend_replica

* cell sramgen_svt_inv_4
* pin vpb
* pin a
* pin vpwr
* pin vgnd
* pin y
* pin vnb
.SUBCKT sramgen_svt_inv_4 1 2 3 4 5 6
* net 1 vpb
* net 2 a
* net 3 vpwr
* net 4 vgnd
* net 5 y
* net 6 vnb
* device instance $1 r0 *1 0.54,2.4 pfet_01v8
M$1 5 2 3 1 pfet_01v8 L=150000U W=4480000U AS=834400000000P AD=834400000000P
+ PS=7090000U PD=7090000U
* device instance $5 r0 *1 0.525,0.74 nfet_01v8
M$5 5 2 4 6 nfet_01v8 L=150000U W=2960000U AS=577200000000P AD=555000000000P
+ PS=5260000U PD=5200000U
.ENDS sramgen_svt_inv_4

* cell sramgen_svt_inv_2
* pin vpb
* pin a
* pin vpwr
* pin y
* pin vgnd
* pin vnb
.SUBCKT sramgen_svt_inv_2 1 2 3 4 5 6
* net 1 vpb
* net 2 a
* net 3 vpwr
* net 4 y
* net 5 vgnd
* net 6 vnb
* device instance $1 r0 *1 0.495,2.4 pfet_01v8
M$1 4 2 3 1 pfet_01v8 L=150000U W=2240000U AS=487200000000P AD=487200000000P
+ PS=4230000U PD=4230000U
* device instance $3 r0 *1 0.51,0.74 nfet_01v8
M$3 4 2 5 6 nfet_01v8 L=150000U W=1480000U AS=314500000000P AD=314500000000P
+ PS=3070000U PD=3070000U
.ENDS sramgen_svt_inv_2

* cell sky130_fd_sc_hs__nand2_8
* pin vgnd
* pin b
* pin a
* pin y
* pin vpwr
* pin vpb
* pin vnb
.SUBCKT sky130_fd_sc_hs__nand2_8 1 3 4 5 6 7 8
* net 1 vgnd
* net 3 b
* net 4 a
* net 5 y
* net 6 vpwr
* net 7 vpb
* net 8 vnb
* device instance $1 r0 *1 5.88,2.4 pfet_01v8
M$1 5 4 6 7 pfet_01v8 L=150000U W=4480000U AS=1.1312e+12P AD=1.0696e+12P
+ PS=7620000U PD=7510000U
* device instance $5 r0 *1 2.08,2.4 pfet_01v8
M$5 5 3 6 7 pfet_01v8 L=150000U W=4480000U AS=2.7496e+12P AD=1.6408e+12P
+ PS=10510000U PD=8530000U
* device instance $9 r0 *1 0.485,0.74 nfet_01v8_lvt
M$9 1 3 2 8 nfet_01v8_lvt L=150000U W=5920000U AS=1.0619e+12P AD=962000000000P
+ PS=9530000U PD=8520000U
* device instance $17 r0 *1 4.285,0.74 nfet_01v8_lvt
M$17 5 4 2 8 nfet_01v8_lvt L=150000U W=5920000U AS=962000000000P
+ AD=1.05645e+12P PS=8520000U PD=9570000U
.ENDS sky130_fd_sc_hs__nand2_8

* cell sky130_fd_sc_hs__and2_4
* pin vgnd
* pin x
* pin b
* pin a
* pin vpwr
* pin vpb
* pin vnb
.SUBCKT sky130_fd_sc_hs__and2_4 1 2 4 6 7 8 9
* net 1 vgnd
* net 2 x
* net 4 b
* net 6 a
* net 7 vpwr
* net 8 vpb
* net 9 vnb
* device instance $1 r0 *1 2.41,2.465 pfet_01v8
M$1 3 4 7 8 pfet_01v8 L=150000U W=1680000U AS=325925000000P AD=384300000000P
+ PS=2645000U PD=3435000U
* device instance $2 r0 *1 2.885,2.465 pfet_01v8
M$2 7 6 3 8 pfet_01v8 L=150000U W=1680000U AS=273000000000P AD=262500000000P
+ PS=2330000U PD=2305000U
* device instance $5 r0 *1 0.505,2.4 pfet_01v8
M$5 2 3 7 8 pfet_01v8 L=150000U W=4480000U AS=845600000000P AD=715125000000P
+ PS=7110000U PD=5785000U
* device instance $9 r0 *1 0.495,0.865 nfet_01v8_lvt
M$9 2 3 1 9 nfet_01v8_lvt L=150000U W=2960000U AS=577200000000P
+ AD=495750000000P PS=5260000U PD=4310000U
* device instance $13 r0 *1 2.445,0.915 nfet_01v8_lvt
M$13 5 4 1 9 nfet_01v8_lvt L=150000U W=1280000U AS=225450000000P
+ AD=280000000000P PS=2040000U PD=2795000U
* device instance $14 r0 *1 2.9,0.915 nfet_01v8_lvt
M$14 3 6 5 9 nfet_01v8_lvt L=150000U W=1280000U AS=201600000000P
+ AD=200000000000P PS=1910000U PD=1905000U
.ENDS sky130_fd_sc_hs__and2_4

* cell inv_chain_9
* pin dout
* pin din
* pin vdd
* pin vss
.SUBCKT inv_chain_9 1 2 3 12
* net 1 dout
* net 2 din
* net 3 vdd
* net 12 vss
* cell instance $1 r0 *1 12.48,-3.33
X$1 3 11 3 12 1 12 sky130_fd_sc_hs__inv_4
* cell instance $2 r0 *1 0,-3.33
X$2 3 2 3 4 12 12 sky130_fd_sc_hs__inv_2
* cell instance $3 r0 *1 1.44,-3.33
X$3 3 4 3 5 12 12 sky130_fd_sc_hs__inv_2
* cell instance $4 r0 *1 2.88,-3.33
X$4 3 5 3 6 12 12 sky130_fd_sc_hs__inv_2
* cell instance $5 r0 *1 4.32,-3.33
X$5 3 6 3 7 12 12 sky130_fd_sc_hs__inv_2
* cell instance $6 r0 *1 5.76,-3.33
X$6 3 7 3 8 12 12 sky130_fd_sc_hs__inv_2
* cell instance $7 r0 *1 7.2,-3.33
X$7 3 8 3 9 12 12 sky130_fd_sc_hs__inv_2
* cell instance $8 r0 *1 8.64,-3.33
X$8 3 9 3 10 12 12 sky130_fd_sc_hs__inv_2
* cell instance $10 r0 *1 11.04,-3.33
X$10 3 10 3 11 12 12 sky130_fd_sc_hs__inv_2
.ENDS inv_chain_9

* cell sky130_fd_sc_hs__inv_4
* pin vpb
* pin a
* pin vpwr
* pin vgnd
* pin y
* pin vnb
.SUBCKT sky130_fd_sc_hs__inv_4 1 2 3 4 5 6
* net 1 vpb
* net 2 a
* net 3 vpwr
* net 4 vgnd
* net 5 y
* net 6 vnb
* device instance $1 r0 *1 0.54,2.4 pfet_01v8
M$1 5 2 3 1 pfet_01v8 L=150000U W=4480000U AS=834400000000P AD=834400000000P
+ PS=7090000U PD=7090000U
* device instance $5 r0 *1 0.525,0.74 nfet_01v8_lvt
M$5 5 2 4 6 nfet_01v8_lvt L=150000U W=2960000U AS=577200000000P
+ AD=555000000000P PS=5260000U PD=5200000U
.ENDS sky130_fd_sc_hs__inv_4

* cell sky130_fd_sc_hs__inv_2
* pin vpb
* pin a
* pin vpwr
* pin y
* pin vgnd
* pin vnb
.SUBCKT sky130_fd_sc_hs__inv_2 1 2 3 4 5 6
* net 1 vpb
* net 2 a
* net 3 vpwr
* net 4 y
* net 5 vgnd
* net 6 vnb
* device instance $1 r0 *1 0.495,2.4 pfet_01v8
M$1 4 2 3 1 pfet_01v8 L=150000U W=2240000U AS=487200000000P AD=487200000000P
+ PS=4230000U PD=4230000U
* device instance $3 r0 *1 0.51,0.74 nfet_01v8_lvt
M$3 4 2 5 6 nfet_01v8_lvt L=150000U W=1480000U AS=314500000000P
+ AD=314500000000P PS=3070000U PD=3070000U
.ENDS sky130_fd_sc_hs__inv_2
